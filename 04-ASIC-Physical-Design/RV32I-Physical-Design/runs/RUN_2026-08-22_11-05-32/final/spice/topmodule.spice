* NGSPICE file created from topmodule.ext - technology: sky130A

* Black-box entry subcircuit for sky130_fd_sc_hd__fill_2 abstract view
.subckt sky130_fd_sc_hd__fill_2 VGND VNB VPB VPWR
.ends

* Black-box entry subcircuit for sky130_fd_sc_hd__decap_3 abstract view
.subckt sky130_fd_sc_hd__decap_3 VGND VNB VPB VPWR
.ends

* Black-box entry subcircuit for sky130_fd_sc_hd__fill_1 abstract view
.subckt sky130_fd_sc_hd__fill_1 VGND VNB VPB VPWR
.ends

* Black-box entry subcircuit for sky130_fd_sc_hd__dfxtp_2 abstract view
.subckt sky130_fd_sc_hd__dfxtp_2 CLK D VGND VNB VPB VPWR Q
.ends

* Black-box entry subcircuit for sky130_fd_sc_hd__nand2_2 abstract view
.subckt sky130_fd_sc_hd__nand2_2 A B VGND VNB VPB VPWR Y
.ends

* Black-box entry subcircuit for sky130_fd_sc_hd__tapvpwrvgnd_1 abstract view
.subckt sky130_fd_sc_hd__tapvpwrvgnd_1 VGND VPWR
.ends

* Black-box entry subcircuit for sky130_fd_sc_hd__mux2_2 abstract view
.subckt sky130_fd_sc_hd__mux2_2 A0 A1 S VGND VNB VPB VPWR X
.ends

* Black-box entry subcircuit for sky130_fd_sc_hd__or3_2 abstract view
.subckt sky130_fd_sc_hd__or3_2 A B C VGND VNB VPB VPWR X
.ends

* Black-box entry subcircuit for sky130_fd_sc_hd__dfrtp_2 abstract view
.subckt sky130_fd_sc_hd__dfrtp_2 CLK D RESET_B VGND VNB VPB VPWR Q
.ends

* Black-box entry subcircuit for sky130_fd_sc_hd__buf_6 abstract view
.subckt sky130_fd_sc_hd__buf_6 A VGND VNB VPB VPWR X
.ends

* Black-box entry subcircuit for sky130_fd_sc_hd__buf_2 abstract view
.subckt sky130_fd_sc_hd__buf_2 A VGND VNB VPB VPWR X
.ends

* Black-box entry subcircuit for sky130_fd_sc_hd__a21oi_2 abstract view
.subckt sky130_fd_sc_hd__a21oi_2 A1 A2 B1 VGND VNB VPB VPWR Y
.ends

* Black-box entry subcircuit for sky130_fd_sc_hd__and3_2 abstract view
.subckt sky130_fd_sc_hd__and3_2 A B C VGND VNB VPB VPWR X
.ends

* Black-box entry subcircuit for sky130_fd_sc_hd__nor2_2 abstract view
.subckt sky130_fd_sc_hd__nor2_2 A B VGND VNB VPB VPWR Y
.ends

* Black-box entry subcircuit for sky130_fd_sc_hd__o311a_2 abstract view
.subckt sky130_fd_sc_hd__o311a_2 A1 A2 A3 B1 C1 VGND VNB VPB VPWR X
.ends

* Black-box entry subcircuit for sky130_fd_sc_hd__and2_2 abstract view
.subckt sky130_fd_sc_hd__and2_2 A B VGND VNB VPB VPWR X
.ends

* Black-box entry subcircuit for sky130_fd_sc_hd__a32o_2 abstract view
.subckt sky130_fd_sc_hd__a32o_2 A1 A2 A3 B1 B2 VGND VNB VPB VPWR X
.ends

* Black-box entry subcircuit for sky130_fd_sc_hd__mux2_4 abstract view
.subckt sky130_fd_sc_hd__mux2_4 A0 A1 S VGND VNB VPB VPWR X
.ends

* Black-box entry subcircuit for sky130_fd_sc_hd__a221o_2 abstract view
.subckt sky130_fd_sc_hd__a221o_2 A1 A2 B1 B2 C1 VGND VNB VPB VPWR X
.ends

* Black-box entry subcircuit for sky130_fd_sc_hd__a31o_2 abstract view
.subckt sky130_fd_sc_hd__a31o_2 A1 A2 A3 B1 VGND VNB VPB VPWR X
.ends

* Black-box entry subcircuit for sky130_fd_sc_hd__o211ai_4 abstract view
.subckt sky130_fd_sc_hd__o211ai_4 A1 A2 B1 C1 VGND VNB VPB VPWR Y
.ends

* Black-box entry subcircuit for sky130_fd_sc_hd__and4_2 abstract view
.subckt sky130_fd_sc_hd__and4_2 A B C D VGND VNB VPB VPWR X
.ends

* Black-box entry subcircuit for sky130_fd_sc_hd__nand2b_2 abstract view
.subckt sky130_fd_sc_hd__nand2b_2 A_N B VGND VNB VPB VPWR Y
.ends

* Black-box entry subcircuit for sky130_fd_sc_hd__dlygate4sd3_1 abstract view
.subckt sky130_fd_sc_hd__dlygate4sd3_1 A VGND VNB VPB VPWR X
.ends

* Black-box entry subcircuit for sky130_fd_sc_hd__o22a_2 abstract view
.subckt sky130_fd_sc_hd__o22a_2 A1 A2 B1 B2 VGND VNB VPB VPWR X
.ends

* Black-box entry subcircuit for sky130_fd_sc_hd__o22ai_2 abstract view
.subckt sky130_fd_sc_hd__o22ai_2 A1 A2 B1 B2 VGND VNB VPB VPWR Y
.ends

* Black-box entry subcircuit for sky130_fd_sc_hd__o21ai_2 abstract view
.subckt sky130_fd_sc_hd__o21ai_2 A1 A2 B1 VGND VNB VPB VPWR Y
.ends

* Black-box entry subcircuit for sky130_fd_sc_hd__o21ai_4 abstract view
.subckt sky130_fd_sc_hd__o21ai_4 A1 A2 B1 VGND VNB VPB VPWR Y
.ends

* Black-box entry subcircuit for sky130_fd_sc_hd__o221a_2 abstract view
.subckt sky130_fd_sc_hd__o221a_2 A1 A2 B1 B2 C1 VGND VNB VPB VPWR X
.ends

* Black-box entry subcircuit for sky130_fd_sc_hd__nand4_2 abstract view
.subckt sky130_fd_sc_hd__nand4_2 A B C D VGND VNB VPB VPWR Y
.ends

* Black-box entry subcircuit for sky130_fd_sc_hd__a41o_2 abstract view
.subckt sky130_fd_sc_hd__a41o_2 A1 A2 A3 A4 B1 VGND VNB VPB VPWR X
.ends

* Black-box entry subcircuit for sky130_fd_sc_hd__nand4_4 abstract view
.subckt sky130_fd_sc_hd__nand4_4 A B C D VGND VNB VPB VPWR Y
.ends

* Black-box entry subcircuit for sky130_fd_sc_hd__or4_2 abstract view
.subckt sky130_fd_sc_hd__or4_2 A B C D VGND VNB VPB VPWR X
.ends

* Black-box entry subcircuit for sky130_fd_sc_hd__a22oi_2 abstract view
.subckt sky130_fd_sc_hd__a22oi_2 A1 A2 B1 B2 VGND VNB VPB VPWR Y
.ends

* Black-box entry subcircuit for sky130_fd_sc_hd__a211o_2 abstract view
.subckt sky130_fd_sc_hd__a211o_2 A1 A2 B1 C1 VGND VNB VPB VPWR X
.ends

* Black-box entry subcircuit for sky130_fd_sc_hd__diode_2 abstract view
.subckt sky130_fd_sc_hd__diode_2 DIODE VGND VNB VPB VPWR
.ends

* Black-box entry subcircuit for sky130_fd_sc_hd__a22o_2 abstract view
.subckt sky130_fd_sc_hd__a22o_2 A1 A2 B1 B2 VGND VNB VPB VPWR X
.ends

* Black-box entry subcircuit for sky130_fd_sc_hd__buf_4 abstract view
.subckt sky130_fd_sc_hd__buf_4 A VGND VNB VPB VPWR X
.ends

* Black-box entry subcircuit for sky130_fd_sc_hd__a31o_4 abstract view
.subckt sky130_fd_sc_hd__a31o_4 A1 A2 A3 B1 VGND VNB VPB VPWR X
.ends

* Black-box entry subcircuit for sky130_fd_sc_hd__or3b_2 abstract view
.subckt sky130_fd_sc_hd__or3b_2 A B C_N VGND VNB VPB VPWR X
.ends

* Black-box entry subcircuit for sky130_fd_sc_hd__o31a_2 abstract view
.subckt sky130_fd_sc_hd__o31a_2 A1 A2 A3 B1 VGND VNB VPB VPWR X
.ends

* Black-box entry subcircuit for sky130_fd_sc_hd__o21a_2 abstract view
.subckt sky130_fd_sc_hd__o21a_2 A1 A2 B1 VGND VNB VPB VPWR X
.ends

* Black-box entry subcircuit for sky130_fd_sc_hd__nand3_4 abstract view
.subckt sky130_fd_sc_hd__nand3_4 A B C VGND VNB VPB VPWR Y
.ends

* Black-box entry subcircuit for sky130_fd_sc_hd__a21o_2 abstract view
.subckt sky130_fd_sc_hd__a21o_2 A1 A2 B1 VGND VNB VPB VPWR X
.ends

* Black-box entry subcircuit for sky130_fd_sc_hd__clkbuf_8 abstract view
.subckt sky130_fd_sc_hd__clkbuf_8 A VGND VNB VPB VPWR X
.ends

* Black-box entry subcircuit for sky130_fd_sc_hd__xor2_2 abstract view
.subckt sky130_fd_sc_hd__xor2_2 A B VGND VNB VPB VPWR X
.ends

* Black-box entry subcircuit for sky130_fd_sc_hd__clkdlybuf4s25_1 abstract view
.subckt sky130_fd_sc_hd__clkdlybuf4s25_1 A VGND VNB VPB VPWR X
.ends

* Black-box entry subcircuit for sky130_fd_sc_hd__o21bai_4 abstract view
.subckt sky130_fd_sc_hd__o21bai_4 A1 A2 B1_N VGND VNB VPB VPWR Y
.ends

* Black-box entry subcircuit for sky130_fd_sc_hd__or3_4 abstract view
.subckt sky130_fd_sc_hd__or3_4 A B C VGND VNB VPB VPWR X
.ends

* Black-box entry subcircuit for sky130_fd_sc_hd__o21bai_2 abstract view
.subckt sky130_fd_sc_hd__o21bai_2 A1 A2 B1_N VGND VNB VPB VPWR Y
.ends

* Black-box entry subcircuit for sky130_fd_sc_hd__nand4b_2 abstract view
.subckt sky130_fd_sc_hd__nand4b_2 A_N B C D VGND VNB VPB VPWR Y
.ends

* Black-box entry subcircuit for sky130_fd_sc_hd__or2_2 abstract view
.subckt sky130_fd_sc_hd__or2_2 A B VGND VNB VPB VPWR X
.ends

* Black-box entry subcircuit for sky130_fd_sc_hd__or4_4 abstract view
.subckt sky130_fd_sc_hd__or4_4 A B C D VGND VNB VPB VPWR X
.ends

* Black-box entry subcircuit for sky130_fd_sc_hd__o41a_4 abstract view
.subckt sky130_fd_sc_hd__o41a_4 A1 A2 A3 A4 B1 VGND VNB VPB VPWR X
.ends

* Black-box entry subcircuit for sky130_fd_sc_hd__o2111ai_2 abstract view
.subckt sky130_fd_sc_hd__o2111ai_2 A1 A2 B1 C1 D1 VGND VNB VPB VPWR Y
.ends

* Black-box entry subcircuit for sky130_fd_sc_hd__and4bb_2 abstract view
.subckt sky130_fd_sc_hd__and4bb_2 A_N B_N C D VGND VNB VPB VPWR X
.ends

* Black-box entry subcircuit for sky130_fd_sc_hd__a2bb2o_2 abstract view
.subckt sky130_fd_sc_hd__a2bb2o_2 A1_N A2_N B1 B2 VGND VNB VPB VPWR X
.ends

* Black-box entry subcircuit for sky130_fd_sc_hd__inv_2 abstract view
.subckt sky130_fd_sc_hd__inv_2 A VGND VNB VPB VPWR Y
.ends

* Black-box entry subcircuit for sky130_fd_sc_hd__nand3_2 abstract view
.subckt sky130_fd_sc_hd__nand3_2 A B C VGND VNB VPB VPWR Y
.ends

* Black-box entry subcircuit for sky130_fd_sc_hd__o211ai_2 abstract view
.subckt sky130_fd_sc_hd__o211ai_2 A1 A2 B1 C1 VGND VNB VPB VPWR Y
.ends

* Black-box entry subcircuit for sky130_fd_sc_hd__o31ai_2 abstract view
.subckt sky130_fd_sc_hd__o31ai_2 A1 A2 A3 B1 VGND VNB VPB VPWR Y
.ends

* Black-box entry subcircuit for sky130_fd_sc_hd__o221ai_2 abstract view
.subckt sky130_fd_sc_hd__o221ai_2 A1 A2 B1 B2 C1 VGND VNB VPB VPWR Y
.ends

* Black-box entry subcircuit for sky130_fd_sc_hd__a211oi_2 abstract view
.subckt sky130_fd_sc_hd__a211oi_2 A1 A2 B1 C1 VGND VNB VPB VPWR Y
.ends

* Black-box entry subcircuit for sky130_fd_sc_hd__buf_8 abstract view
.subckt sky130_fd_sc_hd__buf_8 A VGND VNB VPB VPWR X
.ends

* Black-box entry subcircuit for sky130_fd_sc_hd__a41oi_4 abstract view
.subckt sky130_fd_sc_hd__a41oi_4 A1 A2 A3 A4 B1 VGND VNB VPB VPWR Y
.ends

* Black-box entry subcircuit for sky130_fd_sc_hd__o221a_4 abstract view
.subckt sky130_fd_sc_hd__o221a_4 A1 A2 B1 B2 C1 VGND VNB VPB VPWR X
.ends

* Black-box entry subcircuit for sky130_fd_sc_hd__buf_1 abstract view
.subckt sky130_fd_sc_hd__buf_1 A VGND VNB VPB VPWR X
.ends

* Black-box entry subcircuit for sky130_fd_sc_hd__a31oi_4 abstract view
.subckt sky130_fd_sc_hd__a31oi_4 A1 A2 A3 B1 VGND VNB VPB VPWR Y
.ends

* Black-box entry subcircuit for sky130_fd_sc_hd__o211a_2 abstract view
.subckt sky130_fd_sc_hd__o211a_2 A1 A2 B1 C1 VGND VNB VPB VPWR X
.ends

* Black-box entry subcircuit for sky130_fd_sc_hd__or4b_4 abstract view
.subckt sky130_fd_sc_hd__or4b_4 A B C D_N VGND VNB VPB VPWR X
.ends

* Black-box entry subcircuit for sky130_fd_sc_hd__nor4_2 abstract view
.subckt sky130_fd_sc_hd__nor4_2 A B C D VGND VNB VPB VPWR Y
.ends

* Black-box entry subcircuit for sky130_fd_sc_hd__o41a_2 abstract view
.subckt sky130_fd_sc_hd__o41a_2 A1 A2 A3 A4 B1 VGND VNB VPB VPWR X
.ends

* Black-box entry subcircuit for sky130_fd_sc_hd__a2111oi_2 abstract view
.subckt sky130_fd_sc_hd__a2111oi_2 A1 A2 B1 C1 D1 VGND VNB VPB VPWR Y
.ends

* Black-box entry subcircuit for sky130_fd_sc_hd__and3_4 abstract view
.subckt sky130_fd_sc_hd__and3_4 A B C VGND VNB VPB VPWR X
.ends

* Black-box entry subcircuit for sky130_fd_sc_hd__o2bb2a_2 abstract view
.subckt sky130_fd_sc_hd__o2bb2a_2 A1_N A2_N B1 B2 VGND VNB VPB VPWR X
.ends

* Black-box entry subcircuit for sky130_fd_sc_hd__a21oi_4 abstract view
.subckt sky130_fd_sc_hd__a21oi_4 A1 A2 B1 VGND VNB VPB VPWR Y
.ends

* Black-box entry subcircuit for sky130_fd_sc_hd__o32a_4 abstract view
.subckt sky130_fd_sc_hd__o32a_4 A1 A2 A3 B1 B2 VGND VNB VPB VPWR X
.ends

* Black-box entry subcircuit for sky130_fd_sc_hd__a31oi_2 abstract view
.subckt sky130_fd_sc_hd__a31oi_2 A1 A2 A3 B1 VGND VNB VPB VPWR Y
.ends

* Black-box entry subcircuit for sky130_fd_sc_hd__a211o_4 abstract view
.subckt sky130_fd_sc_hd__a211o_4 A1 A2 B1 C1 VGND VNB VPB VPWR X
.ends

* Black-box entry subcircuit for sky130_fd_sc_hd__a311o_2 abstract view
.subckt sky130_fd_sc_hd__a311o_2 A1 A2 A3 B1 C1 VGND VNB VPB VPWR X
.ends

* Black-box entry subcircuit for sky130_fd_sc_hd__nor2_4 abstract view
.subckt sky130_fd_sc_hd__nor2_4 A B VGND VNB VPB VPWR Y
.ends

* Black-box entry subcircuit for sky130_fd_sc_hd__a311oi_4 abstract view
.subckt sky130_fd_sc_hd__a311oi_4 A1 A2 A3 B1 C1 VGND VNB VPB VPWR Y
.ends

* Black-box entry subcircuit for sky130_fd_sc_hd__clkbuf_16 abstract view
.subckt sky130_fd_sc_hd__clkbuf_16 A VGND VNB VPB VPWR X
.ends

* Black-box entry subcircuit for sky130_fd_sc_hd__nor3_2 abstract view
.subckt sky130_fd_sc_hd__nor3_2 A B C VGND VNB VPB VPWR Y
.ends

* Black-box entry subcircuit for sky130_fd_sc_hd__a22o_4 abstract view
.subckt sky130_fd_sc_hd__a22o_4 A1 A2 B1 B2 VGND VNB VPB VPWR X
.ends

* Black-box entry subcircuit for sky130_fd_sc_hd__clkbuf_4 abstract view
.subckt sky130_fd_sc_hd__clkbuf_4 A VGND VNB VPB VPWR X
.ends

* Black-box entry subcircuit for sky130_fd_sc_hd__a21bo_2 abstract view
.subckt sky130_fd_sc_hd__a21bo_2 A1 A2 B1_N VGND VNB VPB VPWR X
.ends

* Black-box entry subcircuit for sky130_fd_sc_hd__a221oi_4 abstract view
.subckt sky130_fd_sc_hd__a221oi_4 A1 A2 B1 B2 C1 VGND VNB VPB VPWR Y
.ends

* Black-box entry subcircuit for sky130_fd_sc_hd__a21boi_2 abstract view
.subckt sky130_fd_sc_hd__a21boi_2 A1 A2 B1_N VGND VNB VPB VPWR Y
.ends

* Black-box entry subcircuit for sky130_fd_sc_hd__nand2_4 abstract view
.subckt sky130_fd_sc_hd__nand2_4 A B VGND VNB VPB VPWR Y
.ends

* Black-box entry subcircuit for sky130_fd_sc_hd__a41oi_2 abstract view
.subckt sky130_fd_sc_hd__a41oi_2 A1 A2 A3 A4 B1 VGND VNB VPB VPWR Y
.ends

* Black-box entry subcircuit for sky130_fd_sc_hd__o22a_4 abstract view
.subckt sky130_fd_sc_hd__o22a_4 A1 A2 B1 B2 VGND VNB VPB VPWR X
.ends

* Black-box entry subcircuit for sky130_fd_sc_hd__o22ai_4 abstract view
.subckt sky130_fd_sc_hd__o22ai_4 A1 A2 B1 B2 VGND VNB VPB VPWR Y
.ends

* Black-box entry subcircuit for sky130_fd_sc_hd__or4b_2 abstract view
.subckt sky130_fd_sc_hd__or4b_2 A B C D_N VGND VNB VPB VPWR X
.ends

* Black-box entry subcircuit for sky130_fd_sc_hd__o2111a_2 abstract view
.subckt sky130_fd_sc_hd__o2111a_2 A1 A2 B1 C1 D1 VGND VNB VPB VPWR X
.ends

* Black-box entry subcircuit for sky130_fd_sc_hd__and4b_2 abstract view
.subckt sky130_fd_sc_hd__and4b_2 A_N B C D VGND VNB VPB VPWR X
.ends

* Black-box entry subcircuit for sky130_fd_sc_hd__and2b_2 abstract view
.subckt sky130_fd_sc_hd__and2b_2 A_N B VGND VNB VPB VPWR X
.ends

* Black-box entry subcircuit for sky130_fd_sc_hd__inv_6 abstract view
.subckt sky130_fd_sc_hd__inv_6 A VGND VNB VPB VPWR Y
.ends

* Black-box entry subcircuit for sky130_fd_sc_hd__a32oi_2 abstract view
.subckt sky130_fd_sc_hd__a32oi_2 A1 A2 A3 B1 B2 VGND VNB VPB VPWR Y
.ends

* Black-box entry subcircuit for sky130_fd_sc_hd__o32a_2 abstract view
.subckt sky130_fd_sc_hd__o32a_2 A1 A2 A3 B1 B2 VGND VNB VPB VPWR X
.ends

* Black-box entry subcircuit for sky130_fd_sc_hd__a221oi_2 abstract view
.subckt sky130_fd_sc_hd__a221oi_2 A1 A2 B1 B2 C1 VGND VNB VPB VPWR Y
.ends

* Black-box entry subcircuit for sky130_fd_sc_hd__nand3b_2 abstract view
.subckt sky130_fd_sc_hd__nand3b_2 A_N B C VGND VNB VPB VPWR Y
.ends

* Black-box entry subcircuit for sky130_fd_sc_hd__nor3_4 abstract view
.subckt sky130_fd_sc_hd__nor3_4 A B C VGND VNB VPB VPWR Y
.ends

* Black-box entry subcircuit for sky130_fd_sc_hd__a32oi_4 abstract view
.subckt sky130_fd_sc_hd__a32oi_4 A1 A2 A3 B1 B2 VGND VNB VPB VPWR Y
.ends

* Black-box entry subcircuit for sky130_fd_sc_hd__clkinv_2 abstract view
.subckt sky130_fd_sc_hd__clkinv_2 A VGND VNB VPB VPWR Y
.ends

* Black-box entry subcircuit for sky130_fd_sc_hd__inv_4 abstract view
.subckt sky130_fd_sc_hd__inv_4 A VGND VNB VPB VPWR Y
.ends

* Black-box entry subcircuit for sky130_fd_sc_hd__clkinvlp_4 abstract view
.subckt sky130_fd_sc_hd__clkinvlp_4 A VGND VNB VPB VPWR Y
.ends

* Black-box entry subcircuit for sky130_fd_sc_hd__clkinv_1 abstract view
.subckt sky130_fd_sc_hd__clkinv_1 A VGND VNB VPB VPWR Y
.ends

* Black-box entry subcircuit for sky130_fd_sc_hd__o32ai_2 abstract view
.subckt sky130_fd_sc_hd__o32ai_2 A1 A2 A3 B1 B2 VGND VNB VPB VPWR Y
.ends

* Black-box entry subcircuit for sky130_fd_sc_hd__clkinv_4 abstract view
.subckt sky130_fd_sc_hd__clkinv_4 A VGND VNB VPB VPWR Y
.ends

* Black-box entry subcircuit for sky130_fd_sc_hd__a311oi_2 abstract view
.subckt sky130_fd_sc_hd__a311oi_2 A1 A2 A3 B1 C1 VGND VNB VPB VPWR Y
.ends

* Black-box entry subcircuit for sky130_fd_sc_hd__o311a_4 abstract view
.subckt sky130_fd_sc_hd__o311a_4 A1 A2 A3 B1 C1 VGND VNB VPB VPWR X
.ends

* Black-box entry subcircuit for sky130_fd_sc_hd__nor2b_2 abstract view
.subckt sky130_fd_sc_hd__nor2b_2 A B_N VGND VNB VPB VPWR Y
.ends

* Black-box entry subcircuit for sky130_fd_sc_hd__bufinv_16 abstract view
.subckt sky130_fd_sc_hd__bufinv_16 A VGND VNB VPB VPWR Y
.ends

* Black-box entry subcircuit for sky130_fd_sc_hd__xnor2_2 abstract view
.subckt sky130_fd_sc_hd__xnor2_2 A B VGND VNB VPB VPWR Y
.ends

* Black-box entry subcircuit for sky130_fd_sc_hd__o2111ai_4 abstract view
.subckt sky130_fd_sc_hd__o2111ai_4 A1 A2 B1 C1 D1 VGND VNB VPB VPWR Y
.ends

* Black-box entry subcircuit for sky130_fd_sc_hd__clkbuf_1 abstract view
.subckt sky130_fd_sc_hd__clkbuf_1 A VGND VNB VPB VPWR X
.ends

* Black-box entry subcircuit for sky130_fd_sc_hd__clkbuf_2 abstract view
.subckt sky130_fd_sc_hd__clkbuf_2 A VGND VNB VPB VPWR X
.ends

* Black-box entry subcircuit for sky130_fd_sc_hd__o41ai_2 abstract view
.subckt sky130_fd_sc_hd__o41ai_2 A1 A2 A3 A4 B1 VGND VNB VPB VPWR Y
.ends

* Black-box entry subcircuit for sky130_fd_sc_hd__inv_8 abstract view
.subckt sky130_fd_sc_hd__inv_8 A VGND VNB VPB VPWR Y
.ends

* Black-box entry subcircuit for sky130_fd_sc_hd__or2b_2 abstract view
.subckt sky130_fd_sc_hd__or2b_2 A B_N VGND VNB VPB VPWR X
.ends

* Black-box entry subcircuit for sky130_fd_sc_hd__and4_4 abstract view
.subckt sky130_fd_sc_hd__and4_4 A B C D VGND VNB VPB VPWR X
.ends

* Black-box entry subcircuit for sky130_fd_sc_hd__o31a_4 abstract view
.subckt sky130_fd_sc_hd__o31a_4 A1 A2 A3 B1 VGND VNB VPB VPWR X
.ends

* Black-box entry subcircuit for sky130_fd_sc_hd__nor4b_2 abstract view
.subckt sky130_fd_sc_hd__nor4b_2 A B C D_N VGND VNB VPB VPWR Y
.ends

* Black-box entry subcircuit for sky130_fd_sc_hd__a211oi_4 abstract view
.subckt sky130_fd_sc_hd__a211oi_4 A1 A2 B1 C1 VGND VNB VPB VPWR Y
.ends

* Black-box entry subcircuit for sky130_fd_sc_hd__or2_4 abstract view
.subckt sky130_fd_sc_hd__or2_4 A B VGND VNB VPB VPWR X
.ends

* Black-box entry subcircuit for sky130_fd_sc_hd__a2111oi_4 abstract view
.subckt sky130_fd_sc_hd__a2111oi_4 A1 A2 B1 C1 D1 VGND VNB VPB VPWR Y
.ends

* Black-box entry subcircuit for sky130_fd_sc_hd__nor4_4 abstract view
.subckt sky130_fd_sc_hd__nor4_4 A B C D VGND VNB VPB VPWR Y
.ends

* Black-box entry subcircuit for sky130_fd_sc_hd__a2bb2oi_2 abstract view
.subckt sky130_fd_sc_hd__a2bb2oi_2 A1_N A2_N B1 B2 VGND VNB VPB VPWR Y
.ends

* Black-box entry subcircuit for sky130_fd_sc_hd__a22oi_4 abstract view
.subckt sky130_fd_sc_hd__a22oi_4 A1 A2 B1 B2 VGND VNB VPB VPWR Y
.ends

* Black-box entry subcircuit for sky130_fd_sc_hd__o311ai_2 abstract view
.subckt sky130_fd_sc_hd__o311ai_2 A1 A2 A3 B1 C1 VGND VNB VPB VPWR Y
.ends

* Black-box entry subcircuit for sky130_fd_sc_hd__o31ai_4 abstract view
.subckt sky130_fd_sc_hd__o31ai_4 A1 A2 A3 B1 VGND VNB VPB VPWR Y
.ends

* Black-box entry subcircuit for sky130_fd_sc_hd__dlymetal6s4s_1 abstract view
.subckt sky130_fd_sc_hd__dlymetal6s4s_1 A VGND VNB VPB VPWR X
.ends

* Black-box entry subcircuit for sky130_fd_sc_hd__dlymetal6s2s_1 abstract view
.subckt sky130_fd_sc_hd__dlymetal6s2s_1 A VGND VNB VPB VPWR X
.ends

* Black-box entry subcircuit for sky130_fd_sc_hd__a2111o_2 abstract view
.subckt sky130_fd_sc_hd__a2111o_2 A1 A2 B1 C1 D1 VGND VNB VPB VPWR X
.ends

* Black-box entry subcircuit for sky130_fd_sc_hd__nand4b_4 abstract view
.subckt sky130_fd_sc_hd__nand4b_4 A_N B C D VGND VNB VPB VPWR Y
.ends

* Black-box entry subcircuit for sky130_fd_sc_hd__or3b_4 abstract view
.subckt sky130_fd_sc_hd__or3b_4 A B C_N VGND VNB VPB VPWR X
.ends

* Black-box entry subcircuit for sky130_fd_sc_hd__dlygate4sd1_1 abstract view
.subckt sky130_fd_sc_hd__dlygate4sd1_1 A VGND VNB VPB VPWR X
.ends

* Black-box entry subcircuit for sky130_fd_sc_hd__and3b_2 abstract view
.subckt sky130_fd_sc_hd__and3b_2 A_N B C VGND VNB VPB VPWR X
.ends

* Black-box entry subcircuit for sky130_fd_sc_hd__a21o_4 abstract view
.subckt sky130_fd_sc_hd__a21o_4 A1 A2 B1 VGND VNB VPB VPWR X
.ends

* Black-box entry subcircuit for sky130_fd_sc_hd__nor3b_2 abstract view
.subckt sky130_fd_sc_hd__nor3b_2 A B C_N VGND VNB VPB VPWR Y
.ends

* Black-box entry subcircuit for sky130_fd_sc_hd__and2_4 abstract view
.subckt sky130_fd_sc_hd__and2_4 A B VGND VNB VPB VPWR X
.ends

* Black-box entry subcircuit for sky130_fd_sc_hd__o2bb2ai_2 abstract view
.subckt sky130_fd_sc_hd__o2bb2ai_2 A1_N A2_N B1 B2 VGND VNB VPB VPWR Y
.ends

* Black-box entry subcircuit for sky130_fd_sc_hd__or2b_4 abstract view
.subckt sky130_fd_sc_hd__or2b_4 A B_N VGND VNB VPB VPWR X
.ends

* Black-box entry subcircuit for sky130_fd_sc_hd__o211a_4 abstract view
.subckt sky130_fd_sc_hd__o211a_4 A1 A2 B1 C1 VGND VNB VPB VPWR X
.ends

.subckt topmodule VGND VPWR clk instruct_en result[0] result[10] result[11] result[12]
+ result[13] result[14] result[15] result[16] result[17] result[18] result[19] result[1]
+ result[20] result[21] result[22] result[23] result[24] result[25] result[26] result[27]
+ result[28] result[29] result[2] result[30] result[31] result[3] result[4] result[5]
+ result[6] result[7] result[8] result[9] rst
XFILLER_39_222 VGND VGND VPWR VPWR sky130_fd_sc_hd__fill_2
XFILLER_39_255 VGND VGND VPWR VPWR sky130_fd_sc_hd__decap_3
XFILLER_54_203 VGND VGND VPWR VPWR sky130_fd_sc_hd__decap_3
XFILLER_82_523 VGND VGND VPWR VPWR sky130_fd_sc_hd__fill_1
XFILLER_82_545 VGND VGND VPWR VPWR sky130_fd_sc_hd__fill_1
X_6914_ _7509_/CLK _6914_/D VGND VGND VPWR VPWR _6914_/Q sky130_fd_sc_hd__dfxtp_2
XFILLER_82_589 VGND VGND VPWR VPWR sky130_fd_sc_hd__fill_2
XFILLER_52_29 VGND VGND VPWR VPWR sky130_fd_sc_hd__decap_3
X_6845_ _7393_/CLK _6845_/D VGND VGND VPWR VPWR _6845_/Q sky130_fd_sc_hd__dfxtp_2
XFILLER_10_306 VGND VGND VPWR VPWR sky130_fd_sc_hd__fill_2
XFILLER_22_155 VGND VGND VPWR VPWR sky130_fd_sc_hd__decap_3
X_3988_ _3988_/A _3988_/B VGND VGND VPWR VPWR _3988_/Y sky130_fd_sc_hd__nand2_2
XTAP_TAPCELL_ROW_75_1008 VGND VPWR sky130_fd_sc_hd__tapvpwrvgnd_1
X_5589_ _5589_/A0 _5711_/A1 _5593_/S VGND VGND VPWR VPWR _7226_/D sky130_fd_sc_hd__mux2_2
X_4609_ _4609_/A _6465_/B _4609_/C VGND VGND VPWR VPWR _4675_/C sky130_fd_sc_hd__or3_2
X_7328_ _7393_/CLK _7328_/D place2023/X VGND VGND VPWR VPWR _7328_/Q sky130_fd_sc_hd__dfrtp_2
Xplace1083 _4292_/Y VGND VGND VPWR VPWR _6221_/D1 sky130_fd_sc_hd__buf_6
Xplace1094 _5188_/A1 VGND VGND VPWR VPWR _5705_/A1 sky130_fd_sc_hd__buf_2
X_7259_ _7289_/CLK _7259_/D VGND VGND VPWR VPWR _7259_/Q sky130_fd_sc_hd__dfxtp_2
XFILLER_89_166 VGND VGND VPWR VPWR sky130_fd_sc_hd__fill_2
XFILLER_18_417 VGND VGND VPWR VPWR sky130_fd_sc_hd__decap_3
XFILLER_58_586 VGND VGND VPWR VPWR sky130_fd_sc_hd__fill_2
XFILLER_45_203 VGND VGND VPWR VPWR sky130_fd_sc_hd__decap_3
XFILLER_45_225 VGND VGND VPWR VPWR sky130_fd_sc_hd__decap_3
XTAP_TAPCELL_ROW_86_1126 VGND VPWR sky130_fd_sc_hd__tapvpwrvgnd_1
XFILLER_26_472 VGND VGND VPWR VPWR sky130_fd_sc_hd__decap_3
XFILLER_26_483 VGND VGND VPWR VPWR sky130_fd_sc_hd__fill_2
XFILLER_13_133 VGND VGND VPWR VPWR sky130_fd_sc_hd__decap_3
XFILLER_26_85 VGND VGND VPWR VPWR sky130_fd_sc_hd__decap_3
XFILLER_13_166 VGND VGND VPWR VPWR sky130_fd_sc_hd__fill_2
XTAP_TAPCELL_ROW_11_334 VGND VPWR sky130_fd_sc_hd__tapvpwrvgnd_1
XTAP_TAPCELL_ROW_97_1244 VGND VPWR sky130_fd_sc_hd__tapvpwrvgnd_1
XPHY_EDGE_ROW_39_Left_143 VGND VGND VPWR VPWR sky130_fd_sc_hd__decap_3
XFILLER_3_89 VGND VGND VPWR VPWR sky130_fd_sc_hd__decap_3
XFILLER_49_542 VGND VGND VPWR VPWR sky130_fd_sc_hd__decap_3
XFILLER_68_339 VGND VGND VPWR VPWR sky130_fd_sc_hd__fill_2
XFILLER_95_169 VGND VGND VPWR VPWR sky130_fd_sc_hd__decap_3
XFILLER_91_320 VGND VGND VPWR VPWR sky130_fd_sc_hd__fill_1
XTAP_TAPCELL_ROW_47_721 VGND VPWR sky130_fd_sc_hd__tapvpwrvgnd_1
XTAP_TAPCELL_ROW_19_423 VGND VPWR sky130_fd_sc_hd__tapvpwrvgnd_1
XPHY_EDGE_ROW_48_Left_152 VGND VGND VPWR VPWR sky130_fd_sc_hd__decap_3
XFILLER_64_589 VGND VGND VPWR VPWR sky130_fd_sc_hd__fill_2
X_4960_ _4960_/A0 _5296_/A1 _4964_/S VGND VGND VPWR VPWR _6953_/D sky130_fd_sc_hd__mux2_2
XFILLER_32_442 VGND VGND VPWR VPWR sky130_fd_sc_hd__decap_3
X_3911_ _7301_/Q _3920_/B _3910_/Y VGND VGND VPWR VPWR _3916_/A sky130_fd_sc_hd__a21oi_2
XFILLER_32_475 VGND VGND VPWR VPWR sky130_fd_sc_hd__fill_1
X_6630_ _6630_/A0 _6217_/X _6638_/S VGND VGND VPWR VPWR _7478_/D sky130_fd_sc_hd__mux2_2
X_3842_ _3842_/A _3842_/B _3842_/C VGND VGND VPWR VPWR _3842_/X sky130_fd_sc_hd__and3_2
XFILLER_32_486 VGND VGND VPWR VPWR sky130_fd_sc_hd__decap_3
X_6561_ _6559_/Y _6566_/A2 _6560_/Y VGND VGND VPWR VPWR _6561_/Y sky130_fd_sc_hd__a21oi_2
X_3773_ _3773_/A _3773_/B VGND VGND VPWR VPWR _3773_/Y sky130_fd_sc_hd__nand2_2
XPHY_EDGE_ROW_57_Left_161 VGND VGND VPWR VPWR sky130_fd_sc_hd__decap_3
X_6492_ _6492_/A0 _6490_/X _6497_/S VGND VGND VPWR VPWR _7426_/D sky130_fd_sc_hd__mux2_2
X_5374_ _5374_/A0 _5679_/A1 _5391_/S VGND VGND VPWR VPWR _7127_/D sky130_fd_sc_hd__mux2_2
XFILLER_99_442 VGND VGND VPWR VPWR sky130_fd_sc_hd__decap_3
X_7113_ _7114_/CLK _7113_/D VGND VGND VPWR VPWR _7113_/Q sky130_fd_sc_hd__dfxtp_2
X_4325_ _4508_/A _4325_/B VGND VGND VPWR VPWR _4325_/Y sky130_fd_sc_hd__nor2_2
XFILLER_59_306 VGND VGND VPWR VPWR sky130_fd_sc_hd__fill_1
X_7044_ _7490_/CLK _7044_/D VGND VGND VPWR VPWR _7044_/Q sky130_fd_sc_hd__dfxtp_2
X_4256_ _4253_/A _4745_/A2 _4252_/Y _4253_/X _4255_/Y VGND VGND VPWR VPWR _4260_/C
+ sky130_fd_sc_hd__o311a_2
XFILLER_74_309 VGND VGND VPWR VPWR sky130_fd_sc_hd__fill_1
X_4187_ _6180_/A1 _4278_/A2 _4510_/C _4185_/X _4186_/Y VGND VGND VPWR VPWR _4187_/X
+ sky130_fd_sc_hd__o311a_2
XFILLER_27_225 VGND VGND VPWR VPWR sky130_fd_sc_hd__decap_3
XPHY_EDGE_ROW_66_Left_170 VGND VGND VPWR VPWR sky130_fd_sc_hd__decap_3
XFILLER_103_46 VGND VGND VPWR VPWR sky130_fd_sc_hd__fill_1
XFILLER_103_57 VGND VGND VPWR VPWR sky130_fd_sc_hd__fill_1
XFILLER_42_206 VGND VGND VPWR VPWR sky130_fd_sc_hd__decap_3
XFILLER_42_239 VGND VGND VPWR VPWR sky130_fd_sc_hd__decap_3
XFILLER_50_250 VGND VGND VPWR VPWR sky130_fd_sc_hd__fill_2
X_6828_ _6838_/A _6828_/B VGND VGND VPWR VPWR _7572_/D sky130_fd_sc_hd__and2_2
XTAP_TAPCELL_ROW_53_779 VGND VPWR sky130_fd_sc_hd__tapvpwrvgnd_1
XTAP_TAPCELL_ROW_81_1078 VGND VPWR sky130_fd_sc_hd__tapvpwrvgnd_1
XFILLER_6_107 VGND VGND VPWR VPWR sky130_fd_sc_hd__decap_3
X_6759_ _6182_/X _6759_/A1 _6765_/S VGND VGND VPWR VPWR _7539_/D sky130_fd_sc_hd__mux2_2
XFILLER_10_169 VGND VGND VPWR VPWR sky130_fd_sc_hd__decap_3
XFILLER_2_346 VGND VGND VPWR VPWR sky130_fd_sc_hd__decap_3
XTAP_TAPCELL_ROW_92_1185 VGND VPWR sky130_fd_sc_hd__tapvpwrvgnd_1
XFILLER_58_394 VGND VGND VPWR VPWR sky130_fd_sc_hd__decap_3
XFILLER_18_236 VGND VGND VPWR VPWR sky130_fd_sc_hd__decap_3
XFILLER_37_73 VGND VGND VPWR VPWR sky130_fd_sc_hd__fill_2
XFILLER_46_545 VGND VGND VPWR VPWR sky130_fd_sc_hd__decap_3
XFILLER_18_269 VGND VGND VPWR VPWR sky130_fd_sc_hd__fill_1
XFILLER_33_206 VGND VGND VPWR VPWR sky130_fd_sc_hd__decap_3
XFILLER_46_589 VGND VGND VPWR VPWR sky130_fd_sc_hd__decap_3
XFILLER_33_228 VGND VGND VPWR VPWR sky130_fd_sc_hd__decap_3
XFILLER_14_475 VGND VGND VPWR VPWR sky130_fd_sc_hd__fill_1
XFILLER_53_83 VGND VGND VPWR VPWR sky130_fd_sc_hd__decap_3
XTAP_TAPCELL_ROW_24_470 VGND VPWR sky130_fd_sc_hd__tapvpwrvgnd_1
XTAP_TAPCELL_ROW_101_1281 VGND VPWR sky130_fd_sc_hd__tapvpwrvgnd_1
Xplace1808 _3498_/Y VGND VGND VPWR VPWR _3853_/B sky130_fd_sc_hd__buf_2
Xplace1819 _6182_/A2 VGND VGND VPWR VPWR _6220_/A2 sky130_fd_sc_hd__buf_2
X_4110_ _4110_/A _4110_/B VGND VGND VPWR VPWR _4110_/Y sky130_fd_sc_hd__nand2_2
X_4041_ _7301_/Q _4043_/D _7302_/Q VGND VGND VPWR VPWR _4042_/B sky130_fd_sc_hd__a21oi_2
XFILLER_37_501 VGND VGND VPWR VPWR sky130_fd_sc_hd__decap_3
X_5992_ _5990_/X _5991_/X _5813_/A VGND VGND VPWR VPWR _5992_/Y sky130_fd_sc_hd__a21oi_2
XFILLER_24_239 VGND VGND VPWR VPWR sky130_fd_sc_hd__fill_1
XFILLER_52_559 VGND VGND VPWR VPWR sky130_fd_sc_hd__decap_3
X_4943_ _4943_/A0 _5342_/A1 _4958_/S VGND VGND VPWR VPWR _6945_/D sky130_fd_sc_hd__mux2_2
XFILLER_32_283 VGND VGND VPWR VPWR sky130_fd_sc_hd__decap_3
X_6613_ _6613_/A0 _6128_/X _6634_/S VGND VGND VPWR VPWR _7470_/D sky130_fd_sc_hd__mux2_2
XTAP_TAPCELL_ROW_50_749 VGND VPWR sky130_fd_sc_hd__tapvpwrvgnd_1
XFILLER_20_445 VGND VGND VPWR VPWR sky130_fd_sc_hd__decap_3
X_7593_ _7611_/CLK _7593_/D place2058/X VGND VGND VPWR VPWR _7593_/Q sky130_fd_sc_hd__dfrtp_2
X_3825_ _3836_/A1 _3825_/A2 _7501_/Q _3617_/Y _7437_/Q VGND VGND VPWR VPWR _3825_/X
+ sky130_fd_sc_hd__a32o_2
X_6544_ _6544_/A0 _6181_/X _6569_/S VGND VGND VPWR VPWR _7442_/D sky130_fd_sc_hd__mux2_4
X_3756_ _7410_/Q _6662_/S _3755_/X VGND VGND VPWR VPWR _3756_/Y sky130_fd_sc_hd__a21oi_2
X_6475_ _6475_/A _6475_/B VGND VGND VPWR VPWR _6475_/Y sky130_fd_sc_hd__nand2_2
X_3687_ _7451_/Q _3913_/A2 _3733_/A2 _7355_/Q _3686_/X VGND VGND VPWR VPWR _3687_/X
+ sky130_fd_sc_hd__a221o_2
XFILLER_87_401 VGND VGND VPWR VPWR sky130_fd_sc_hd__decap_3
X_5357_ _5357_/A0 _5357_/A1 _5357_/S VGND VGND VPWR VPWR _7120_/D sky130_fd_sc_hd__mux2_2
XFILLER_59_125 VGND VGND VPWR VPWR sky130_fd_sc_hd__decap_3
X_4308_ _4448_/C _4510_/A _4373_/C _6302_/B VGND VGND VPWR VPWR _4308_/X sky130_fd_sc_hd__a31o_2
XFILLER_59_147 VGND VGND VPWR VPWR sky130_fd_sc_hd__decap_3
XFILLER_59_169 VGND VGND VPWR VPWR sky130_fd_sc_hd__fill_2
X_7027_ _7114_/CLK _7027_/D VGND VGND VPWR VPWR _7027_/Q sky130_fd_sc_hd__dfxtp_2
X_4239_ _4232_/X _4238_/B _4237_/X _4238_/X VGND VGND VPWR VPWR _4239_/Y sky130_fd_sc_hd__o211ai_4
XFILLER_101_277 VGND VGND VPWR VPWR sky130_fd_sc_hd__decap_3
XFILLER_28_523 VGND VGND VPWR VPWR sky130_fd_sc_hd__decap_3
XTAP_TAPCELL_ROW_58_827 VGND VPWR sky130_fd_sc_hd__tapvpwrvgnd_1
XFILLER_28_589 VGND VGND VPWR VPWR sky130_fd_sc_hd__fill_2
XFILLER_43_526 VGND VGND VPWR VPWR sky130_fd_sc_hd__decap_3
XFILLER_55_386 VGND VGND VPWR VPWR sky130_fd_sc_hd__fill_2
XFILLER_15_228 VGND VGND VPWR VPWR sky130_fd_sc_hd__decap_3
XFILLER_43_559 VGND VGND VPWR VPWR sky130_fd_sc_hd__fill_1
XFILLER_23_261 VGND VGND VPWR VPWR sky130_fd_sc_hd__decap_3
XFILLER_7_427 VGND VGND VPWR VPWR sky130_fd_sc_hd__fill_2
XTAP_TAPCELL_ROW_21_440 VGND VPWR sky130_fd_sc_hd__tapvpwrvgnd_1
XFILLER_99_35 VGND VGND VPWR VPWR sky130_fd_sc_hd__fill_1
XTAP_TAPCELL_ROW_94_1214 VGND VPWR sky130_fd_sc_hd__tapvpwrvgnd_1
XFILLER_3_611 VGND VGND VPWR VPWR sky130_fd_sc_hd__fill_1
XFILLER_99_57 VGND VGND VPWR VPWR sky130_fd_sc_hd__fill_2
XFILLER_46_331 VGND VGND VPWR VPWR sky130_fd_sc_hd__decap_3
XFILLER_19_578 VGND VGND VPWR VPWR sky130_fd_sc_hd__decap_3
XFILLER_61_312 VGND VGND VPWR VPWR sky130_fd_sc_hd__decap_3
XFILLER_61_334 VGND VGND VPWR VPWR sky130_fd_sc_hd__fill_2
XTAP_TAPCELL_ROW_103_1310 VGND VPWR sky130_fd_sc_hd__tapvpwrvgnd_1
XFILLER_9_55 VGND VGND VPWR VPWR sky130_fd_sc_hd__fill_1
XFILLER_9_99 VGND VGND VPWR VPWR sky130_fd_sc_hd__fill_1
X_4590_ _4590_/A0 _5612_/A1 _4665_/S VGND VGND VPWR VPWR _6844_/D sky130_fd_sc_hd__mux2_2
X_3541_ _3541_/A _3975_/C _3975_/B _3541_/D VGND VGND VPWR VPWR _3541_/X sky130_fd_sc_hd__and4_2
Xplace1605 _4261_/A VGND VGND VPWR VPWR _4297_/A sky130_fd_sc_hd__buf_2
Xplace1616 _6518_/S VGND VGND VPWR VPWR _6529_/S sky130_fd_sc_hd__buf_2
Xplace1627 _3617_/Y VGND VGND VPWR VPWR _4009_/B1 sky130_fd_sc_hd__buf_6
XFILLER_50_3 VGND VGND VPWR VPWR sky130_fd_sc_hd__decap_3
Xplace1638 _3670_/B VGND VGND VPWR VPWR _4244_/B1 sky130_fd_sc_hd__buf_2
Xplace1649 _3582_/Y VGND VGND VPWR VPWR _4250_/C1 sky130_fd_sc_hd__buf_2
X_6260_ _6292_/A _6260_/B VGND VGND VPWR VPWR _7337_/D sky130_fd_sc_hd__and2_2
X_3472_ _3433_/A _3473_/A VGND VGND VPWR VPWR _3472_/Y sky130_fd_sc_hd__nand2b_2
Xhold3008 _7369_/Q VGND VGND VPWR VPWR _6322_/B2 sky130_fd_sc_hd__dlygate4sd3_1
Xhold3019 _7405_/Q VGND VGND VPWR VPWR _6376_/B2 sky130_fd_sc_hd__dlygate4sd3_1
X_6191_ _6188_/X _6398_/B1 _5813_/A _6190_/X VGND VGND VPWR VPWR _6198_/A sky130_fd_sc_hd__o22a_2
X_5211_ _5211_/A0 _4769_/Y _5211_/S VGND VGND VPWR VPWR _7066_/D sky130_fd_sc_hd__mux2_2
X_5142_ _5142_/A0 _4745_/Y _5152_/S VGND VGND VPWR VPWR _7034_/D sky130_fd_sc_hd__mux2_2
XFILLER_96_253 VGND VGND VPWR VPWR sky130_fd_sc_hd__fill_2
XFILLER_56_117 VGND VGND VPWR VPWR sky130_fd_sc_hd__fill_2
XFILLER_84_415 VGND VGND VPWR VPWR sky130_fd_sc_hd__fill_1
XFILLER_37_320 VGND VGND VPWR VPWR sky130_fd_sc_hd__decap_3
XFILLER_49_191 VGND VGND VPWR VPWR sky130_fd_sc_hd__decap_3
XFILLER_37_353 VGND VGND VPWR VPWR sky130_fd_sc_hd__decap_3
XFILLER_25_526 VGND VGND VPWR VPWR sky130_fd_sc_hd__decap_3
XFILLER_25_548 VGND VGND VPWR VPWR sky130_fd_sc_hd__decap_3
XFILLER_64_194 VGND VGND VPWR VPWR sky130_fd_sc_hd__fill_2
X_5975_ _6213_/A1 _6892_/Q _7284_/Q _6165_/A1 VGND VGND VPWR VPWR _5975_/Y sky130_fd_sc_hd__o22ai_2
XFILLER_33_581 VGND VGND VPWR VPWR sky130_fd_sc_hd__decap_3
X_4926_ _4926_/A0 _5692_/A1 _4952_/S VGND VGND VPWR VPWR _6937_/D sky130_fd_sc_hd__mux2_2
XTAP_TAPCELL_ROW_63_885 VGND VPWR sky130_fd_sc_hd__tapvpwrvgnd_1
XTAP_TAPCELL_ROW_35_587 VGND VPWR sky130_fd_sc_hd__tapvpwrvgnd_1
XFILLER_20_231 VGND VGND VPWR VPWR sky130_fd_sc_hd__fill_2
X_7576_ _7579_/CLK _7576_/D place2016/X VGND VGND VPWR VPWR _7576_/Q sky130_fd_sc_hd__dfrtp_2
X_3808_ _3670_/A _4676_/A0 _3807_/D VGND VGND VPWR VPWR _3809_/B sky130_fd_sc_hd__o21ai_2
X_6527_ _7434_/Q _6080_/X _6541_/S VGND VGND VPWR VPWR _7434_/D sky130_fd_sc_hd__mux2_2
X_3739_ _4297_/C _3736_/X _3738_/X VGND VGND VPWR VPWR _3739_/Y sky130_fd_sc_hd__o21ai_4
X_6458_ _5813_/A _6451_/X _6454_/X _6458_/B2 _6457_/X VGND VGND VPWR VPWR _6458_/X
+ sky130_fd_sc_hd__o221a_2
X_6389_ _6389_/A _6389_/B _6389_/C _6564_/D VGND VGND VPWR VPWR _6389_/Y sky130_fd_sc_hd__nand4_2
Xhold2830 _7359_/Q VGND VGND VPWR VPWR _6309_/B2 sky130_fd_sc_hd__dlygate4sd3_1
Xhold2841 _7332_/Q VGND VGND VPWR VPWR _6250_/B sky130_fd_sc_hd__dlygate4sd3_1
XFILLER_47_106 VGND VGND VPWR VPWR sky130_fd_sc_hd__decap_3
XFILLER_47_117 VGND VGND VPWR VPWR sky130_fd_sc_hd__fill_2
Xhold2852 _7562_/Q VGND VGND VPWR VPWR _6807_/B sky130_fd_sc_hd__dlygate4sd3_1
Xhold2863 _7383_/Q VGND VGND VPWR VPWR _6342_/B2 sky130_fd_sc_hd__dlygate4sd3_1
Xhold2874 _7351_/Q VGND VGND VPWR VPWR _6290_/B sky130_fd_sc_hd__dlygate4sd3_1
XFILLER_18_42 VGND VGND VPWR VPWR sky130_fd_sc_hd__decap_3
XFILLER_47_139 VGND VGND VPWR VPWR sky130_fd_sc_hd__fill_2
Xhold2885 _7350_/Q VGND VGND VPWR VPWR _6288_/B sky130_fd_sc_hd__dlygate4sd3_1
Xhold2896 _7386_/Q VGND VGND VPWR VPWR _6345_/B2 sky130_fd_sc_hd__dlygate4sd3_1
XFILLER_55_161 VGND VGND VPWR VPWR sky130_fd_sc_hd__decap_3
XFILLER_16_548 VGND VGND VPWR VPWR sky130_fd_sc_hd__decap_3
XFILLER_43_334 VGND VGND VPWR VPWR sky130_fd_sc_hd__fill_2
XFILLER_70_131 VGND VGND VPWR VPWR sky130_fd_sc_hd__fill_1
XFILLER_31_529 VGND VGND VPWR VPWR sky130_fd_sc_hd__decap_3
XFILLER_11_231 VGND VGND VPWR VPWR sky130_fd_sc_hd__decap_3
XFILLER_34_85 VGND VGND VPWR VPWR sky130_fd_sc_hd__decap_3
XFILLER_70_197 VGND VGND VPWR VPWR sky130_fd_sc_hd__fill_1
XFILLER_7_257 VGND VGND VPWR VPWR sky130_fd_sc_hd__decap_3
XFILLER_50_62 VGND VGND VPWR VPWR sky130_fd_sc_hd__decap_3
XFILLER_66_415 VGND VGND VPWR VPWR sky130_fd_sc_hd__decap_3
XFILLER_15_6 VGND VGND VPWR VPWR sky130_fd_sc_hd__decap_3
XFILLER_38_139 VGND VGND VPWR VPWR sky130_fd_sc_hd__fill_1
XFILLER_78_297 VGND VGND VPWR VPWR sky130_fd_sc_hd__decap_3
XTAP_TAPCELL_ROW_6_290 VGND VPWR sky130_fd_sc_hd__tapvpwrvgnd_1
XFILLER_46_150 VGND VGND VPWR VPWR sky130_fd_sc_hd__fill_2
XFILLER_34_312 VGND VGND VPWR VPWR sky130_fd_sc_hd__decap_3
XFILLER_46_161 VGND VGND VPWR VPWR sky130_fd_sc_hd__fill_1
XFILLER_46_183 VGND VGND VPWR VPWR sky130_fd_sc_hd__decap_3
XFILLER_62_610 VGND VGND VPWR VPWR sky130_fd_sc_hd__fill_2
XFILLER_22_507 VGND VGND VPWR VPWR sky130_fd_sc_hd__decap_3
XFILLER_61_131 VGND VGND VPWR VPWR sky130_fd_sc_hd__fill_1
XFILLER_22_529 VGND VGND VPWR VPWR sky130_fd_sc_hd__decap_3
XFILLER_61_175 VGND VGND VPWR VPWR sky130_fd_sc_hd__decap_3
X_4711_ _4675_/A _4675_/B _4675_/C _4711_/B1 VGND VGND VPWR VPWR _4711_/X sky130_fd_sc_hd__a31o_2
XTAP_TAPCELL_ROW_60_855 VGND VPWR sky130_fd_sc_hd__tapvpwrvgnd_1
XTAP_TAPCELL_ROW_32_557 VGND VPWR sky130_fd_sc_hd__tapvpwrvgnd_1
X_7430_ clkload4/A _7430_/D place2017/X VGND VGND VPWR VPWR _7430_/Q sky130_fd_sc_hd__dfrtp_2
X_4642_ _4637_/A _6489_/A1 _4637_/B _5850_/C VGND VGND VPWR VPWR _4642_/X sky130_fd_sc_hd__a31o_2
X_7361_ _7581_/CLK _7361_/D place2019/X VGND VGND VPWR VPWR _7361_/Q sky130_fd_sc_hd__dfrtp_2
X_4573_ _7318_/Q _4558_/B _7320_/Q _4558_/D _7321_/Q VGND VGND VPWR VPWR _4573_/X
+ sky130_fd_sc_hd__a41o_2
Xplace1402 _3850_/Y VGND VGND VPWR VPWR _4185_/A sky130_fd_sc_hd__buf_2
Xplace1413 _4245_/A VGND VGND VPWR VPWR _3685_/B sky130_fd_sc_hd__buf_2
Xplace1424 _6089_/B1 VGND VGND VPWR VPWR _6515_/A3 sky130_fd_sc_hd__buf_2
Xplace1435 _3972_/Y VGND VGND VPWR VPWR _3973_/B sky130_fd_sc_hd__buf_2
X_7292_ clkload2/A _7292_/D place2031/X VGND VGND VPWR VPWR _7292_/Q sky130_fd_sc_hd__dfrtp_2
X_6312_ _6312_/A1 _6313_/A2 _6313_/A3 _6313_/B1 _6312_/B2 VGND VGND VPWR VPWR _7362_/D
+ sky130_fd_sc_hd__a32o_2
X_3524_ _3826_/A _3524_/B VGND VGND VPWR VPWR _3524_/Y sky130_fd_sc_hd__nor2_2
Xplace1446 _3871_/Y VGND VGND VPWR VPWR _4180_/A2 sky130_fd_sc_hd__buf_2
Xplace1457 _3760_/Y VGND VGND VPWR VPWR _4227_/D sky130_fd_sc_hd__buf_2
Xplace1468 _3670_/D VGND VGND VPWR VPWR _4567_/B sky130_fd_sc_hd__buf_2
X_6243_ _6247_/A _6243_/B VGND VGND VPWR VPWR _7329_/D sky130_fd_sc_hd__and2_2
X_3455_ _3455_/A _3652_/A _3826_/C _3508_/C VGND VGND VPWR VPWR _3975_/C sky130_fd_sc_hd__nand4_4
Xplace1479 _4144_/C VGND VGND VPWR VPWR _4773_/B1 sky130_fd_sc_hd__buf_2
XFILLER_69_231 VGND VGND VPWR VPWR sky130_fd_sc_hd__decap_3
X_6174_ _7283_/Q _6436_/A _6465_/C _6465_/D VGND VGND VPWR VPWR _6174_/X sky130_fd_sc_hd__or4_2
XFILLER_57_415 VGND VGND VPWR VPWR sky130_fd_sc_hd__decap_3
X_5125_ _5125_/A0 _5336_/A1 _5146_/S VGND VGND VPWR VPWR _7026_/D sky130_fd_sc_hd__mux2_2
XTAP_TAPCELL_ROW_68_933 VGND VPWR sky130_fd_sc_hd__tapvpwrvgnd_1
X_4007_ _7457_/Q _4007_/A2 _4007_/B1 _7393_/Q VGND VGND VPWR VPWR _4011_/C sky130_fd_sc_hd__a22oi_2
XFILLER_25_312 VGND VGND VPWR VPWR sky130_fd_sc_hd__decap_3
XFILLER_25_334 VGND VGND VPWR VPWR sky130_fd_sc_hd__fill_2
XFILLER_40_326 VGND VGND VPWR VPWR sky130_fd_sc_hd__decap_3
XFILLER_52_164 VGND VGND VPWR VPWR sky130_fd_sc_hd__decap_3
X_5958_ _5956_/X _5957_/X _4778_/A _6482_/A2 VGND VGND VPWR VPWR _5962_/C sky130_fd_sc_hd__a211o_2
X_4909_ _4909_/A0 _5221_/A1 _4930_/S VGND VGND VPWR VPWR _6929_/D sky130_fd_sc_hd__mux2_2
XFILLER_21_595 VGND VGND VPWR VPWR sky130_fd_sc_hd__decap_3
X_7559_ _7565_/CLK _7559_/D place2015/X VGND VGND VPWR VPWR _7559_/Q sky130_fd_sc_hd__dfrtp_2
XTAP_TAPCELL_ROW_78_1039 VGND VPWR sky130_fd_sc_hd__tapvpwrvgnd_1
XFILLER_20_21 VGND VGND VPWR VPWR sky130_fd_sc_hd__decap_3
XFILLER_20_32 VGND VGND VPWR VPWR sky130_fd_sc_hd__decap_3
Xplace1991 _3491_/B VGND VGND VPWR VPWR _4373_/B sky130_fd_sc_hd__buf_2
Xplace1980 _3443_/C VGND VGND VPWR VPWR _3487_/C sky130_fd_sc_hd__buf_2
XFILLER_0_455 VGND VGND VPWR VPWR sky130_fd_sc_hd__decap_3
XFILLER_0_477 VGND VGND VPWR VPWR sky130_fd_sc_hd__decap_3
XFILLER_48_415 VGND VGND VPWR VPWR sky130_fd_sc_hd__decap_3
XFILLER_102_394 VGND VGND VPWR VPWR sky130_fd_sc_hd__fill_1
XFILLER_29_63 VGND VGND VPWR VPWR sky130_fd_sc_hd__fill_2
XFILLER_48_459 VGND VGND VPWR VPWR sky130_fd_sc_hd__decap_3
XFILLER_75_223 VGND VGND VPWR VPWR sky130_fd_sc_hd__fill_1
Xhold2660 _6865_/Q VGND VGND VPWR VPWR _4741_/A0 sky130_fd_sc_hd__dlygate4sd3_1
Xhold2671 _6957_/Q VGND VGND VPWR VPWR _4975_/A0 sky130_fd_sc_hd__dlygate4sd3_1
Xhold2682 _7251_/Q VGND VGND VPWR VPWR _5644_/A0 sky130_fd_sc_hd__dlygate4sd3_1
Xhold2693 _6860_/Q VGND VGND VPWR VPWR _4702_/A0 sky130_fd_sc_hd__dlygate4sd3_1
XTAP_TAPCELL_ROW_89_1157 VGND VPWR sky130_fd_sc_hd__tapvpwrvgnd_1
XFILLER_16_312 VGND VGND VPWR VPWR sky130_fd_sc_hd__fill_1
XFILLER_28_161 VGND VGND VPWR VPWR sky130_fd_sc_hd__decap_3
XFILLER_56_492 VGND VGND VPWR VPWR sky130_fd_sc_hd__decap_3
XPHY_EDGE_ROW_11_Left_115 VGND VGND VPWR VPWR sky130_fd_sc_hd__decap_3
XFILLER_28_194 VGND VGND VPWR VPWR sky130_fd_sc_hd__fill_2
XFILLER_43_175 VGND VGND VPWR VPWR sky130_fd_sc_hd__fill_2
XFILLER_31_337 VGND VGND VPWR VPWR sky130_fd_sc_hd__decap_3
XFILLER_31_359 VGND VGND VPWR VPWR sky130_fd_sc_hd__decap_3
XPHY_EDGE_ROW_20_Left_124 VGND VGND VPWR VPWR sky130_fd_sc_hd__decap_3
XANTENNA_5 _4595_/X VGND VGND VPWR VPWR sky130_fd_sc_hd__diode_2
XFILLER_6_56 VGND VGND VPWR VPWR sky130_fd_sc_hd__decap_3
XFILLER_3_271 VGND VGND VPWR VPWR sky130_fd_sc_hd__decap_3
XFILLER_13_3 VGND VGND VPWR VPWR sky130_fd_sc_hd__decap_3
XFILLER_66_223 VGND VGND VPWR VPWR sky130_fd_sc_hd__fill_1
XFILLER_94_521 VGND VGND VPWR VPWR sky130_fd_sc_hd__fill_1
XFILLER_66_278 VGND VGND VPWR VPWR sky130_fd_sc_hd__decap_3
XTAP_TAPCELL_ROW_65_903 VGND VPWR sky130_fd_sc_hd__tapvpwrvgnd_1
XFILLER_19_172 VGND VGND VPWR VPWR sky130_fd_sc_hd__decap_3
XFILLER_47_492 VGND VGND VPWR VPWR sky130_fd_sc_hd__fill_2
XFILLER_54_429 VGND VGND VPWR VPWR sky130_fd_sc_hd__decap_3
X_6930_ _7275_/CLK _6930_/D VGND VGND VPWR VPWR _6930_/Q sky130_fd_sc_hd__dfxtp_2
XTAP_TAPCELL_ROW_37_616 VGND VPWR sky130_fd_sc_hd__tapvpwrvgnd_1
X_6861_ _7114_/CLK _6861_/D VGND VGND VPWR VPWR _6861_/Q sky130_fd_sc_hd__dfxtp_2
XFILLER_22_304 VGND VGND VPWR VPWR sky130_fd_sc_hd__decap_3
XFILLER_34_164 VGND VGND VPWR VPWR sky130_fd_sc_hd__decap_3
X_5812_ _7081_/Q _6401_/A1 _6146_/B1 _7109_/Q _5811_/X VGND VGND VPWR VPWR _5813_/B
+ sky130_fd_sc_hd__o221a_2
XFILLER_22_326 VGND VGND VPWR VPWR sky130_fd_sc_hd__decap_3
XTAP_TAPCELL_ROW_73_991 VGND VPWR sky130_fd_sc_hd__tapvpwrvgnd_1
XTAP_TAPCELL_ROW_45_693 VGND VPWR sky130_fd_sc_hd__tapvpwrvgnd_1
X_7413_ _7509_/CLK _7413_/D place2069/A VGND VGND VPWR VPWR _7413_/Q sky130_fd_sc_hd__dfrtp_2
X_4625_ _6318_/B2 _6178_/A1 _5839_/B1 _4624_/X VGND VGND VPWR VPWR _4625_/X sky130_fd_sc_hd__a31o_2
Xplace1210 _4838_/S VGND VGND VPWR VPWR _4808_/S sky130_fd_sc_hd__buf_2
X_7344_ _7575_/CLK _7344_/D place2012/X VGND VGND VPWR VPWR _7344_/Q sky130_fd_sc_hd__dfrtp_2
X_4556_ _6771_/A1 _4550_/S _4554_/X _4555_/X VGND VGND VPWR VPWR _7319_/D sky130_fd_sc_hd__a22o_2
Xplace1221 _4149_/X VGND VGND VPWR VPWR _4163_/A3 sky130_fd_sc_hd__buf_2
Xplace1232 _5547_/S VGND VGND VPWR VPWR _5513_/S sky130_fd_sc_hd__buf_2
Xplace1243 _4125_/Y VGND VGND VPWR VPWR _6465_/D sky130_fd_sc_hd__buf_2
X_3507_ _3459_/A _3460_/A _3499_/A _3430_/Y VGND VGND VPWR VPWR _3509_/C sky130_fd_sc_hd__o22ai_2
XTAP_TAPCELL_ROW_9_319 VGND VPWR sky130_fd_sc_hd__tapvpwrvgnd_1
Xplace1254 _4158_/Y VGND VGND VPWR VPWR _4163_/A2 sky130_fd_sc_hd__buf_2
Xplace1265 _6502_/B1 VGND VGND VPWR VPWR _6510_/A1 sky130_fd_sc_hd__buf_2
Xplace1276 place1277/X VGND VGND VPWR VPWR _6451_/B1 sky130_fd_sc_hd__buf_4
X_7275_ _7275_/CLK _7275_/D VGND VGND VPWR VPWR _7275_/Q sky130_fd_sc_hd__dfxtp_2
XFILLER_103_158 VGND VGND VPWR VPWR sky130_fd_sc_hd__fill_2
Xplace1287 _6455_/B2 VGND VGND VPWR VPWR _6393_/B2 sky130_fd_sc_hd__buf_2
Xplace1298 _4209_/X VGND VGND VPWR VPWR _4216_/A1 sky130_fd_sc_hd__buf_2
X_6226_ _6010_/A _6010_/B _6010_/C _6226_/B1 VGND VGND VPWR VPWR _6226_/X sky130_fd_sc_hd__a31o_2
X_3438_ _3435_/Y _3436_/Y _3508_/C _3437_/X VGND VGND VPWR VPWR _3519_/A sky130_fd_sc_hd__a31o_4
XFILLER_103_169 VGND VGND VPWR VPWR sky130_fd_sc_hd__decap_3
X_6157_ _6150_/X _6153_/X _6156_/X _6547_/A1 VGND VGND VPWR VPWR _6157_/X sky130_fd_sc_hd__a31o_2
XFILLER_57_212 VGND VGND VPWR VPWR sky130_fd_sc_hd__fill_1
X_5108_ _5108_/A0 _5686_/A1 _5118_/S VGND VGND VPWR VPWR _7018_/D sky130_fd_sc_hd__mux2_2
X_6088_ _6088_/A _6183_/C _5820_/X VGND VGND VPWR VPWR _6088_/X sky130_fd_sc_hd__or3b_2
XFILLER_26_610 VGND VGND VPWR VPWR sky130_fd_sc_hd__fill_2
XFILLER_53_484 VGND VGND VPWR VPWR sky130_fd_sc_hd__fill_1
XFILLER_13_337 VGND VGND VPWR VPWR sky130_fd_sc_hd__fill_1
XFILLER_25_186 VGND VGND VPWR VPWR sky130_fd_sc_hd__decap_3
XFILLER_15_87 VGND VGND VPWR VPWR sky130_fd_sc_hd__decap_3
XFILLER_21_381 VGND VGND VPWR VPWR sky130_fd_sc_hd__decap_3
XFILLER_31_53 VGND VGND VPWR VPWR sky130_fd_sc_hd__decap_3
XFILLER_31_97 VGND VGND VPWR VPWR sky130_fd_sc_hd__decap_3
XFILLER_36_418 VGND VGND VPWR VPWR sky130_fd_sc_hd__fill_2
XFILLER_48_245 VGND VGND VPWR VPWR sky130_fd_sc_hd__decap_3
XFILLER_48_256 VGND VGND VPWR VPWR sky130_fd_sc_hd__decap_3
Xhold2490 _7126_/Q VGND VGND VPWR VPWR _5372_/A0 sky130_fd_sc_hd__dlygate4sd3_1
XFILLER_36_429 VGND VGND VPWR VPWR sky130_fd_sc_hd__fill_2
XFILLER_56_61 VGND VGND VPWR VPWR sky130_fd_sc_hd__fill_2
XFILLER_91_557 VGND VGND VPWR VPWR sky130_fd_sc_hd__decap_3
XFILLER_16_175 VGND VGND VPWR VPWR sky130_fd_sc_hd__decap_3
XFILLER_44_473 VGND VGND VPWR VPWR sky130_fd_sc_hd__decap_3
XFILLER_16_197 VGND VGND VPWR VPWR sky130_fd_sc_hd__decap_3
XFILLER_71_281 VGND VGND VPWR VPWR sky130_fd_sc_hd__decap_3
XFILLER_31_145 VGND VGND VPWR VPWR sky130_fd_sc_hd__decap_3
XFILLER_72_93 VGND VGND VPWR VPWR sky130_fd_sc_hd__decap_3
XTAP_TAPCELL_ROW_70_961 VGND VPWR sky130_fd_sc_hd__tapvpwrvgnd_1
XTAP_TAPCELL_ROW_42_663 VGND VPWR sky130_fd_sc_hd__tapvpwrvgnd_1
XTAP_TAPCELL_ROW_14_365 VGND VPWR sky130_fd_sc_hd__tapvpwrvgnd_1
X_4410_ _4437_/B1 _4420_/B _4407_/X _4409_/Y VGND VGND VPWR VPWR _4410_/X sky130_fd_sc_hd__o31a_2
X_4341_ _6231_/A2 _4340_/Y _6231_/A1 VGND VGND VPWR VPWR _4341_/X sky130_fd_sc_hd__o21a_2
X_7060_ _7235_/CLK _7060_/D VGND VGND VPWR VPWR _7060_/Q sky130_fd_sc_hd__dfxtp_2
X_4272_ _4297_/A _4272_/A2 _4272_/A3 _4261_/X VGND VGND VPWR VPWR _4273_/A sky130_fd_sc_hd__o31a_2
X_6011_ _6011_/A _6011_/B _6011_/C _6011_/D VGND VGND VPWR VPWR _6011_/Y sky130_fd_sc_hd__nand4_4
XFILLER_39_234 VGND VGND VPWR VPWR sky130_fd_sc_hd__decap_3
XFILLER_39_267 VGND VGND VPWR VPWR sky130_fd_sc_hd__decap_3
XFILLER_54_215 VGND VGND VPWR VPWR sky130_fd_sc_hd__decap_3
XFILLER_54_237 VGND VGND VPWR VPWR sky130_fd_sc_hd__decap_3
X_6913_ _7282_/CLK _6913_/D VGND VGND VPWR VPWR _6913_/Q sky130_fd_sc_hd__dfxtp_2
XFILLER_35_462 VGND VGND VPWR VPWR sky130_fd_sc_hd__decap_3
XFILLER_22_134 VGND VGND VPWR VPWR sky130_fd_sc_hd__decap_3
XFILLER_50_421 VGND VGND VPWR VPWR sky130_fd_sc_hd__decap_3
X_6844_ _7276_/CLK _6844_/D VGND VGND VPWR VPWR _6844_/Q sky130_fd_sc_hd__dfxtp_2
XFILLER_22_167 VGND VGND VPWR VPWR sky130_fd_sc_hd__decap_3
X_6775_ _6229_/X _7547_/Q _6775_/S VGND VGND VPWR VPWR _7547_/D sky130_fd_sc_hd__mux2_2
X_3987_ _4393_/D _4393_/C _4393_/B VGND VGND VPWR VPWR _3987_/Y sky130_fd_sc_hd__nand3_4
XFILLER_10_318 VGND VGND VPWR VPWR sky130_fd_sc_hd__decap_3
X_5726_ _5726_/A0 _5726_/A1 _5728_/S VGND VGND VPWR VPWR _7289_/D sky130_fd_sc_hd__mux2_2
X_5657_ _5657_/A0 _5718_/A1 _5669_/S VGND VGND VPWR VPWR _7257_/D sky130_fd_sc_hd__mux2_2
X_4608_ _4608_/A1 _4608_/A2 _4608_/B1 VGND VGND VPWR VPWR _4637_/B sky130_fd_sc_hd__a21o_2
XTAP_TAPCELL_ROW_75_1009 VGND VPWR sky130_fd_sc_hd__tapvpwrvgnd_1
XFILLER_2_539 VGND VGND VPWR VPWR sky130_fd_sc_hd__decap_3
X_7327_ _7581_/CLK _7327_/D place2023/X VGND VGND VPWR VPWR _7327_/Q sky130_fd_sc_hd__dfrtp_2
X_4539_ _4538_/X _6765_/A1 _4539_/S VGND VGND VPWR VPWR _7316_/D sky130_fd_sc_hd__mux2_2
Xplace1084 _4285_/C VGND VGND VPWR VPWR _6564_/A sky130_fd_sc_hd__buf_2
X_7258_ _7288_/CLK _7258_/D VGND VGND VPWR VPWR _7258_/Q sky130_fd_sc_hd__dfxtp_2
Xplace1095 _4693_/X VGND VGND VPWR VPWR _5188_/A1 sky130_fd_sc_hd__buf_2
X_6209_ _6399_/A1 _6923_/Q _7259_/Q _6393_/B2 VGND VGND VPWR VPWR _6209_/X sky130_fd_sc_hd__o22a_2
X_7189_ _7217_/CLK _7189_/D VGND VGND VPWR VPWR _7189_/Q sky130_fd_sc_hd__dfxtp_2
XFILLER_18_407 VGND VGND VPWR VPWR sky130_fd_sc_hd__fill_1
XFILLER_45_215 VGND VGND VPWR VPWR sky130_fd_sc_hd__fill_1
XTAP_TAPCELL_ROW_86_1127 VGND VPWR sky130_fd_sc_hd__tapvpwrvgnd_1
XFILLER_26_42 VGND VGND VPWR VPWR sky130_fd_sc_hd__decap_3
XFILLER_26_440 VGND VGND VPWR VPWR sky130_fd_sc_hd__decap_3
XFILLER_45_237 VGND VGND VPWR VPWR sky130_fd_sc_hd__decap_3
XFILLER_26_462 VGND VGND VPWR VPWR sky130_fd_sc_hd__fill_1
XFILLER_60_218 VGND VGND VPWR VPWR sky130_fd_sc_hd__fill_1
Xclkbuf_3_6__f_clk clkbuf_0_clk/X VGND VGND VPWR VPWR clkbuf_3_6__f_clk/X sky130_fd_sc_hd__clkbuf_8
XFILLER_13_123 VGND VGND VPWR VPWR sky130_fd_sc_hd__fill_2
XFILLER_26_495 VGND VGND VPWR VPWR sky130_fd_sc_hd__decap_3
XFILLER_53_281 VGND VGND VPWR VPWR sky130_fd_sc_hd__decap_3
XFILLER_13_145 VGND VGND VPWR VPWR sky130_fd_sc_hd__decap_3
XFILLER_9_116 VGND VGND VPWR VPWR sky130_fd_sc_hd__decap_3
XFILLER_13_189 VGND VGND VPWR VPWR sky130_fd_sc_hd__decap_3
XFILLER_41_498 VGND VGND VPWR VPWR sky130_fd_sc_hd__decap_3
XFILLER_42_52 VGND VGND VPWR VPWR sky130_fd_sc_hd__decap_3
XFILLER_9_138 VGND VGND VPWR VPWR sky130_fd_sc_hd__fill_2
XFILLER_42_85 VGND VGND VPWR VPWR sky130_fd_sc_hd__decap_3
XTAP_TAPCELL_ROW_11_335 VGND VPWR sky130_fd_sc_hd__tapvpwrvgnd_1
XFILLER_5_311 VGND VGND VPWR VPWR sky130_fd_sc_hd__decap_3
XTAP_TAPCELL_ROW_97_1245 VGND VPWR sky130_fd_sc_hd__tapvpwrvgnd_1
XFILLER_5_366 VGND VGND VPWR VPWR sky130_fd_sc_hd__decap_3
XFILLER_1_561 VGND VGND VPWR VPWR sky130_fd_sc_hd__decap_3
XFILLER_67_60 VGND VGND VPWR VPWR sky130_fd_sc_hd__fill_1
XFILLER_36_215 VGND VGND VPWR VPWR sky130_fd_sc_hd__decap_3
XTAP_TAPCELL_ROW_19_424 VGND VPWR sky130_fd_sc_hd__tapvpwrvgnd_1
XFILLER_17_473 VGND VGND VPWR VPWR sky130_fd_sc_hd__fill_1
XFILLER_64_579 VGND VGND VPWR VPWR sky130_fd_sc_hd__fill_1
XFILLER_17_484 VGND VGND VPWR VPWR sky130_fd_sc_hd__decap_3
XFILLER_17_495 VGND VGND VPWR VPWR sky130_fd_sc_hd__fill_1
XFILLER_32_421 VGND VGND VPWR VPWR sky130_fd_sc_hd__fill_1
X_4890_ _4890_/A0 _5718_/A1 _4900_/S VGND VGND VPWR VPWR _6921_/D sky130_fd_sc_hd__mux2_2
X_3910_ _3910_/A _3910_/B VGND VGND VPWR VPWR _3910_/Y sky130_fd_sc_hd__nand2_2
XFILLER_32_454 VGND VGND VPWR VPWR sky130_fd_sc_hd__decap_3
XFILLER_32_498 VGND VGND VPWR VPWR sky130_fd_sc_hd__fill_1
X_6560_ _7608_/Q _6560_/B VGND VGND VPWR VPWR _6560_/Y sky130_fd_sc_hd__nor2_2
X_3772_ _7313_/Q _4211_/A VGND VGND VPWR VPWR _3773_/B sky130_fd_sc_hd__nand2_2
X_5511_ _5511_/A0 _5572_/A1 _5513_/S VGND VGND VPWR VPWR _7190_/D sky130_fd_sc_hd__mux2_2
XFILLER_8_171 VGND VGND VPWR VPWR sky130_fd_sc_hd__fill_2
XFILLER_8_193 VGND VGND VPWR VPWR sky130_fd_sc_hd__decap_3
X_5442_ _5442_/A0 _5564_/A1 _5452_/S VGND VGND VPWR VPWR _7158_/D sky130_fd_sc_hd__mux2_2
X_7112_ _7280_/CLK _7112_/D VGND VGND VPWR VPWR _7112_/Q sky130_fd_sc_hd__dfxtp_2
X_4324_ _4324_/A _4324_/B VGND VGND VPWR VPWR _4324_/X sky130_fd_sc_hd__xor2_2
XFILLER_101_415 VGND VGND VPWR VPWR sky130_fd_sc_hd__decap_3
Xfanout106 instruct_en VGND VGND VPWR VPWR _3481_/A sky130_fd_sc_hd__clkdlybuf4s25_1
X_7043_ _7275_/CLK _7043_/D VGND VGND VPWR VPWR _7043_/Q sky130_fd_sc_hd__dfxtp_2
X_4255_ _4241_/Y _4239_/Y _4254_/Y VGND VGND VPWR VPWR _4255_/Y sky130_fd_sc_hd__o21bai_4
XFILLER_67_340 VGND VGND VPWR VPWR sky130_fd_sc_hd__decap_3
X_4186_ _4185_/B _4186_/A2 _4185_/A VGND VGND VPWR VPWR _4186_/Y sky130_fd_sc_hd__o21ai_2
XFILLER_27_215 VGND VGND VPWR VPWR sky130_fd_sc_hd__decap_3
XFILLER_55_502 VGND VGND VPWR VPWR sky130_fd_sc_hd__fill_2
XFILLER_55_524 VGND VGND VPWR VPWR sky130_fd_sc_hd__fill_2
XFILLER_82_321 VGND VGND VPWR VPWR sky130_fd_sc_hd__decap_3
XFILLER_42_218 VGND VGND VPWR VPWR sky130_fd_sc_hd__fill_1
XFILLER_70_505 VGND VGND VPWR VPWR sky130_fd_sc_hd__decap_3
XFILLER_82_365 VGND VGND VPWR VPWR sky130_fd_sc_hd__decap_3
XFILLER_35_281 VGND VGND VPWR VPWR sky130_fd_sc_hd__decap_3
XFILLER_23_443 VGND VGND VPWR VPWR sky130_fd_sc_hd__decap_3
XFILLER_10_115 VGND VGND VPWR VPWR sky130_fd_sc_hd__decap_3
XFILLER_10_126 VGND VGND VPWR VPWR sky130_fd_sc_hd__decap_3
XFILLER_10_148 VGND VGND VPWR VPWR sky130_fd_sc_hd__decap_3
XFILLER_50_295 VGND VGND VPWR VPWR sky130_fd_sc_hd__decap_3
XFILLER_12_44 VGND VGND VPWR VPWR sky130_fd_sc_hd__decap_3
XFILLER_6_119 VGND VGND VPWR VPWR sky130_fd_sc_hd__decap_3
X_6689_ _6689_/A0 _6181_/X _6698_/S VGND VGND VPWR VPWR _7506_/D sky130_fd_sc_hd__mux2_4
X_5709_ _5709_/A0 _5709_/A1 _5711_/S VGND VGND VPWR VPWR _7281_/D sky130_fd_sc_hd__mux2_2
XFILLER_12_88 VGND VGND VPWR VPWR sky130_fd_sc_hd__decap_3
XTAP_TAPCELL_ROW_92_1186 VGND VPWR sky130_fd_sc_hd__tapvpwrvgnd_1
XFILLER_92_118 VGND VGND VPWR VPWR sky130_fd_sc_hd__fill_1
XFILLER_37_63 VGND VGND VPWR VPWR sky130_fd_sc_hd__fill_1
XFILLER_33_218 VGND VGND VPWR VPWR sky130_fd_sc_hd__decap_3
XFILLER_37_96 VGND VGND VPWR VPWR sky130_fd_sc_hd__decap_3
XFILLER_73_354 VGND VGND VPWR VPWR sky130_fd_sc_hd__fill_1
XFILLER_53_51 VGND VGND VPWR VPWR sky130_fd_sc_hd__decap_3
XFILLER_41_273 VGND VGND VPWR VPWR sky130_fd_sc_hd__decap_3
XFILLER_41_284 VGND VGND VPWR VPWR sky130_fd_sc_hd__decap_3
XFILLER_53_95 VGND VGND VPWR VPWR sky130_fd_sc_hd__fill_1
XTAP_TAPCELL_ROW_24_471 VGND VPWR sky130_fd_sc_hd__tapvpwrvgnd_1
XTAP_TAPCELL_ROW_101_1282 VGND VPWR sky130_fd_sc_hd__tapvpwrvgnd_1
Xplace1809 _3598_/B VGND VGND VPWR VPWR _3545_/C sky130_fd_sc_hd__buf_2
XFILLER_5_141 VGND VGND VPWR VPWR sky130_fd_sc_hd__decap_3
XFILLER_96_424 VGND VGND VPWR VPWR sky130_fd_sc_hd__fill_1
XFILLER_49_340 VGND VGND VPWR VPWR sky130_fd_sc_hd__fill_2
XPHY_EDGE_ROW_3_Left_107 VGND VGND VPWR VPWR sky130_fd_sc_hd__decap_3
X_4040_ _7301_/Q _7302_/Q _4043_/D VGND VGND VPWR VPWR _4044_/B sky130_fd_sc_hd__and3_2
X_5991_ _6504_/A2 _7080_/Q _6856_/Q _5991_/B2 VGND VGND VPWR VPWR _5991_/X sky130_fd_sc_hd__o22a_2
XFILLER_17_281 VGND VGND VPWR VPWR sky130_fd_sc_hd__decap_3
XFILLER_52_549 VGND VGND VPWR VPWR sky130_fd_sc_hd__fill_1
XFILLER_20_424 VGND VGND VPWR VPWR sky130_fd_sc_hd__decap_3
XFILLER_32_251 VGND VGND VPWR VPWR sky130_fd_sc_hd__fill_1
XFILLER_32_262 VGND VGND VPWR VPWR sky130_fd_sc_hd__decap_3
XFILLER_60_593 VGND VGND VPWR VPWR sky130_fd_sc_hd__fill_1
X_4873_ _4873_/A0 _5701_/A1 _4896_/S VGND VGND VPWR VPWR _6913_/D sky130_fd_sc_hd__mux2_2
X_7592_ _7611_/CLK _7592_/D place2060/X VGND VGND VPWR VPWR _7592_/Q sky130_fd_sc_hd__dfrtp_2
X_3824_ _7405_/Q _3855_/A2 _3823_/X VGND VGND VPWR VPWR _3832_/B sky130_fd_sc_hd__a21oi_2
X_3755_ _7442_/Q _3793_/A2 _3816_/B1 _7346_/Q _3754_/X VGND VGND VPWR VPWR _3755_/X
+ sky130_fd_sc_hd__a221o_2
X_6474_ _6484_/A2 _6987_/Q _6959_/Q _6480_/B2 VGND VGND VPWR VPWR _6475_/B sky130_fd_sc_hd__o22a_2
X_3686_ _3780_/A1 _3815_/A2 _7387_/Q _3815_/B1 _7579_/Q VGND VGND VPWR VPWR _3686_/X
+ sky130_fd_sc_hd__a32o_2
XPHY_EDGE_ROW_12_Right_12 VGND VGND VPWR VPWR sky130_fd_sc_hd__decap_3
X_5425_ _5425_/A0 _5608_/A1 _5425_/S VGND VGND VPWR VPWR _7151_/D sky130_fd_sc_hd__mux2_2
X_5287_ _5287_/A0 _5353_/A1 _5293_/S VGND VGND VPWR VPWR _7090_/D sky130_fd_sc_hd__mux2_2
XFILLER_87_457 VGND VGND VPWR VPWR sky130_fd_sc_hd__fill_1
X_7026_ _7279_/CLK _7026_/D VGND VGND VPWR VPWR _7026_/Q sky130_fd_sc_hd__dfxtp_2
X_4238_ _4238_/A _4238_/B _4238_/C VGND VGND VPWR VPWR _4238_/X sky130_fd_sc_hd__or3_4
XFILLER_55_310 VGND VGND VPWR VPWR sky130_fd_sc_hd__decap_3
XTAP_TAPCELL_ROW_58_828 VGND VPWR sky130_fd_sc_hd__tapvpwrvgnd_1
XFILLER_28_557 VGND VGND VPWR VPWR sky130_fd_sc_hd__decap_3
X_4169_ _4157_/B _4158_/Y _3916_/Y VGND VGND VPWR VPWR _4169_/Y sky130_fd_sc_hd__o21bai_2
XPHY_EDGE_ROW_21_Right_21 VGND VGND VPWR VPWR sky130_fd_sc_hd__decap_3
XFILLER_70_324 VGND VGND VPWR VPWR sky130_fd_sc_hd__decap_3
XFILLER_82_173 VGND VGND VPWR VPWR sky130_fd_sc_hd__fill_1
XFILLER_23_240 VGND VGND VPWR VPWR sky130_fd_sc_hd__decap_3
XFILLER_23_21 VGND VGND VPWR VPWR sky130_fd_sc_hd__fill_2
XFILLER_23_65 VGND VGND VPWR VPWR sky130_fd_sc_hd__decap_3
XTAP_TAPCELL_ROW_21_441 VGND VPWR sky130_fd_sc_hd__tapvpwrvgnd_1
XPHY_EDGE_ROW_30_Right_30 VGND VGND VPWR VPWR sky130_fd_sc_hd__decap_3
XTAP_TAPCELL_ROW_94_1215 VGND VPWR sky130_fd_sc_hd__tapvpwrvgnd_1
XFILLER_78_457 VGND VGND VPWR VPWR sky130_fd_sc_hd__fill_1
XFILLER_65_107 VGND VGND VPWR VPWR sky130_fd_sc_hd__fill_1
XFILLER_46_343 VGND VGND VPWR VPWR sky130_fd_sc_hd__decap_3
XTAP_TAPCELL_ROW_29_530 VGND VPWR sky130_fd_sc_hd__tapvpwrvgnd_1
XFILLER_0_69 VGND VGND VPWR VPWR sky130_fd_sc_hd__decap_3
XFILLER_19_568 VGND VGND VPWR VPWR sky130_fd_sc_hd__fill_1
XFILLER_34_527 VGND VGND VPWR VPWR sky130_fd_sc_hd__decap_3
XFILLER_46_398 VGND VGND VPWR VPWR sky130_fd_sc_hd__fill_1
XTAP_TAPCELL_ROW_103_1300 VGND VPWR sky130_fd_sc_hd__tapvpwrvgnd_1
XPHY_EDGE_ROW_85_Left_189 VGND VGND VPWR VPWR sky130_fd_sc_hd__decap_3
XTAP_TAPCELL_ROW_103_1311 VGND VPWR sky130_fd_sc_hd__tapvpwrvgnd_1
XFILLER_14_251 VGND VGND VPWR VPWR sky130_fd_sc_hd__fill_1
XFILLER_9_67 VGND VGND VPWR VPWR sky130_fd_sc_hd__fill_1
XFILLER_9_78 VGND VGND VPWR VPWR sky130_fd_sc_hd__fill_1
XFILLER_80_93 VGND VGND VPWR VPWR sky130_fd_sc_hd__fill_2
Xplace1606 _4225_/A1 VGND VGND VPWR VPWR _4261_/A sky130_fd_sc_hd__buf_2
Xplace1617 _6518_/S VGND VGND VPWR VPWR _6497_/S sky130_fd_sc_hd__buf_2
XFILLER_6_483 VGND VGND VPWR VPWR sky130_fd_sc_hd__decap_3
Xplace1628 _3858_/B1 VGND VGND VPWR VPWR _3907_/A2 sky130_fd_sc_hd__buf_2
Xplace1639 _3598_/X VGND VGND VPWR VPWR _3923_/B1 sky130_fd_sc_hd__buf_4
X_3471_ _3499_/A _4352_/B _3471_/C _3471_/D VGND VGND VPWR VPWR _3478_/B sky130_fd_sc_hd__nand4b_2
XPHY_EDGE_ROW_94_Left_198 VGND VGND VPWR VPWR sky130_fd_sc_hd__decap_3
XFILLER_43_3 VGND VGND VPWR VPWR sky130_fd_sc_hd__decap_3
Xhold3009 _6322_/X VGND VGND VPWR VPWR _7369_/D sky130_fd_sc_hd__dlygate4sd3_1
X_6190_ _7090_/Q _6394_/A1 _6399_/A1 _7118_/Q _6189_/X VGND VGND VPWR VPWR _6190_/X
+ sky130_fd_sc_hd__o221a_2
XFILLER_96_221 VGND VGND VPWR VPWR sky130_fd_sc_hd__fill_1
X_5072_ _5072_/A0 _5344_/A1 _5085_/S VGND VGND VPWR VPWR _7002_/D sky130_fd_sc_hd__mux2_2
XFILLER_56_129 VGND VGND VPWR VPWR sky130_fd_sc_hd__decap_3
X_4023_ _4023_/A _4023_/B VGND VGND VPWR VPWR _7584_/D sky130_fd_sc_hd__or2_2
XFILLER_37_332 VGND VGND VPWR VPWR sky130_fd_sc_hd__decap_3
XFILLER_25_505 VGND VGND VPWR VPWR sky130_fd_sc_hd__decap_3
XFILLER_25_538 VGND VGND VPWR VPWR sky130_fd_sc_hd__fill_1
X_5974_ _5972_/Y _5973_/Y _5093_/C VGND VGND VPWR VPWR _5978_/A sky130_fd_sc_hd__o21ai_2
XFILLER_40_519 VGND VGND VPWR VPWR sky130_fd_sc_hd__fill_1
XTAP_TAPCELL_ROW_63_886 VGND VPWR sky130_fd_sc_hd__tapvpwrvgnd_1
XTAP_TAPCELL_ROW_35_588 VGND VPWR sky130_fd_sc_hd__tapvpwrvgnd_1
XFILLER_20_221 VGND VGND VPWR VPWR sky130_fd_sc_hd__fill_2
X_4856_ _4856_/A0 _5317_/A1 _4870_/S VGND VGND VPWR VPWR _6905_/D sky130_fd_sc_hd__mux2_2
X_7575_ _7575_/CLK _7575_/D place2013/X VGND VGND VPWR VPWR _7575_/Q sky130_fd_sc_hd__dfrtp_2
X_3807_ _4211_/A _4184_/B _3807_/C _3807_/D VGND VGND VPWR VPWR _3809_/A sky130_fd_sc_hd__or4_4
X_4787_ _4787_/A0 _5677_/A1 _4806_/S VGND VGND VPWR VPWR _6874_/D sky130_fd_sc_hd__mux2_2
X_3738_ _3738_/A _3738_/B _3738_/C VGND VGND VPWR VPWR _3738_/X sky130_fd_sc_hd__or3_4
X_6457_ _6455_/X _6456_/X _6457_/B1 _6457_/C1 VGND VGND VPWR VPWR _6457_/X sky130_fd_sc_hd__a211o_2
X_3669_ _4237_/A _3738_/B _3669_/A3 _3665_/Y _3668_/Y VGND VGND VPWR VPWR _4274_/A
+ sky130_fd_sc_hd__o41a_4
X_6388_ _6698_/A0 _6411_/A2 _6388_/A3 _6410_/B1 _7414_/Q VGND VGND VPWR VPWR _6388_/X
+ sky130_fd_sc_hd__a32o_2
X_5408_ _5408_/A0 _5591_/A1 _5410_/S VGND VGND VPWR VPWR _7143_/D sky130_fd_sc_hd__mux2_2
Xhold2820 _7558_/Q VGND VGND VPWR VPWR _6800_/B sky130_fd_sc_hd__dlygate4sd3_1
Xhold2831 _6309_/X VGND VGND VPWR VPWR _7359_/D sky130_fd_sc_hd__dlygate4sd3_1
Xhold2842 _7570_/Q VGND VGND VPWR VPWR _6824_/B sky130_fd_sc_hd__dlygate4sd3_1
Xhold2853 _7576_/Q VGND VGND VPWR VPWR _6836_/B sky130_fd_sc_hd__dlygate4sd3_1
Xhold2864 _7553_/Q VGND VGND VPWR VPWR _6789_/B sky130_fd_sc_hd__dlygate4sd3_1
Xhold2875 _7370_/Q VGND VGND VPWR VPWR _6323_/B2 sky130_fd_sc_hd__dlygate4sd3_1
XFILLER_28_321 VGND VGND VPWR VPWR sky130_fd_sc_hd__fill_2
XFILLER_28_332 VGND VGND VPWR VPWR sky130_fd_sc_hd__decap_3
Xhold2886 _7548_/Q VGND VGND VPWR VPWR _6779_/B sky130_fd_sc_hd__dlygate4sd3_1
Xhold2897 _6345_/X VGND VGND VPWR VPWR _7386_/D sky130_fd_sc_hd__dlygate4sd3_1
X_7009_ _7287_/CLK _7009_/D VGND VGND VPWR VPWR _7009_/Q sky130_fd_sc_hd__dfxtp_2
XFILLER_18_76 VGND VGND VPWR VPWR sky130_fd_sc_hd__fill_2
XFILLER_83_460 VGND VGND VPWR VPWR sky130_fd_sc_hd__decap_3
XTAP_TAPCELL_ROW_26_500 VGND VPWR sky130_fd_sc_hd__tapvpwrvgnd_1
XFILLER_31_508 VGND VGND VPWR VPWR sky130_fd_sc_hd__decap_3
XFILLER_24_560 VGND VGND VPWR VPWR sky130_fd_sc_hd__fill_1
XFILLER_24_571 VGND VGND VPWR VPWR sky130_fd_sc_hd__decap_3
XFILLER_70_187 VGND VGND VPWR VPWR sky130_fd_sc_hd__decap_3
XFILLER_24_593 VGND VGND VPWR VPWR sky130_fd_sc_hd__fill_2
XFILLER_34_97 VGND VGND VPWR VPWR sky130_fd_sc_hd__decap_3
XFILLER_51_390 VGND VGND VPWR VPWR sky130_fd_sc_hd__fill_2
XFILLER_7_214 VGND VGND VPWR VPWR sky130_fd_sc_hd__fill_2
XFILLER_11_276 VGND VGND VPWR VPWR sky130_fd_sc_hd__decap_3
XFILLER_50_85 VGND VGND VPWR VPWR sky130_fd_sc_hd__fill_1
XFILLER_7_269 VGND VGND VPWR VPWR sky130_fd_sc_hd__decap_3
XFILLER_3_453 VGND VGND VPWR VPWR sky130_fd_sc_hd__fill_2
XFILLER_3_464 VGND VGND VPWR VPWR sky130_fd_sc_hd__decap_3
XFILLER_19_332 VGND VGND VPWR VPWR sky130_fd_sc_hd__decap_3
XTAP_TAPCELL_ROW_6_291 VGND VPWR sky130_fd_sc_hd__tapvpwrvgnd_1
XFILLER_19_343 VGND VGND VPWR VPWR sky130_fd_sc_hd__decap_3
XFILLER_19_376 VGND VGND VPWR VPWR sky130_fd_sc_hd__fill_1
XFILLER_34_324 VGND VGND VPWR VPWR sky130_fd_sc_hd__decap_3
XFILLER_34_368 VGND VGND VPWR VPWR sky130_fd_sc_hd__decap_3
XFILLER_46_195 VGND VGND VPWR VPWR sky130_fd_sc_hd__fill_1
XFILLER_61_143 VGND VGND VPWR VPWR sky130_fd_sc_hd__decap_3
X_5690_ _5690_/A0 _5690_/A1 _5696_/S VGND VGND VPWR VPWR _7272_/D sky130_fd_sc_hd__mux2_2
XTAP_TAPCELL_ROW_60_856 VGND VPWR sky130_fd_sc_hd__tapvpwrvgnd_1
XFILLER_30_574 VGND VGND VPWR VPWR sky130_fd_sc_hd__decap_3
X_4641_ _4641_/A1 _4735_/C _4639_/Y VGND VGND VPWR VPWR _4641_/Y sky130_fd_sc_hd__o21ai_2
XTAP_TAPCELL_ROW_32_558 VGND VPWR sky130_fd_sc_hd__tapvpwrvgnd_1
X_7360_ _7581_/CLK _7360_/D place2025/X VGND VGND VPWR VPWR _7360_/Q sky130_fd_sc_hd__dfrtp_2
X_4572_ _7321_/Q _4572_/B VGND VGND VPWR VPWR _4572_/Y sky130_fd_sc_hd__nand2_2
Xplace1403 _3833_/B VGND VGND VPWR VPWR _4202_/B sky130_fd_sc_hd__buf_2
Xplace1414 _3585_/A VGND VGND VPWR VPWR _4733_/B1 sky130_fd_sc_hd__buf_2
Xplace1425 _4296_/B VGND VGND VPWR VPWR _4295_/A2 sky130_fd_sc_hd__buf_2
X_7291_ _7291_/CLK _7291_/D VGND VGND VPWR VPWR _7291_/Q sky130_fd_sc_hd__dfxtp_2
X_6311_ _6311_/A1 _6313_/A2 _6313_/A3 _6313_/B1 _6311_/B2 VGND VGND VPWR VPWR _7361_/D
+ sky130_fd_sc_hd__a32o_2
X_3523_ _3520_/X _3521_/Y _3522_/X VGND VGND VPWR VPWR _3529_/A sky130_fd_sc_hd__o21bai_4
XFILLER_89_508 VGND VGND VPWR VPWR sky130_fd_sc_hd__fill_2
Xplace1436 _3970_/X VGND VGND VPWR VPWR _3973_/A sky130_fd_sc_hd__buf_2
Xplace1447 _3870_/Y VGND VGND VPWR VPWR _4654_/A1 sky130_fd_sc_hd__buf_2
Xplace1458 _3756_/Y VGND VGND VPWR VPWR _4719_/A1 sky130_fd_sc_hd__buf_2
Xplace1469 _3670_/C VGND VGND VPWR VPWR _4745_/A2 sky130_fd_sc_hd__buf_2
X_3454_ _3505_/A2 _3505_/A1 _3453_/X VGND VGND VPWR VPWR _3652_/A sky130_fd_sc_hd__a21oi_2
XFILLER_103_329 VGND VGND VPWR VPWR sky130_fd_sc_hd__decap_3
X_6173_ _6173_/A1 _6919_/Q _7255_/Q _6173_/B2 VGND VGND VPWR VPWR _6173_/X sky130_fd_sc_hd__o22a_2
XFILLER_57_427 VGND VGND VPWR VPWR sky130_fd_sc_hd__fill_1
XFILLER_69_254 VGND VGND VPWR VPWR sky130_fd_sc_hd__decap_3
XFILLER_69_276 VGND VGND VPWR VPWR sky130_fd_sc_hd__decap_3
XFILLER_69_287 VGND VGND VPWR VPWR sky130_fd_sc_hd__decap_3
XFILLER_57_438 VGND VGND VPWR VPWR sky130_fd_sc_hd__fill_1
XFILLER_57_449 VGND VGND VPWR VPWR sky130_fd_sc_hd__decap_3
X_5055_ _5055_/A0 _4656_/X _5057_/S VGND VGND VPWR VPWR _6994_/D sky130_fd_sc_hd__mux2_2
XTAP_TAPCELL_ROW_68_934 VGND VPWR sky130_fd_sc_hd__tapvpwrvgnd_1
X_4006_ _4012_/A1 _4005_/X _3940_/X VGND VGND VPWR VPWR _4010_/A sky130_fd_sc_hd__o21ai_2
XFILLER_80_430 VGND VGND VPWR VPWR sky130_fd_sc_hd__fill_2
XFILLER_25_368 VGND VGND VPWR VPWR sky130_fd_sc_hd__decap_3
XFILLER_25_379 VGND VGND VPWR VPWR sky130_fd_sc_hd__decap_3
XFILLER_52_176 VGND VGND VPWR VPWR sky130_fd_sc_hd__decap_3
X_5957_ _7184_/Q _6477_/A2 _7212_/Q _5960_/B2 VGND VGND VPWR VPWR _5957_/X sky130_fd_sc_hd__o22a_2
XFILLER_33_390 VGND VGND VPWR VPWR sky130_fd_sc_hd__fill_2
XFILLER_21_552 VGND VGND VPWR VPWR sky130_fd_sc_hd__decap_3
X_5888_ _6897_/Q _6204_/A2 _6925_/Q _6455_/A1 VGND VGND VPWR VPWR _5888_/X sky130_fd_sc_hd__o22a_2
X_7558_ clkload9/A _7558_/D place2033/X VGND VGND VPWR VPWR _7558_/Q sky130_fd_sc_hd__dfrtp_2
X_7489_ _7581_/CLK _7489_/D place2025/X VGND VGND VPWR VPWR _7489_/Q sky130_fd_sc_hd__dfrtp_2
X_6509_ _6507_/X _6508_/X _6509_/B1 _6512_/C1 VGND VGND VPWR VPWR _6509_/X sky130_fd_sc_hd__a211o_2
Xplace1981 _3443_/C VGND VGND VPWR VPWR _3573_/A2 sky130_fd_sc_hd__buf_2
Xplace1970 _7297_/Q VGND VGND VPWR VPWR _4361_/A sky130_fd_sc_hd__buf_2
XFILLER_0_445 VGND VGND VPWR VPWR sky130_fd_sc_hd__decap_3
Xplace1992 _7294_/Q VGND VGND VPWR VPWR _3491_/B sky130_fd_sc_hd__buf_2
XFILLER_0_467 VGND VGND VPWR VPWR sky130_fd_sc_hd__decap_3
XFILLER_0_489 VGND VGND VPWR VPWR sky130_fd_sc_hd__decap_3
XFILLER_48_427 VGND VGND VPWR VPWR sky130_fd_sc_hd__decap_3
XFILLER_29_86 VGND VGND VPWR VPWR sky130_fd_sc_hd__decap_3
Xhold2650 _7133_/Q VGND VGND VPWR VPWR _5387_/A0 sky130_fd_sc_hd__dlygate4sd3_1
Xhold2661 _7180_/Q VGND VGND VPWR VPWR _5490_/A0 sky130_fd_sc_hd__dlygate4sd3_1
Xhold2672 _7042_/Q VGND VGND VPWR VPWR _5160_/A0 sky130_fd_sc_hd__dlygate4sd3_1
Xhold2683 _7056_/Q VGND VGND VPWR VPWR _5190_/A0 sky130_fd_sc_hd__dlygate4sd3_1
XFILLER_63_419 VGND VGND VPWR VPWR sky130_fd_sc_hd__fill_2
Xhold2694 _7270_/Q VGND VGND VPWR VPWR _5686_/A0 sky130_fd_sc_hd__dlygate4sd3_1
XTAP_TAPCELL_ROW_89_1158 VGND VPWR sky130_fd_sc_hd__tapvpwrvgnd_1
XTAP_TAPCELL_ROW_3_250 VGND VPWR sky130_fd_sc_hd__tapvpwrvgnd_1
XFILLER_44_611 VGND VGND VPWR VPWR sky130_fd_sc_hd__fill_1
XFILLER_43_110 VGND VGND VPWR VPWR sky130_fd_sc_hd__fill_2
XFILLER_31_316 VGND VGND VPWR VPWR sky130_fd_sc_hd__decap_3
XFILLER_8_589 VGND VGND VPWR VPWR sky130_fd_sc_hd__decap_3
XANTENNA_6 _5789_/X VGND VGND VPWR VPWR sky130_fd_sc_hd__diode_2
XFILLER_94_500 VGND VGND VPWR VPWR sky130_fd_sc_hd__fill_1
XFILLER_39_449 VGND VGND VPWR VPWR sky130_fd_sc_hd__fill_2
XFILLER_86_70 VGND VGND VPWR VPWR sky130_fd_sc_hd__decap_3
XTAP_TAPCELL_ROW_65_904 VGND VPWR sky130_fd_sc_hd__tapvpwrvgnd_1
XFILLER_19_151 VGND VGND VPWR VPWR sky130_fd_sc_hd__decap_3
XFILLER_19_184 VGND VGND VPWR VPWR sky130_fd_sc_hd__decap_3
X_6860_ _7280_/CLK _6860_/D VGND VGND VPWR VPWR _6860_/Q sky130_fd_sc_hd__dfxtp_2
X_6791_ _6805_/A _6791_/B VGND VGND VPWR VPWR _7554_/D sky130_fd_sc_hd__and2_2
X_5811_ _5984_/B1 _7053_/Q _6857_/Q _6399_/B2 VGND VGND VPWR VPWR _5811_/X sky130_fd_sc_hd__o22a_2
XFILLER_34_187 VGND VGND VPWR VPWR sky130_fd_sc_hd__decap_3
XTAP_TAPCELL_ROW_73_992 VGND VPWR sky130_fd_sc_hd__tapvpwrvgnd_1
XTAP_TAPCELL_ROW_45_694 VGND VPWR sky130_fd_sc_hd__tapvpwrvgnd_1
XFILLER_30_360 VGND VGND VPWR VPWR sky130_fd_sc_hd__decap_3
XFILLER_30_371 VGND VGND VPWR VPWR sky130_fd_sc_hd__decap_3
X_5673_ _5673_/A0 _5673_/A1 _5698_/S VGND VGND VPWR VPWR _7264_/D sky130_fd_sc_hd__mux2_2
XPHY_EDGE_ROW_6_Right_6 VGND VGND VPWR VPWR sky130_fd_sc_hd__decap_3
X_7412_ _7509_/CLK _7412_/D place2069/A VGND VGND VPWR VPWR _7412_/Q sky130_fd_sc_hd__dfrtp_2
X_4624_ _4743_/A _4675_/B _6437_/B1 _4622_/Y _6226_/B1 VGND VGND VPWR VPWR _4624_/X
+ sky130_fd_sc_hd__o311a_2
Xplace1200 _4905_/X VGND VGND VPWR VPWR _4952_/S sky130_fd_sc_hd__buf_2
X_7343_ _7577_/CLK _7343_/D place2012/X VGND VGND VPWR VPWR _7343_/Q sky130_fd_sc_hd__dfrtp_2
X_4555_ _4533_/A _7609_/D _4533_/D _4571_/B1 VGND VGND VPWR VPWR _4555_/X sky130_fd_sc_hd__o31a_2
Xplace1211 _4771_/S VGND VGND VPWR VPWR _4759_/S sky130_fd_sc_hd__buf_2
Xplace1222 _4138_/Y VGND VGND VPWR VPWR _6495_/A1 sky130_fd_sc_hd__buf_4
Xplace1233 _5547_/S VGND VGND VPWR VPWR _5545_/S sky130_fd_sc_hd__buf_2
Xplace1244 _6506_/A2 VGND VGND VPWR VPWR _6482_/A2 sky130_fd_sc_hd__buf_2
Xplace1255 _4136_/Y VGND VGND VPWR VPWR _4138_/A2 sky130_fd_sc_hd__buf_2
Xplace1266 place1266/A VGND VGND VPWR VPWR _6502_/B1 sky130_fd_sc_hd__buf_2
Xplace1277 _5759_/Y VGND VGND VPWR VPWR place1277/X sky130_fd_sc_hd__buf_6
X_7274_ _7274_/CLK _7274_/D VGND VGND VPWR VPWR _7274_/Q sky130_fd_sc_hd__dfxtp_2
X_4486_ _4485_/X _6748_/A1 _4539_/S VGND VGND VPWR VPWR _7308_/D sky130_fd_sc_hd__mux2_2
Xplace1288 _6455_/B2 VGND VGND VPWR VPWR _6390_/B2 sky130_fd_sc_hd__buf_2
Xplace1299 _4154_/Y VGND VGND VPWR VPWR _4155_/C sky130_fd_sc_hd__buf_2
X_6225_ _6559_/A1 _6347_/D _6559_/B1 _6225_/C1 _6225_/D1 VGND VGND VPWR VPWR _6228_/A
+ sky130_fd_sc_hd__o2111ai_2
X_3437_ _7294_/Q _3500_/B _7296_/Q _3437_/D VGND VGND VPWR VPWR _3437_/X sky130_fd_sc_hd__and4bb_2
X_6156_ _6154_/X _6155_/X _6506_/A1 _6156_/C1 VGND VGND VPWR VPWR _6156_/X sky130_fd_sc_hd__a211o_2
XFILLER_85_522 VGND VGND VPWR VPWR sky130_fd_sc_hd__fill_2
X_5038_ _5038_/A0 _5099_/A1 _5059_/S VGND VGND VPWR VPWR _6986_/D sky130_fd_sc_hd__mux2_2
XTAP_TAPCELL_ROW_0_220 VGND VPWR sky130_fd_sc_hd__tapvpwrvgnd_1
XFILLER_72_249 VGND VGND VPWR VPWR sky130_fd_sc_hd__decap_3
XFILLER_13_316 VGND VGND VPWR VPWR sky130_fd_sc_hd__decap_3
XFILLER_25_165 VGND VGND VPWR VPWR sky130_fd_sc_hd__decap_3
XFILLER_41_603 VGND VGND VPWR VPWR sky130_fd_sc_hd__decap_3
XFILLER_53_452 VGND VGND VPWR VPWR sky130_fd_sc_hd__decap_3
XFILLER_15_66 VGND VGND VPWR VPWR sky130_fd_sc_hd__decap_3
XFILLER_25_198 VGND VGND VPWR VPWR sky130_fd_sc_hd__decap_3
X_6989_ _7243_/CLK _6989_/D VGND VGND VPWR VPWR _6989_/Q sky130_fd_sc_hd__dfxtp_2
XFILLER_40_168 VGND VGND VPWR VPWR sky130_fd_sc_hd__decap_3
XFILLER_21_393 VGND VGND VPWR VPWR sky130_fd_sc_hd__decap_3
XFILLER_31_87 VGND VGND VPWR VPWR sky130_fd_sc_hd__fill_1
XFILLER_0_253 VGND VGND VPWR VPWR sky130_fd_sc_hd__decap_3
XFILLER_48_202 VGND VGND VPWR VPWR sky130_fd_sc_hd__decap_3
XFILLER_76_566 VGND VGND VPWR VPWR sky130_fd_sc_hd__fill_2
Xhold2491 _7016_/Q VGND VGND VPWR VPWR _5103_/A0 sky130_fd_sc_hd__dlygate4sd3_1
Xhold2480 _7158_/Q VGND VGND VPWR VPWR _5442_/A0 sky130_fd_sc_hd__dlygate4sd3_1
XFILLER_29_482 VGND VGND VPWR VPWR sky130_fd_sc_hd__decap_3
XFILLER_91_514 VGND VGND VPWR VPWR sky130_fd_sc_hd__decap_3
Xplace216 _4147_/Y VGND VGND VPWR VPWR place216/X sky130_fd_sc_hd__buf_4
XFILLER_32_603 VGND VGND VPWR VPWR sky130_fd_sc_hd__decap_3
XFILLER_31_113 VGND VGND VPWR VPWR sky130_fd_sc_hd__decap_3
XFILLER_31_157 VGND VGND VPWR VPWR sky130_fd_sc_hd__decap_3
XTAP_TAPCELL_ROW_70_962 VGND VPWR sky130_fd_sc_hd__tapvpwrvgnd_1
XTAP_TAPCELL_ROW_42_664 VGND VPWR sky130_fd_sc_hd__tapvpwrvgnd_1
XPHY_EDGE_ROW_59_Right_59 VGND VGND VPWR VPWR sky130_fd_sc_hd__decap_3
XTAP_TAPCELL_ROW_14_366 VGND VPWR sky130_fd_sc_hd__tapvpwrvgnd_1
X_4340_ _4373_/B _4340_/B VGND VGND VPWR VPWR _4340_/Y sky130_fd_sc_hd__nor2_2
XFILLER_4_592 VGND VGND VPWR VPWR sky130_fd_sc_hd__fill_2
X_4271_ _4271_/A _4271_/B VGND VGND VPWR VPWR _4276_/A sky130_fd_sc_hd__nor2_2
XFILLER_98_168 VGND VGND VPWR VPWR sky130_fd_sc_hd__decap_3
X_6010_ _6010_/A _6010_/B _6010_/C _6010_/D VGND VGND VPWR VPWR _6011_/D sky130_fd_sc_hd__nand4_4
XFILLER_39_213 VGND VGND VPWR VPWR sky130_fd_sc_hd__decap_3
XFILLER_79_393 VGND VGND VPWR VPWR sky130_fd_sc_hd__decap_3
XPHY_EDGE_ROW_68_Right_68 VGND VGND VPWR VPWR sky130_fd_sc_hd__decap_3
XFILLER_39_246 VGND VGND VPWR VPWR sky130_fd_sc_hd__decap_3
XFILLER_39_279 VGND VGND VPWR VPWR sky130_fd_sc_hd__fill_1
XFILLER_54_227 VGND VGND VPWR VPWR sky130_fd_sc_hd__fill_1
XFILLER_94_363 VGND VGND VPWR VPWR sky130_fd_sc_hd__fill_1
XFILLER_94_374 VGND VGND VPWR VPWR sky130_fd_sc_hd__fill_2
X_6912_ _7276_/CLK _6912_/D VGND VGND VPWR VPWR _6912_/Q sky130_fd_sc_hd__dfxtp_2
XFILLER_35_452 VGND VGND VPWR VPWR sky130_fd_sc_hd__fill_1
XFILLER_35_496 VGND VGND VPWR VPWR sky130_fd_sc_hd__decap_3
XFILLER_50_433 VGND VGND VPWR VPWR sky130_fd_sc_hd__decap_3
XPHY_EDGE_ROW_77_Right_77 VGND VGND VPWR VPWR sky130_fd_sc_hd__decap_3
X_3986_ _7422_/Q _4009_/B1 _7454_/Q _3986_/B2 VGND VGND VPWR VPWR _4393_/D sky130_fd_sc_hd__a22oi_2
XFILLER_50_488 VGND VGND VPWR VPWR sky130_fd_sc_hd__decap_3
X_4607_ _4609_/A _4607_/B VGND VGND VPWR VPWR _4637_/A sky130_fd_sc_hd__or2_2
X_5587_ _5587_/A0 _4707_/X _5593_/S VGND VGND VPWR VPWR _7225_/D sky130_fd_sc_hd__mux2_2
XFILLER_2_518 VGND VGND VPWR VPWR sky130_fd_sc_hd__fill_2
X_7326_ clkload7/A _7326_/D place2021/X VGND VGND VPWR VPWR _7326_/Q sky130_fd_sc_hd__dfrtp_2
X_4538_ _4537_/X _7606_/D _4538_/S VGND VGND VPWR VPWR _4538_/X sky130_fd_sc_hd__mux2_2
Xplace1085 _4289_/B VGND VGND VPWR VPWR _6564_/B sky130_fd_sc_hd__buf_2
X_7257_ _7290_/CLK _7257_/D VGND VGND VPWR VPWR _7257_/Q sky130_fd_sc_hd__dfxtp_2
X_4469_ _6742_/A1 _4452_/S _4468_/X VGND VGND VPWR VPWR _7305_/D sky130_fd_sc_hd__a21o_2
XFILLER_89_179 VGND VGND VPWR VPWR sky130_fd_sc_hd__fill_2
XPHY_EDGE_ROW_86_Right_86 VGND VGND VPWR VPWR sky130_fd_sc_hd__decap_3
Xplace1096 _4260_/C VGND VGND VPWR VPWR _4257_/B sky130_fd_sc_hd__buf_2
X_6208_ _6211_/B1 _6208_/A2 _6204_/X _6207_/X VGND VGND VPWR VPWR _6208_/X sky130_fd_sc_hd__o31a_2
X_7188_ _7247_/CLK _7188_/D VGND VGND VPWR VPWR _7188_/Q sky130_fd_sc_hd__dfxtp_2
X_6139_ _6139_/A1 _6888_/Q _7280_/Q _6397_/B2 VGND VGND VPWR VPWR _6139_/X sky130_fd_sc_hd__o22a_2
XTAP_TAPCELL_ROW_86_1128 VGND VPWR sky130_fd_sc_hd__tapvpwrvgnd_1
XFILLER_13_113 VGND VGND VPWR VPWR sky130_fd_sc_hd__decap_3
XPHY_EDGE_ROW_95_Right_95 VGND VGND VPWR VPWR sky130_fd_sc_hd__decap_3
XFILLER_13_157 VGND VGND VPWR VPWR sky130_fd_sc_hd__decap_3
XFILLER_41_444 VGND VGND VPWR VPWR sky130_fd_sc_hd__decap_3
XTAP_TAPCELL_ROW_11_336 VGND VPWR sky130_fd_sc_hd__tapvpwrvgnd_1
XFILLER_42_97 VGND VGND VPWR VPWR sky130_fd_sc_hd__fill_2
XTAP_TAPCELL_ROW_97_1246 VGND VPWR sky130_fd_sc_hd__tapvpwrvgnd_1
XFILLER_1_573 VGND VGND VPWR VPWR sky130_fd_sc_hd__decap_3
XFILLER_67_50 VGND VGND VPWR VPWR sky130_fd_sc_hd__decap_3
XFILLER_95_149 VGND VGND VPWR VPWR sky130_fd_sc_hd__decap_3
XTAP_TAPCELL_ROW_47_712 VGND VPWR sky130_fd_sc_hd__tapvpwrvgnd_1
XFILLER_29_290 VGND VGND VPWR VPWR sky130_fd_sc_hd__decap_3
XFILLER_64_536 VGND VGND VPWR VPWR sky130_fd_sc_hd__fill_2
XFILLER_91_333 VGND VGND VPWR VPWR sky130_fd_sc_hd__decap_3
XTAP_TAPCELL_ROW_19_425 VGND VPWR sky130_fd_sc_hd__tapvpwrvgnd_1
XFILLER_32_411 VGND VGND VPWR VPWR sky130_fd_sc_hd__fill_2
XFILLER_32_433 VGND VGND VPWR VPWR sky130_fd_sc_hd__decap_3
XFILLER_44_293 VGND VGND VPWR VPWR sky130_fd_sc_hd__decap_3
XFILLER_32_477 VGND VGND VPWR VPWR sky130_fd_sc_hd__decap_3
X_3771_ _3771_/A _3771_/B _3771_/C VGND VGND VPWR VPWR _3773_/A sky130_fd_sc_hd__and3_2
XFILLER_73_3 VGND VGND VPWR VPWR sky130_fd_sc_hd__decap_3
XFILLER_8_150 VGND VGND VPWR VPWR sky130_fd_sc_hd__decap_3
X_6490_ _5841_/B _6804_/A1 _6565_/B _7586_/Q _6489_/X VGND VGND VPWR VPWR _6490_/X
+ sky130_fd_sc_hd__o221a_2
X_5372_ _5372_/A0 _5677_/A1 _5391_/S VGND VGND VPWR VPWR _7126_/D sky130_fd_sc_hd__mux2_2
X_7111_ _7279_/CLK _7111_/D VGND VGND VPWR VPWR _7111_/Q sky130_fd_sc_hd__dfxtp_2
X_4323_ _4473_/A place1798/X _4315_/A _6720_/S VGND VGND VPWR VPWR _4324_/B sky130_fd_sc_hd__a2bb2o_2
XFILLER_99_466 VGND VGND VPWR VPWR sky130_fd_sc_hd__decap_3
X_7042_ _7266_/CLK _7042_/D VGND VGND VPWR VPWR _7042_/Q sky130_fd_sc_hd__dfxtp_2
X_4254_ _4254_/A VGND VGND VPWR VPWR _4254_/Y sky130_fd_sc_hd__inv_2
XFILLER_79_190 VGND VGND VPWR VPWR sky130_fd_sc_hd__fill_1
XFILLER_86_149 VGND VGND VPWR VPWR sky130_fd_sc_hd__decap_3
X_4185_ _4185_/A _4185_/B _4185_/C VGND VGND VPWR VPWR _4185_/X sky130_fd_sc_hd__or3_2
XFILLER_55_514 VGND VGND VPWR VPWR sky130_fd_sc_hd__fill_2
XFILLER_27_249 VGND VGND VPWR VPWR sky130_fd_sc_hd__decap_3
XFILLER_55_547 VGND VGND VPWR VPWR sky130_fd_sc_hd__fill_1
XFILLER_35_260 VGND VGND VPWR VPWR sky130_fd_sc_hd__decap_3
XFILLER_35_293 VGND VGND VPWR VPWR sky130_fd_sc_hd__decap_3
XFILLER_50_230 VGND VGND VPWR VPWR sky130_fd_sc_hd__decap_3
X_6826_ _6838_/A _6826_/B VGND VGND VPWR VPWR _7571_/D sky130_fd_sc_hd__and2_2
XFILLER_23_477 VGND VGND VPWR VPWR sky130_fd_sc_hd__decap_3
XTAP_TAPCELL_ROW_81_1069 VGND VPWR sky130_fd_sc_hd__tapvpwrvgnd_1
X_3969_ _3969_/A _3969_/B _3969_/C _3969_/D VGND VGND VPWR VPWR _3972_/A sky130_fd_sc_hd__nand4_2
XFILLER_12_56 VGND VGND VPWR VPWR sky130_fd_sc_hd__decap_3
XFILLER_2_304 VGND VGND VPWR VPWR sky130_fd_sc_hd__decap_3
XFILLER_88_38 VGND VGND VPWR VPWR sky130_fd_sc_hd__decap_3
X_7309_ _7606_/CLK _7309_/D place2049/X VGND VGND VPWR VPWR _7309_/Q sky130_fd_sc_hd__dfrtp_2
XFILLER_2_359 VGND VGND VPWR VPWR sky130_fd_sc_hd__decap_3
XFILLER_78_606 VGND VGND VPWR VPWR sky130_fd_sc_hd__decap_3
XTAP_TAPCELL_ROW_92_1187 VGND VPWR sky130_fd_sc_hd__tapvpwrvgnd_1
XFILLER_58_330 VGND VGND VPWR VPWR sky130_fd_sc_hd__decap_3
XFILLER_37_42 VGND VGND VPWR VPWR sky130_fd_sc_hd__decap_3
XFILLER_58_352 VGND VGND VPWR VPWR sky130_fd_sc_hd__decap_3
XFILLER_58_363 VGND VGND VPWR VPWR sky130_fd_sc_hd__fill_1
XFILLER_73_311 VGND VGND VPWR VPWR sky130_fd_sc_hd__decap_3
XFILLER_18_227 VGND VGND VPWR VPWR sky130_fd_sc_hd__decap_3
XFILLER_46_536 VGND VGND VPWR VPWR sky130_fd_sc_hd__decap_3
XFILLER_26_282 VGND VGND VPWR VPWR sky130_fd_sc_hd__decap_3
XFILLER_73_388 VGND VGND VPWR VPWR sky130_fd_sc_hd__decap_3
XFILLER_53_74 VGND VGND VPWR VPWR sky130_fd_sc_hd__decap_3
XTAP_TAPCELL_ROW_52_770 VGND VPWR sky130_fd_sc_hd__tapvpwrvgnd_1
XTAP_TAPCELL_ROW_24_472 VGND VPWR sky130_fd_sc_hd__tapvpwrvgnd_1
XTAP_TAPCELL_ROW_101_1283 VGND VPWR sky130_fd_sc_hd__tapvpwrvgnd_1
XFILLER_5_186 VGND VGND VPWR VPWR sky130_fd_sc_hd__fill_2
XFILLER_1_381 VGND VGND VPWR VPWR sky130_fd_sc_hd__decap_3
XFILLER_37_547 VGND VGND VPWR VPWR sky130_fd_sc_hd__fill_1
XFILLER_24_208 VGND VGND VPWR VPWR sky130_fd_sc_hd__decap_3
X_5990_ _7108_/Q _6449_/B1 _6453_/B1 _7052_/Q VGND VGND VPWR VPWR _5990_/X sky130_fd_sc_hd__o22a_2
X_4941_ _4941_/A0 _5190_/A1 _4958_/S VGND VGND VPWR VPWR _6944_/D sky130_fd_sc_hd__mux2_2
XFILLER_32_230 VGND VGND VPWR VPWR sky130_fd_sc_hd__decap_3
XFILLER_32_274 VGND VGND VPWR VPWR sky130_fd_sc_hd__decap_3
X_6611_ _6611_/A0 _6113_/X _6638_/S VGND VGND VPWR VPWR _7469_/D sky130_fd_sc_hd__mux2_2
X_3823_ _7437_/Q _3490_/X _3598_/X _7341_/Q _3822_/X VGND VGND VPWR VPWR _3823_/X
+ sky130_fd_sc_hd__a221o_2
X_7591_ clkload5/A _7591_/D place2060/X VGND VGND VPWR VPWR _7591_/Q sky130_fd_sc_hd__dfrtp_2
X_3754_ _3815_/A1 _3792_/A2 _7378_/Q _3792_/B1 _7570_/Q VGND VGND VPWR VPWR _3754_/X
+ sky130_fd_sc_hd__a32o_2
X_6473_ _6473_/A1 _7015_/Q _6931_/Q _6476_/B2 VGND VGND VPWR VPWR _6475_/A sky130_fd_sc_hd__o22a_2
X_3685_ _4274_/A _3685_/B _4260_/B VGND VGND VPWR VPWR _3742_/C sky130_fd_sc_hd__nand3_4
X_5355_ _5355_/A0 _5600_/A1 _5361_/S VGND VGND VPWR VPWR _7119_/D sky130_fd_sc_hd__mux2_2
X_4306_ _4306_/A _4306_/B _4306_/C VGND VGND VPWR VPWR _4508_/A sky130_fd_sc_hd__and3_2
XFILLER_59_138 VGND VGND VPWR VPWR sky130_fd_sc_hd__decap_3
XFILLER_87_447 VGND VGND VPWR VPWR sky130_fd_sc_hd__fill_1
X_7025_ _7280_/CLK _7025_/D VGND VGND VPWR VPWR _7025_/Q sky130_fd_sc_hd__dfxtp_2
X_4237_ _4237_/A _4237_/B _4237_/C _4237_/D VGND VGND VPWR VPWR _4237_/X sky130_fd_sc_hd__or4_2
XTAP_TAPCELL_ROW_58_829 VGND VPWR sky130_fd_sc_hd__tapvpwrvgnd_1
XFILLER_28_536 VGND VGND VPWR VPWR sky130_fd_sc_hd__decap_3
XFILLER_55_322 VGND VGND VPWR VPWR sky130_fd_sc_hd__decap_3
X_4168_ _4168_/A _4168_/B _4168_/C VGND VGND VPWR VPWR _4168_/Y sky130_fd_sc_hd__nand3_2
X_4099_ _4099_/A _4099_/B VGND VGND VPWR VPWR _4099_/Y sky130_fd_sc_hd__nor2_2
XFILLER_55_399 VGND VGND VPWR VPWR sky130_fd_sc_hd__decap_3
XFILLER_23_252 VGND VGND VPWR VPWR sky130_fd_sc_hd__decap_3
X_6809_ _6840_/A _6809_/B VGND VGND VPWR VPWR _7563_/D sky130_fd_sc_hd__and2_2
XFILLER_23_285 VGND VGND VPWR VPWR sky130_fd_sc_hd__decap_3
XTAP_TAPCELL_ROW_21_442 VGND VPWR sky130_fd_sc_hd__tapvpwrvgnd_1
XTAP_TAPCELL_ROW_94_1205 VGND VPWR sky130_fd_sc_hd__tapvpwrvgnd_1
XFILLER_3_3 VGND VGND VPWR VPWR sky130_fd_sc_hd__decap_3
XFILLER_78_447 VGND VGND VPWR VPWR sky130_fd_sc_hd__fill_2
XFILLER_19_503 VGND VGND VPWR VPWR sky130_fd_sc_hd__fill_1
XFILLER_58_160 VGND VGND VPWR VPWR sky130_fd_sc_hd__decap_3
XFILLER_0_26 VGND VGND VPWR VPWR sky130_fd_sc_hd__fill_2
XFILLER_46_322 VGND VGND VPWR VPWR sky130_fd_sc_hd__decap_3
XFILLER_46_355 VGND VGND VPWR VPWR sky130_fd_sc_hd__decap_3
XFILLER_73_130 VGND VGND VPWR VPWR sky130_fd_sc_hd__decap_3
XTAP_TAPCELL_ROW_29_531 VGND VPWR sky130_fd_sc_hd__tapvpwrvgnd_1
XFILLER_34_539 VGND VGND VPWR VPWR sky130_fd_sc_hd__decap_3
XFILLER_61_325 VGND VGND VPWR VPWR sky130_fd_sc_hd__decap_3
XTAP_TAPCELL_ROW_103_1301 VGND VPWR sky130_fd_sc_hd__tapvpwrvgnd_1
XFILLER_14_230 VGND VGND VPWR VPWR sky130_fd_sc_hd__decap_3
XFILLER_61_358 VGND VGND VPWR VPWR sky130_fd_sc_hd__decap_3
XTAP_TAPCELL_ROW_103_1312 VGND VPWR sky130_fd_sc_hd__tapvpwrvgnd_1
XFILLER_14_263 VGND VGND VPWR VPWR sky130_fd_sc_hd__decap_3
XFILLER_9_46 VGND VGND VPWR VPWR sky130_fd_sc_hd__decap_3
XFILLER_80_72 VGND VGND VPWR VPWR sky130_fd_sc_hd__decap_3
Xplace1607 _3670_/A VGND VGND VPWR VPWR _4225_/A1 sky130_fd_sc_hd__buf_2
Xplace1618 _6569_/S VGND VGND VPWR VPWR _6567_/S sky130_fd_sc_hd__buf_2
XFILLER_6_495 VGND VGND VPWR VPWR sky130_fd_sc_hd__decap_3
Xplace1629 _3810_/B1 VGND VGND VPWR VPWR _3757_/B1 sky130_fd_sc_hd__buf_2
X_3470_ _3480_/B _3491_/B _3470_/B1 _3470_/C1 VGND VGND VPWR VPWR _3471_/D sky130_fd_sc_hd__o211ai_2
XFILLER_36_3 VGND VGND VPWR VPWR sky130_fd_sc_hd__decap_3
X_5140_ _5140_/A0 _5351_/A1 _5152_/S VGND VGND VPWR VPWR _7033_/D sky130_fd_sc_hd__mux2_2
XFILLER_69_447 VGND VGND VPWR VPWR sky130_fd_sc_hd__fill_1
XFILLER_56_108 VGND VGND VPWR VPWR sky130_fd_sc_hd__decap_3
X_4022_ _4022_/A _4022_/B VGND VGND VPWR VPWR _7583_/D sky130_fd_sc_hd__nand2_2
XFILLER_37_311 VGND VGND VPWR VPWR sky130_fd_sc_hd__decap_3
XFILLER_49_182 VGND VGND VPWR VPWR sky130_fd_sc_hd__decap_3
XFILLER_64_141 VGND VGND VPWR VPWR sky130_fd_sc_hd__fill_2
XFILLER_52_325 VGND VGND VPWR VPWR sky130_fd_sc_hd__fill_2
X_5973_ _6168_/B2 _7032_/Q _6948_/Q _6173_/B2 VGND VGND VPWR VPWR _5973_/Y sky130_fd_sc_hd__o22ai_2
X_4924_ _4924_/A0 _5446_/A1 _4930_/S VGND VGND VPWR VPWR _6936_/D sky130_fd_sc_hd__mux2_2
XTAP_TAPCELL_ROW_63_887 VGND VPWR sky130_fd_sc_hd__tapvpwrvgnd_1
XTAP_TAPCELL_ROW_35_589 VGND VPWR sky130_fd_sc_hd__tapvpwrvgnd_1
XFILLER_20_200 VGND VGND VPWR VPWR sky130_fd_sc_hd__decap_3
XFILLER_20_266 VGND VGND VPWR VPWR sky130_fd_sc_hd__fill_2
X_7574_ _7577_/CLK _7574_/D place2013/X VGND VGND VPWR VPWR _7574_/Q sky130_fd_sc_hd__dfrtp_2
X_3806_ _7306_/Q _4211_/A _3805_/Y VGND VGND VPWR VPWR _3807_/D sky130_fd_sc_hd__a21oi_2
X_3737_ _7320_/Q _3761_/B _3761_/C VGND VGND VPWR VPWR _4297_/C sky130_fd_sc_hd__and3_2
XFILLER_69_18 VGND VGND VPWR VPWR sky130_fd_sc_hd__fill_2
XFILLER_69_29 VGND VGND VPWR VPWR sky130_fd_sc_hd__decap_3
X_6456_ _6456_/A1 _7010_/Q _6982_/Q _6456_/B2 VGND VGND VPWR VPWR _6456_/X sky130_fd_sc_hd__o22a_2
X_3668_ _4297_/A _3668_/A2 _3667_/Y VGND VGND VPWR VPWR _3668_/Y sky130_fd_sc_hd__o21bai_4
X_6387_ _6696_/A0 _6410_/A2 _6410_/A3 _6410_/B1 _7413_/Q VGND VGND VPWR VPWR _6387_/X
+ sky130_fd_sc_hd__a32o_2
XFILLER_0_605 VGND VGND VPWR VPWR sky130_fd_sc_hd__decap_3
X_5338_ _5338_/A0 _5705_/A1 _5357_/S VGND VGND VPWR VPWR _7111_/D sky130_fd_sc_hd__mux2_2
XFILLER_102_533 VGND VGND VPWR VPWR sky130_fd_sc_hd__decap_3
Xhold2810 _6920_/Q VGND VGND VPWR VPWR _4887_/A0 sky130_fd_sc_hd__dlygate4sd3_1
Xhold2821 _7556_/Q VGND VGND VPWR VPWR _6796_/B sky130_fd_sc_hd__dlygate4sd3_1
Xhold2832 _7555_/Q VGND VGND VPWR VPWR _6793_/B sky130_fd_sc_hd__dlygate4sd3_1
XFILLER_87_277 VGND VGND VPWR VPWR sky130_fd_sc_hd__decap_3
Xhold2843 _7345_/Q VGND VGND VPWR VPWR _6277_/B sky130_fd_sc_hd__dlygate4sd3_1
Xhold2854 _7567_/Q VGND VGND VPWR VPWR _6818_/B sky130_fd_sc_hd__dlygate4sd3_1
Xhold2865 _7564_/Q VGND VGND VPWR VPWR _6811_/B sky130_fd_sc_hd__dlygate4sd3_1
X_7008_ _7291_/CLK _7008_/D VGND VGND VPWR VPWR _7008_/Q sky130_fd_sc_hd__dfxtp_2
Xhold2876 _7327_/Q VGND VGND VPWR VPWR _6239_/A sky130_fd_sc_hd__dlygate4sd3_1
Xhold2887 _7560_/Q VGND VGND VPWR VPWR _6804_/B1 sky130_fd_sc_hd__dlygate4sd3_1
Xhold2898 _7517_/Q VGND VGND VPWR VPWR _6712_/A1 sky130_fd_sc_hd__dlygate4sd3_1
XFILLER_16_506 VGND VGND VPWR VPWR sky130_fd_sc_hd__decap_3
XFILLER_18_55 VGND VGND VPWR VPWR sky130_fd_sc_hd__fill_2
XFILLER_55_152 VGND VGND VPWR VPWR sky130_fd_sc_hd__fill_1
XFILLER_16_539 VGND VGND VPWR VPWR sky130_fd_sc_hd__fill_1
XFILLER_28_377 VGND VGND VPWR VPWR sky130_fd_sc_hd__decap_3
XFILLER_43_325 VGND VGND VPWR VPWR sky130_fd_sc_hd__decap_3
XTAP_TAPCELL_ROW_26_501 VGND VPWR sky130_fd_sc_hd__tapvpwrvgnd_1
XFILLER_11_200 VGND VGND VPWR VPWR sky130_fd_sc_hd__decap_3
XFILLER_24_583 VGND VGND VPWR VPWR sky130_fd_sc_hd__fill_1
XFILLER_7_248 VGND VGND VPWR VPWR sky130_fd_sc_hd__decap_3
XFILLER_50_75 VGND VGND VPWR VPWR sky130_fd_sc_hd__decap_3
XFILLER_22_9 VGND VGND VPWR VPWR sky130_fd_sc_hd__decap_3
XFILLER_19_311 VGND VGND VPWR VPWR sky130_fd_sc_hd__decap_3
XTAP_TAPCELL_ROW_6_281 VGND VPWR sky130_fd_sc_hd__tapvpwrvgnd_1
XFILLER_19_355 VGND VGND VPWR VPWR sky130_fd_sc_hd__fill_1
XFILLER_46_141 VGND VGND VPWR VPWR sky130_fd_sc_hd__decap_3
XFILLER_34_303 VGND VGND VPWR VPWR sky130_fd_sc_hd__decap_3
XFILLER_46_174 VGND VGND VPWR VPWR sky130_fd_sc_hd__decap_3
XFILLER_34_358 VGND VGND VPWR VPWR sky130_fd_sc_hd__decap_3
XFILLER_61_155 VGND VGND VPWR VPWR sky130_fd_sc_hd__decap_3
XFILLER_91_60 VGND VGND VPWR VPWR sky130_fd_sc_hd__fill_2
XFILLER_30_520 VGND VGND VPWR VPWR sky130_fd_sc_hd__decap_3
XFILLER_91_71 VGND VGND VPWR VPWR sky130_fd_sc_hd__fill_2
XTAP_TAPCELL_ROW_60_857 VGND VPWR sky130_fd_sc_hd__tapvpwrvgnd_1
XTAP_TAPCELL_ROW_32_559 VGND VPWR sky130_fd_sc_hd__tapvpwrvgnd_1
XFILLER_30_586 VGND VGND VPWR VPWR sky130_fd_sc_hd__fill_2
X_6310_ _7392_/Q _6313_/A2 _6313_/A3 _6313_/B1 _6310_/B2 VGND VGND VPWR VPWR _7360_/D
+ sky130_fd_sc_hd__a32o_2
X_4571_ _4508_/A _4508_/B _7611_/D _4571_/B1 VGND VGND VPWR VPWR _4571_/Y sky130_fd_sc_hd__o31ai_2
Xplace1404 _3821_/A VGND VGND VPWR VPWR _4201_/A sky130_fd_sc_hd__buf_2
Xplace1415 _6348_/S VGND VGND VPWR VPWR _6363_/B1 sky130_fd_sc_hd__buf_2
Xplace1426 _4287_/X VGND VGND VPWR VPWR _4569_/A1 sky130_fd_sc_hd__buf_2
X_7290_ _7290_/CLK _7290_/D VGND VGND VPWR VPWR _7290_/Q sky130_fd_sc_hd__dfxtp_2
X_3522_ _3522_/A1 _3522_/A2 _3462_/B _4319_/A1 _3481_/B VGND VGND VPWR VPWR _3522_/X
+ sky130_fd_sc_hd__a41o_2
XFILLER_6_292 VGND VGND VPWR VPWR sky130_fd_sc_hd__decap_3
Xplace1448 _3860_/Y VGND VGND VPWR VPWR _4184_/D sky130_fd_sc_hd__buf_2
Xplace1459 _3756_/Y VGND VGND VPWR VPWR _4232_/B sky130_fd_sc_hd__buf_2
X_6241_ _6247_/A _6241_/B VGND VGND VPWR VPWR _7328_/D sky130_fd_sc_hd__and2_2
X_3453_ _3485_/C _3459_/A _6302_/A VGND VGND VPWR VPWR _3453_/X sky130_fd_sc_hd__a21o_2
X_6172_ _7031_/Q _4780_/C _6186_/C1 _6171_/X VGND VGND VPWR VPWR _6172_/X sky130_fd_sc_hd__o31a_2
XFILLER_69_244 VGND VGND VPWR VPWR sky130_fd_sc_hd__fill_1
X_5123_ _5123_/A0 _5334_/A1 _5146_/S VGND VGND VPWR VPWR _7025_/D sky130_fd_sc_hd__mux2_2
XTAP_TAPCELL_ROW_68_935 VGND VPWR sky130_fd_sc_hd__tapvpwrvgnd_1
X_4005_ _7393_/Q _6363_/A2 _4595_/A3 _4004_/X VGND VGND VPWR VPWR _4005_/X sky130_fd_sc_hd__a31o_2
XFILLER_52_122 VGND VGND VPWR VPWR sky130_fd_sc_hd__decap_3
X_5956_ _6476_/A1 _7156_/Q _7128_/Q _6424_/B2 VGND VGND VPWR VPWR _5956_/X sky130_fd_sc_hd__o22a_2
XFILLER_21_520 VGND VGND VPWR VPWR sky130_fd_sc_hd__decap_3
XFILLER_52_188 VGND VGND VPWR VPWR sky130_fd_sc_hd__decap_3
X_5887_ _6456_/B2 _7289_/Q _7261_/Q _6448_/B2 VGND VGND VPWR VPWR _5887_/X sky130_fd_sc_hd__o22a_2
X_4907_ _4907_/A0 _5673_/A1 _4964_/S VGND VGND VPWR VPWR _6928_/D sky130_fd_sc_hd__mux2_2
XFILLER_21_564 VGND VGND VPWR VPWR sky130_fd_sc_hd__decap_3
X_4838_ _4838_/A0 _4769_/Y _4838_/S VGND VGND VPWR VPWR _6898_/D sky130_fd_sc_hd__mux2_2
X_7557_ _7565_/CLK _7557_/D place2015/X VGND VGND VPWR VPWR _7557_/Q sky130_fd_sc_hd__dfrtp_2
X_4769_ _6404_/A2 _4297_/B _4768_/Y VGND VGND VPWR VPWR _4769_/Y sky130_fd_sc_hd__a21oi_2
XFILLER_4_218 VGND VGND VPWR VPWR sky130_fd_sc_hd__decap_3
X_7488_ _7581_/CLK _7488_/D place2025/X VGND VGND VPWR VPWR _7488_/Q sky130_fd_sc_hd__dfrtp_2
X_6508_ _6511_/A1 _6990_/Q _6962_/Q _6511_/B2 VGND VGND VPWR VPWR _6508_/X sky130_fd_sc_hd__o22a_2
X_6439_ _6486_/C _6435_/X _6403_/X _4735_/X _6438_/X VGND VGND VPWR VPWR _6439_/Y
+ sky130_fd_sc_hd__o221ai_2
XFILLER_0_402 VGND VGND VPWR VPWR sky130_fd_sc_hd__decap_3
Xplace1982 _3443_/C VGND VGND VPWR VPWR _3470_/B1 sky130_fd_sc_hd__buf_2
Xplace1971 _4503_/C VGND VGND VPWR VPWR _6302_/B sky130_fd_sc_hd__buf_2
Xplace1960 _7356_/Q VGND VGND VPWR VPWR _3530_/A sky130_fd_sc_hd__buf_2
XFILLER_0_424 VGND VGND VPWR VPWR sky130_fd_sc_hd__fill_2
XFILLER_88_531 VGND VGND VPWR VPWR sky130_fd_sc_hd__fill_1
XFILLER_96_27 VGND VGND VPWR VPWR sky130_fd_sc_hd__fill_1
Xplace1993 _4337_/B VGND VGND VPWR VPWR _4315_/A sky130_fd_sc_hd__buf_2
Xhold2640 _6922_/Q VGND VGND VPWR VPWR _4892_/A0 sky130_fd_sc_hd__dlygate4sd3_1
XFILLER_29_54 VGND VGND VPWR VPWR sky130_fd_sc_hd__fill_2
XFILLER_75_225 VGND VGND VPWR VPWR sky130_fd_sc_hd__fill_2
XFILLER_88_597 VGND VGND VPWR VPWR sky130_fd_sc_hd__fill_1
Xhold2651 _6993_/Q VGND VGND VPWR VPWR _5053_/A0 sky130_fd_sc_hd__dlygate4sd3_1
Xhold2662 _6902_/Q VGND VGND VPWR VPWR _4849_/A0 sky130_fd_sc_hd__dlygate4sd3_1
Xhold2673 _6858_/Q VGND VGND VPWR VPWR _4688_/A0 sky130_fd_sc_hd__dlygate4sd3_1
Xhold2684 _6927_/Q VGND VGND VPWR VPWR _4902_/A0 sky130_fd_sc_hd__dlygate4sd3_1
Xhold2695 _7034_/Q VGND VGND VPWR VPWR _5142_/A0 sky130_fd_sc_hd__dlygate4sd3_1
XTAP_TAPCELL_ROW_89_1159 VGND VPWR sky130_fd_sc_hd__tapvpwrvgnd_1
XTAP_TAPCELL_ROW_3_251 VGND VPWR sky130_fd_sc_hd__tapvpwrvgnd_1
XFILLER_28_152 VGND VGND VPWR VPWR sky130_fd_sc_hd__decap_3
XFILLER_28_174 VGND VGND VPWR VPWR sky130_fd_sc_hd__decap_3
XFILLER_56_483 VGND VGND VPWR VPWR sky130_fd_sc_hd__decap_3
XFILLER_31_306 VGND VGND VPWR VPWR sky130_fd_sc_hd__decap_3
XFILLER_43_155 VGND VGND VPWR VPWR sky130_fd_sc_hd__decap_3
XFILLER_45_97 VGND VGND VPWR VPWR sky130_fd_sc_hd__decap_3
XFILLER_43_199 VGND VGND VPWR VPWR sky130_fd_sc_hd__fill_1
XFILLER_8_513 VGND VGND VPWR VPWR sky130_fd_sc_hd__decap_3
XFILLER_12_586 VGND VGND VPWR VPWR sky130_fd_sc_hd__fill_2
XANTENNA_7 _6126_/X VGND VGND VPWR VPWR sky130_fd_sc_hd__diode_2
XFILLER_3_262 VGND VGND VPWR VPWR sky130_fd_sc_hd__fill_2
XFILLER_20_6 VGND VGND VPWR VPWR sky130_fd_sc_hd__fill_2
XFILLER_66_203 VGND VGND VPWR VPWR sky130_fd_sc_hd__fill_1
XFILLER_66_214 VGND VGND VPWR VPWR sky130_fd_sc_hd__decap_3
XFILLER_19_130 VGND VGND VPWR VPWR sky130_fd_sc_hd__decap_3
XFILLER_66_269 VGND VGND VPWR VPWR sky130_fd_sc_hd__decap_3
XTAP_TAPCELL_ROW_65_905 VGND VPWR sky130_fd_sc_hd__tapvpwrvgnd_1
XFILLER_19_163 VGND VGND VPWR VPWR sky130_fd_sc_hd__decap_3
XFILLER_34_100 VGND VGND VPWR VPWR sky130_fd_sc_hd__fill_1
XFILLER_94_589 VGND VGND VPWR VPWR sky130_fd_sc_hd__decap_3
XTAP_TAPCELL_ROW_37_607 VGND VPWR sky130_fd_sc_hd__tapvpwrvgnd_1
XFILLER_34_111 VGND VGND VPWR VPWR sky130_fd_sc_hd__fill_1
X_5810_ _5808_/X _5809_/X _6395_/B1 VGND VGND VPWR VPWR _5820_/A sky130_fd_sc_hd__a21oi_2
XTAP_TAPCELL_ROW_73_993 VGND VPWR sky130_fd_sc_hd__tapvpwrvgnd_1
XTAP_TAPCELL_ROW_45_695 VGND VPWR sky130_fd_sc_hd__tapvpwrvgnd_1
XTAP_TAPCELL_ROW_17_397 VGND VPWR sky130_fd_sc_hd__tapvpwrvgnd_1
XFILLER_15_391 VGND VGND VPWR VPWR sky130_fd_sc_hd__fill_1
XFILLER_30_383 VGND VGND VPWR VPWR sky130_fd_sc_hd__decap_3
X_7411_ _7507_/CLK _7411_/D place2038/X VGND VGND VPWR VPWR _7411_/Q sky130_fd_sc_hd__dfrtp_2
Xplace1201 _4958_/S VGND VGND VPWR VPWR _4964_/S sky130_fd_sc_hd__buf_2
X_7342_ _7579_/CLK _7342_/D place2044/X VGND VGND VPWR VPWR _7342_/Q sky130_fd_sc_hd__dfrtp_2
X_4554_ _4533_/A _4533_/D _4552_/X _4553_/Y VGND VGND VPWR VPWR _4554_/X sky130_fd_sc_hd__a2bb2o_2
XTAP_TAPCELL_ROW_77_1030 VGND VPWR sky130_fd_sc_hd__tapvpwrvgnd_1
Xplace1212 _4776_/S VGND VGND VPWR VPWR _4771_/S sky130_fd_sc_hd__buf_2
Xplace1223 _6436_/C VGND VGND VPWR VPWR _4727_/D sky130_fd_sc_hd__buf_2
Xplace1234 _5547_/S VGND VGND VPWR VPWR _5532_/S sky130_fd_sc_hd__buf_2
Xrebuffer2202 _3950_/A2 VGND VGND VPWR VPWR _5734_/A sky130_fd_sc_hd__buf_2
X_7273_ _7273_/CLK _7273_/D VGND VGND VPWR VPWR _7273_/Q sky130_fd_sc_hd__dfxtp_2
X_3505_ _3505_/A1 _3505_/A2 _4014_/B1 _3505_/C1 VGND VGND VPWR VPWR _3505_/Y sky130_fd_sc_hd__a211oi_2
Xplace1245 _6208_/A2 VGND VGND VPWR VPWR _6506_/A2 sky130_fd_sc_hd__buf_2
Xplace1256 _6457_/C1 VGND VGND VPWR VPWR _6156_/C1 sky130_fd_sc_hd__buf_2
Xplace1267 _6451_/B1 VGND VGND VPWR VPWR _6449_/B1 sky130_fd_sc_hd__buf_2
X_4485_ _7598_/D _4538_/S _4484_/Y VGND VGND VPWR VPWR _4485_/X sky130_fd_sc_hd__a21o_2
Xplace1278 _6473_/A1 VGND VGND VPWR VPWR _6484_/B2 sky130_fd_sc_hd__buf_4
Xplace1289 _6138_/B2 VGND VGND VPWR VPWR _6399_/B2 sky130_fd_sc_hd__buf_8
X_3436_ _3468_/A _3473_/A _3429_/B _3474_/A _7296_/Q VGND VGND VPWR VPWR _3436_/Y
+ sky130_fd_sc_hd__a41oi_4
X_6155_ _6175_/A2 _6889_/Q _7281_/Q _6165_/A1 VGND VGND VPWR VPWR _6155_/X sky130_fd_sc_hd__o22a_2
XFILLER_57_203 VGND VGND VPWR VPWR sky130_fd_sc_hd__fill_1
XFILLER_57_225 VGND VGND VPWR VPWR sky130_fd_sc_hd__decap_3
X_6086_ _6220_/A1 _6182_/A2 _6220_/B1 _7595_/Q _6085_/X VGND VGND VPWR VPWR _6086_/X
+ sky130_fd_sc_hd__o221a_4
X_5106_ _5106_/A0 _5317_/A1 _5118_/S VGND VGND VPWR VPWR _7017_/D sky130_fd_sc_hd__mux2_2
XFILLER_85_578 VGND VGND VPWR VPWR sky130_fd_sc_hd__fill_1
XTAP_TAPCELL_ROW_0_221 VGND VPWR sky130_fd_sc_hd__tapvpwrvgnd_1
XTAP_TAPCELL_ROW_0_210 VGND VPWR sky130_fd_sc_hd__tapvpwrvgnd_1
XFILLER_53_420 VGND VGND VPWR VPWR sky130_fd_sc_hd__fill_2
XFILLER_82_29 VGND VGND VPWR VPWR sky130_fd_sc_hd__decap_3
XFILLER_53_475 VGND VGND VPWR VPWR sky130_fd_sc_hd__decap_3
XFILLER_13_328 VGND VGND VPWR VPWR sky130_fd_sc_hd__decap_3
XFILLER_25_177 VGND VGND VPWR VPWR sky130_fd_sc_hd__decap_3
XFILLER_53_497 VGND VGND VPWR VPWR sky130_fd_sc_hd__decap_3
X_6988_ _7275_/CLK _6988_/D VGND VGND VPWR VPWR _6988_/Q sky130_fd_sc_hd__dfxtp_2
X_5939_ _5939_/A _5939_/B _6486_/C VGND VGND VPWR VPWR _5939_/X sky130_fd_sc_hd__or3_2
X_7609_ _7610_/CLK _7609_/D place2055/X VGND VGND VPWR VPWR _7609_/Q sky130_fd_sc_hd__dfrtp_2
XTAP_TAPCELL_ROW_8_310 VGND VPWR sky130_fd_sc_hd__tapvpwrvgnd_1
XFILLER_0_210 VGND VGND VPWR VPWR sky130_fd_sc_hd__decap_3
Xplace1790 _3519_/B VGND VGND VPWR VPWR _4146_/A1 sky130_fd_sc_hd__buf_2
XFILLER_0_243 VGND VGND VPWR VPWR sky130_fd_sc_hd__decap_3
XFILLER_0_276 VGND VGND VPWR VPWR sky130_fd_sc_hd__decap_3
XFILLER_48_225 VGND VGND VPWR VPWR sky130_fd_sc_hd__decap_3
XFILLER_48_236 VGND VGND VPWR VPWR sky130_fd_sc_hd__decap_3
Xhold2481 _7231_/Q VGND VGND VPWR VPWR _5600_/A0 sky130_fd_sc_hd__dlygate4sd3_1
Xhold2470 _7151_/Q VGND VGND VPWR VPWR _5425_/A0 sky130_fd_sc_hd__dlygate4sd3_1
XFILLER_29_461 VGND VGND VPWR VPWR sky130_fd_sc_hd__decap_3
XFILLER_76_589 VGND VGND VPWR VPWR sky130_fd_sc_hd__decap_3
Xhold2492 _6851_/Q VGND VGND VPWR VPWR _4633_/A0 sky130_fd_sc_hd__dlygate4sd3_1
XFILLER_16_122 VGND VGND VPWR VPWR sky130_fd_sc_hd__decap_3
XFILLER_29_494 VGND VGND VPWR VPWR sky130_fd_sc_hd__decap_3
XFILLER_56_85 VGND VGND VPWR VPWR sky130_fd_sc_hd__decap_3
XFILLER_16_144 VGND VGND VPWR VPWR sky130_fd_sc_hd__decap_3
XFILLER_16_188 VGND VGND VPWR VPWR sky130_fd_sc_hd__decap_3
XFILLER_31_125 VGND VGND VPWR VPWR sky130_fd_sc_hd__fill_1
XTAP_TAPCELL_ROW_70_963 VGND VPWR sky130_fd_sc_hd__tapvpwrvgnd_1
XFILLER_31_169 VGND VGND VPWR VPWR sky130_fd_sc_hd__decap_3
XTAP_TAPCELL_ROW_42_665 VGND VPWR sky130_fd_sc_hd__tapvpwrvgnd_1
XTAP_TAPCELL_ROW_14_367 VGND VPWR sky130_fd_sc_hd__tapvpwrvgnd_1
XFILLER_8_365 VGND VGND VPWR VPWR sky130_fd_sc_hd__fill_1
XFILLER_8_387 VGND VGND VPWR VPWR sky130_fd_sc_hd__fill_1
XFILLER_98_125 VGND VGND VPWR VPWR sky130_fd_sc_hd__fill_2
X_4270_ _4270_/A VGND VGND VPWR VPWR _4270_/X sky130_fd_sc_hd__buf_1
XFILLER_97_92 VGND VGND VPWR VPWR sky130_fd_sc_hd__decap_3
XFILLER_39_225 VGND VGND VPWR VPWR sky130_fd_sc_hd__decap_3
XFILLER_54_206 VGND VGND VPWR VPWR sky130_fd_sc_hd__decap_3
XFILLER_35_420 VGND VGND VPWR VPWR sky130_fd_sc_hd__decap_3
XFILLER_47_291 VGND VGND VPWR VPWR sky130_fd_sc_hd__decap_3
X_6911_ _7247_/CLK _6911_/D VGND VGND VPWR VPWR _6911_/Q sky130_fd_sc_hd__dfxtp_2
XFILLER_23_604 VGND VGND VPWR VPWR sky130_fd_sc_hd__decap_3
X_6842_ _6842_/A _6842_/B VGND VGND VPWR VPWR _7579_/D sky130_fd_sc_hd__and2_2
XFILLER_22_103 VGND VGND VPWR VPWR sky130_fd_sc_hd__decap_3
XFILLER_90_592 VGND VGND VPWR VPWR sky130_fd_sc_hd__decap_3
XFILLER_22_158 VGND VGND VPWR VPWR sky130_fd_sc_hd__decap_3
X_6773_ _6223_/Y _6773_/A1 _6773_/S VGND VGND VPWR VPWR _7546_/D sky130_fd_sc_hd__mux2_2
X_3985_ _6363_/A2 _6363_/A3 _7486_/Q _3984_/X VGND VGND VPWR VPWR _4393_/C sky130_fd_sc_hd__a31oi_4
XFILLER_10_309 VGND VGND VPWR VPWR sky130_fd_sc_hd__fill_2
X_5724_ _5724_/A0 _5724_/A1 _5728_/S VGND VGND VPWR VPWR _7288_/D sky130_fd_sc_hd__mux2_2
X_7325_ clkload7/A _7325_/D place2020/X VGND VGND VPWR VPWR _7325_/Q sky130_fd_sc_hd__dfrtp_2
X_4537_ _7316_/Q _4542_/C VGND VGND VPWR VPWR _4537_/X sky130_fd_sc_hd__xor2_2
X_7256_ _7575_/CLK _7256_/D VGND VGND VPWR VPWR _7256_/Q sky130_fd_sc_hd__dfxtp_2
X_4468_ _4475_/S _4466_/X _4467_/X _4468_/C1 VGND VGND VPWR VPWR _4468_/X sky130_fd_sc_hd__o211a_2
XFILLER_77_29 VGND VGND VPWR VPWR sky130_fd_sc_hd__decap_3
XFILLER_89_169 VGND VGND VPWR VPWR sky130_fd_sc_hd__fill_1
Xplace1086 _4282_/Y VGND VGND VPWR VPWR _4289_/B sky130_fd_sc_hd__buf_6
Xplace1097 _4251_/B VGND VGND VPWR VPWR _6200_/A3 sky130_fd_sc_hd__buf_2
X_7187_ _7217_/CLK _7187_/D VGND VGND VPWR VPWR _7187_/Q sky130_fd_sc_hd__dfxtp_2
X_6207_ _6205_/X _6206_/X _6457_/B1 _6208_/A2 VGND VGND VPWR VPWR _6207_/X sky130_fd_sc_hd__a211o_2
X_6138_ _6138_/A1 _6916_/Q _7252_/Q _6138_/B2 VGND VGND VPWR VPWR _6138_/X sky130_fd_sc_hd__o22a_2
X_4399_ _4399_/A1 _4399_/A2 _4337_/X _4398_/Y VGND VGND VPWR VPWR _4399_/X sky130_fd_sc_hd__o22a_2
XFILLER_45_206 VGND VGND VPWR VPWR sky130_fd_sc_hd__decap_3
XFILLER_58_589 VGND VGND VPWR VPWR sky130_fd_sc_hd__fill_1
X_6069_ _6067_/X _6068_/X _6211_/B1 _6070_/A2 VGND VGND VPWR VPWR _6069_/X sky130_fd_sc_hd__a211o_2
XFILLER_45_228 VGND VGND VPWR VPWR sky130_fd_sc_hd__decap_3
XFILLER_73_559 VGND VGND VPWR VPWR sky130_fd_sc_hd__fill_1
XTAP_TAPCELL_ROW_86_1129 VGND VPWR sky130_fd_sc_hd__tapvpwrvgnd_1
XFILLER_26_55 VGND VGND VPWR VPWR sky130_fd_sc_hd__decap_3
XFILLER_26_475 VGND VGND VPWR VPWR sky130_fd_sc_hd__fill_1
XFILLER_26_88 VGND VGND VPWR VPWR sky130_fd_sc_hd__decap_3
XFILLER_13_136 VGND VGND VPWR VPWR sky130_fd_sc_hd__decap_3
XFILLER_13_169 VGND VGND VPWR VPWR sky130_fd_sc_hd__fill_1
XFILLER_9_129 VGND VGND VPWR VPWR sky130_fd_sc_hd__decap_3
XTAP_TAPCELL_ROW_11_337 VGND VPWR sky130_fd_sc_hd__tapvpwrvgnd_1
XFILLER_3_15 VGND VGND VPWR VPWR sky130_fd_sc_hd__decap_3
XFILLER_68_309 VGND VGND VPWR VPWR sky130_fd_sc_hd__decap_3
XFILLER_49_545 VGND VGND VPWR VPWR sky130_fd_sc_hd__decap_3
XTAP_TAPCELL_ROW_47_713 VGND VPWR sky130_fd_sc_hd__tapvpwrvgnd_1
XFILLER_91_345 VGND VGND VPWR VPWR sky130_fd_sc_hd__fill_1
XTAP_TAPCELL_ROW_19_426 VGND VPWR sky130_fd_sc_hd__tapvpwrvgnd_1
XFILLER_72_592 VGND VGND VPWR VPWR sky130_fd_sc_hd__fill_2
XFILLER_32_445 VGND VGND VPWR VPWR sky130_fd_sc_hd__decap_3
XPHY_EDGE_ROW_17_Left_121 VGND VGND VPWR VPWR sky130_fd_sc_hd__decap_3
XFILLER_32_489 VGND VGND VPWR VPWR sky130_fd_sc_hd__decap_3
X_3770_ _7539_/Q _3812_/A2 _3789_/B1 _7411_/Q VGND VGND VPWR VPWR _3771_/C sky130_fd_sc_hd__a22oi_2
X_5440_ _5440_/A0 _5684_/A1 _5454_/S VGND VGND VPWR VPWR _7157_/D sky130_fd_sc_hd__mux2_2
XFILLER_66_3 VGND VGND VPWR VPWR sky130_fd_sc_hd__decap_3
XFILLER_8_184 VGND VGND VPWR VPWR sky130_fd_sc_hd__decap_3
XTAP_TAPCELL_ROW_74_1000 VGND VPWR sky130_fd_sc_hd__tapvpwrvgnd_1
XFILLER_99_445 VGND VGND VPWR VPWR sky130_fd_sc_hd__decap_3
XPHY_EDGE_ROW_26_Left_130 VGND VGND VPWR VPWR sky130_fd_sc_hd__decap_3
X_7110_ _7279_/CLK _7110_/D VGND VGND VPWR VPWR _7110_/Q sky130_fd_sc_hd__dfxtp_2
X_7041_ _7266_/CLK _7041_/D VGND VGND VPWR VPWR _7041_/Q sky130_fd_sc_hd__dfxtp_2
X_4253_ _4253_/A _4253_/B _4253_/C _4245_/Y VGND VGND VPWR VPWR _4253_/X sky130_fd_sc_hd__or4b_4
X_4184_ _4184_/A _4184_/B _4184_/C _4184_/D VGND VGND VPWR VPWR _4184_/Y sky130_fd_sc_hd__nor4_2
XFILLER_27_228 VGND VGND VPWR VPWR sky130_fd_sc_hd__fill_2
XFILLER_67_386 VGND VGND VPWR VPWR sky130_fd_sc_hd__decap_3
XFILLER_42_209 VGND VGND VPWR VPWR sky130_fd_sc_hd__decap_3
XFILLER_23_401 VGND VGND VPWR VPWR sky130_fd_sc_hd__fill_2
XFILLER_35_272 VGND VGND VPWR VPWR sky130_fd_sc_hd__decap_3
XFILLER_23_434 VGND VGND VPWR VPWR sky130_fd_sc_hd__decap_3
XFILLER_50_242 VGND VGND VPWR VPWR sky130_fd_sc_hd__fill_2
X_6756_ _6181_/X _6756_/A1 _6765_/S VGND VGND VPWR VPWR _7538_/D sky130_fd_sc_hd__mux2_4
X_3968_ _7488_/Q _3968_/B VGND VGND VPWR VPWR _3969_/C sky130_fd_sc_hd__nand2_2
X_5707_ _5707_/A0 _5707_/A1 _5711_/S VGND VGND VPWR VPWR _7280_/D sky130_fd_sc_hd__mux2_2
X_6687_ _6687_/A0 _6162_/X _6687_/S VGND VGND VPWR VPWR _7505_/D sky130_fd_sc_hd__mux2_4
X_3899_ _7429_/Q _3490_/X _3923_/B1 _7333_/Q _3898_/X VGND VGND VPWR VPWR _3899_/X
+ sky130_fd_sc_hd__a221o_2
X_7308_ _7608_/CLK _7308_/D place2049/X VGND VGND VPWR VPWR _7308_/Q sky130_fd_sc_hd__dfrtp_2
XFILLER_2_349 VGND VGND VPWR VPWR sky130_fd_sc_hd__fill_1
X_7239_ _7272_/CLK _7239_/D VGND VGND VPWR VPWR _7239_/Q sky130_fd_sc_hd__dfxtp_2
XTAP_TAPCELL_ROW_92_1188 VGND VPWR sky130_fd_sc_hd__tapvpwrvgnd_1
XFILLER_18_206 VGND VGND VPWR VPWR sky130_fd_sc_hd__decap_3
XFILLER_73_301 VGND VGND VPWR VPWR sky130_fd_sc_hd__fill_2
XFILLER_18_239 VGND VGND VPWR VPWR sky130_fd_sc_hd__decap_3
XFILLER_58_397 VGND VGND VPWR VPWR sky130_fd_sc_hd__decap_3
XFILLER_33_209 VGND VGND VPWR VPWR sky130_fd_sc_hd__decap_3
XFILLER_41_231 VGND VGND VPWR VPWR sky130_fd_sc_hd__decap_3
XFILLER_53_42 VGND VGND VPWR VPWR sky130_fd_sc_hd__decap_3
XFILLER_41_264 VGND VGND VPWR VPWR sky130_fd_sc_hd__decap_3
XFILLER_53_86 VGND VGND VPWR VPWR sky130_fd_sc_hd__decap_3
XTAP_TAPCELL_ROW_52_771 VGND VPWR sky130_fd_sc_hd__tapvpwrvgnd_1
XTAP_TAPCELL_ROW_24_473 VGND VPWR sky130_fd_sc_hd__tapvpwrvgnd_1
XTAP_TAPCELL_ROW_101_1284 VGND VPWR sky130_fd_sc_hd__tapvpwrvgnd_1
XFILLER_5_110 VGND VGND VPWR VPWR sky130_fd_sc_hd__fill_2
XFILLER_5_132 VGND VGND VPWR VPWR sky130_fd_sc_hd__decap_3
XFILLER_5_165 VGND VGND VPWR VPWR sky130_fd_sc_hd__decap_3
XFILLER_49_397 VGND VGND VPWR VPWR sky130_fd_sc_hd__decap_3
XFILLER_32_220 VGND VGND VPWR VPWR sky130_fd_sc_hd__fill_1
XFILLER_32_253 VGND VGND VPWR VPWR sky130_fd_sc_hd__decap_3
X_7590_ clkload5/A _7590_/D place2062/X VGND VGND VPWR VPWR _7590_/Q sky130_fd_sc_hd__dfrtp_2
X_3822_ _3952_/A1 _3498_/Y _7373_/Q _3854_/A2 _7565_/Q VGND VGND VPWR VPWR _3822_/X
+ sky130_fd_sc_hd__a32o_2
XFILLER_20_448 VGND VGND VPWR VPWR sky130_fd_sc_hd__fill_1
XFILLER_32_286 VGND VGND VPWR VPWR sky130_fd_sc_hd__decap_3
X_6541_ _6541_/A0 _6162_/X _6541_/S VGND VGND VPWR VPWR _7441_/D sky130_fd_sc_hd__mux2_4
X_3753_ _3698_/B _4237_/C _3746_/X _3753_/A4 _3752_/X VGND VGND VPWR VPWR _4236_/A
+ sky130_fd_sc_hd__o41a_4
X_6472_ _4629_/S _6471_/Y _6177_/Y _5821_/X VGND VGND VPWR VPWR _6472_/X sky130_fd_sc_hd__o22a_2
X_3684_ _3738_/A _3738_/B _4261_/C _3680_/Y _3683_/Y VGND VGND VPWR VPWR _4274_/B
+ sky130_fd_sc_hd__o41a_2
X_5423_ _5423_/A0 _5606_/A1 _5423_/S VGND VGND VPWR VPWR _7150_/D sky130_fd_sc_hd__mux2_2
X_4305_ _4305_/A _4305_/B VGND VGND VPWR VPWR _4306_/C sky130_fd_sc_hd__and2_2
XFILLER_59_128 VGND VGND VPWR VPWR sky130_fd_sc_hd__decap_3
XFILLER_101_247 VGND VGND VPWR VPWR sky130_fd_sc_hd__fill_1
XFILLER_4_91 VGND VGND VPWR VPWR sky130_fd_sc_hd__decap_3
X_7024_ _7241_/CLK _7024_/D VGND VGND VPWR VPWR _7024_/Q sky130_fd_sc_hd__dfxtp_2
X_4236_ _4236_/A _4236_/B _4236_/C _4236_/D VGND VGND VPWR VPWR _4236_/X sky130_fd_sc_hd__or4_4
XFILLER_28_515 VGND VGND VPWR VPWR sky130_fd_sc_hd__decap_3
X_4167_ _4148_/A _4148_/B _3895_/Y _3896_/X _3916_/Y VGND VGND VPWR VPWR _4168_/B
+ sky130_fd_sc_hd__a2111oi_2
XFILLER_28_526 VGND VGND VPWR VPWR sky130_fd_sc_hd__decap_3
XFILLER_55_345 VGND VGND VPWR VPWR sky130_fd_sc_hd__decap_3
X_4098_ _4099_/A _4098_/A2 _3973_/Y _4097_/X VGND VGND VPWR VPWR _4098_/Y sky130_fd_sc_hd__o211ai_2
XFILLER_43_529 VGND VGND VPWR VPWR sky130_fd_sc_hd__decap_3
XFILLER_23_231 VGND VGND VPWR VPWR sky130_fd_sc_hd__decap_3
XFILLER_23_12 VGND VGND VPWR VPWR sky130_fd_sc_hd__decap_3
XFILLER_23_264 VGND VGND VPWR VPWR sky130_fd_sc_hd__decap_3
X_6739_ _6080_/X _6739_/A1 _6773_/S VGND VGND VPWR VPWR _7530_/D sky130_fd_sc_hd__mux2_2
XTAP_TAPCELL_ROW_21_443 VGND VPWR sky130_fd_sc_hd__tapvpwrvgnd_1
XFILLER_23_89 VGND VGND VPWR VPWR sky130_fd_sc_hd__decap_3
XFILLER_99_16 VGND VGND VPWR VPWR sky130_fd_sc_hd__decap_3
XTAP_TAPCELL_ROW_94_1206 VGND VPWR sky130_fd_sc_hd__tapvpwrvgnd_1
XFILLER_2_124 VGND VGND VPWR VPWR sky130_fd_sc_hd__fill_1
XFILLER_58_150 VGND VGND VPWR VPWR sky130_fd_sc_hd__decap_3
XFILLER_19_548 VGND VGND VPWR VPWR sky130_fd_sc_hd__decap_3
XFILLER_46_312 VGND VGND VPWR VPWR sky130_fd_sc_hd__fill_2
XFILLER_46_334 VGND VGND VPWR VPWR sky130_fd_sc_hd__decap_3
XFILLER_86_481 VGND VGND VPWR VPWR sky130_fd_sc_hd__fill_1
XFILLER_19_559 VGND VGND VPWR VPWR sky130_fd_sc_hd__fill_1
XTAP_TAPCELL_ROW_29_532 VGND VPWR sky130_fd_sc_hd__tapvpwrvgnd_1
XFILLER_27_570 VGND VGND VPWR VPWR sky130_fd_sc_hd__decap_3
XFILLER_61_315 VGND VGND VPWR VPWR sky130_fd_sc_hd__decap_3
XFILLER_73_197 VGND VGND VPWR VPWR sky130_fd_sc_hd__fill_2
XTAP_TAPCELL_ROW_103_1313 VGND VPWR sky130_fd_sc_hd__tapvpwrvgnd_1
XTAP_TAPCELL_ROW_103_1302 VGND VPWR sky130_fd_sc_hd__tapvpwrvgnd_1
XFILLER_14_242 VGND VGND VPWR VPWR sky130_fd_sc_hd__decap_3
XFILLER_14_253 VGND VGND VPWR VPWR sky130_fd_sc_hd__fill_1
XFILLER_6_430 VGND VGND VPWR VPWR sky130_fd_sc_hd__decap_3
Xplace1608 place1609/X VGND VGND VPWR VPWR _3670_/A sky130_fd_sc_hd__buf_4
XFILLER_50_6 VGND VGND VPWR VPWR sky130_fd_sc_hd__fill_1
Xplace1619 _6518_/S VGND VGND VPWR VPWR _6569_/S sky130_fd_sc_hd__buf_2
XFILLER_89_93 VGND VGND VPWR VPWR sky130_fd_sc_hd__fill_2
X_5070_ _5070_/A0 _5709_/A1 _5085_/S VGND VGND VPWR VPWR _7001_/D sky130_fd_sc_hd__mux2_2
XFILLER_37_323 VGND VGND VPWR VPWR sky130_fd_sc_hd__decap_3
XFILLER_37_356 VGND VGND VPWR VPWR sky130_fd_sc_hd__fill_2
XFILLER_37_367 VGND VGND VPWR VPWR sky130_fd_sc_hd__decap_3
XFILLER_49_194 VGND VGND VPWR VPWR sky130_fd_sc_hd__fill_2
XFILLER_25_529 VGND VGND VPWR VPWR sky130_fd_sc_hd__decap_3
X_5972_ _6213_/A1 _7004_/Q _6976_/Q _6213_/B2 VGND VGND VPWR VPWR _5972_/Y sky130_fd_sc_hd__o22ai_2
XFILLER_64_197 VGND VGND VPWR VPWR sky130_fd_sc_hd__fill_1
XTAP_TAPCELL_ROW_63_888 VGND VPWR sky130_fd_sc_hd__tapvpwrvgnd_1
XFILLER_20_212 VGND VGND VPWR VPWR sky130_fd_sc_hd__decap_3
XFILLER_33_584 VGND VGND VPWR VPWR sky130_fd_sc_hd__fill_2
X_7573_ _7577_/CLK _7573_/D place2013/X VGND VGND VPWR VPWR _7573_/Q sky130_fd_sc_hd__dfrtp_2
X_4785_ _4785_/A0 _5614_/A1 _4806_/S VGND VGND VPWR VPWR _6873_/D sky130_fd_sc_hd__mux2_2
X_3805_ _3805_/A _3805_/B _3805_/C _3805_/D VGND VGND VPWR VPWR _3805_/Y sky130_fd_sc_hd__nand4_2
XFILLER_20_289 VGND VGND VPWR VPWR sky130_fd_sc_hd__decap_3
X_6524_ _6524_/A0 _6078_/X _6529_/S VGND VGND VPWR VPWR _7433_/D sky130_fd_sc_hd__mux2_2
X_3736_ _7514_/Q _3881_/B _3757_/B1 _7450_/Q _3735_/X VGND VGND VPWR VPWR _3736_/X
+ sky130_fd_sc_hd__a221o_2
X_6455_ _6455_/A1 _7038_/Q _6954_/Q _6455_/B2 VGND VGND VPWR VPWR _6455_/X sky130_fd_sc_hd__o22a_2
X_3667_ _7317_/Q _4237_/A _3667_/B1 VGND VGND VPWR VPWR _3667_/Y sky130_fd_sc_hd__a21oi_2
X_6386_ _6694_/A0 _6410_/A2 _6410_/A3 _6410_/B1 _7412_/Q VGND VGND VPWR VPWR _6386_/X
+ sky130_fd_sc_hd__a32o_2
X_5406_ _5406_/A0 _5711_/A1 _5410_/S VGND VGND VPWR VPWR _7142_/D sky130_fd_sc_hd__mux2_2
X_3598_ _3598_/A _3598_/B _3598_/C VGND VGND VPWR VPWR _3598_/X sky130_fd_sc_hd__and3_4
Xhold2800 _7512_/Q VGND VGND VPWR VPWR _6702_/A0 sky130_fd_sc_hd__dlygate4sd3_1
Xhold2811 _7004_/Q VGND VGND VPWR VPWR _5076_/A0 sky130_fd_sc_hd__dlygate4sd3_1
Xhold2822 _7557_/Q VGND VGND VPWR VPWR _6798_/B sky130_fd_sc_hd__dlygate4sd3_1
X_5268_ _5268_/A0 _5707_/A1 _5293_/S VGND VGND VPWR VPWR _7084_/D sky130_fd_sc_hd__mux2_2
XFILLER_47_109 VGND VGND VPWR VPWR sky130_fd_sc_hd__decap_3
Xhold2833 _7338_/Q VGND VGND VPWR VPWR _6262_/B sky130_fd_sc_hd__dlygate4sd3_1
Xhold2844 _7578_/Q VGND VGND VPWR VPWR _6840_/B sky130_fd_sc_hd__dlygate4sd3_1
Xhold2855 _7572_/Q VGND VGND VPWR VPWR _6828_/B sky130_fd_sc_hd__dlygate4sd3_1
Xhold2866 _7579_/Q VGND VGND VPWR VPWR _6842_/B sky130_fd_sc_hd__dlygate4sd3_1
X_7007_ _7287_/CLK _7007_/D VGND VGND VPWR VPWR _7007_/Q sky130_fd_sc_hd__dfxtp_2
X_4219_ _4193_/Y _4194_/A _4209_/X VGND VGND VPWR VPWR _4219_/Y sky130_fd_sc_hd__o21bai_4
XFILLER_18_12 VGND VGND VPWR VPWR sky130_fd_sc_hd__decap_3
XFILLER_28_312 VGND VGND VPWR VPWR sky130_fd_sc_hd__decap_3
XFILLER_56_610 VGND VGND VPWR VPWR sky130_fd_sc_hd__fill_2
Xhold2877 _7479_/Q VGND VGND VPWR VPWR _6632_/A0 sky130_fd_sc_hd__dlygate4sd3_1
Xhold2888 _7353_/Q VGND VGND VPWR VPWR _6294_/B sky130_fd_sc_hd__dlygate4sd3_1
Xhold2899 _7459_/Q VGND VGND VPWR VPWR _6590_/A0 sky130_fd_sc_hd__dlygate4sd3_1
XFILLER_18_45 VGND VGND VPWR VPWR sky130_fd_sc_hd__fill_2
XFILLER_55_164 VGND VGND VPWR VPWR sky130_fd_sc_hd__decap_3
XFILLER_43_337 VGND VGND VPWR VPWR sky130_fd_sc_hd__decap_3
XFILLER_24_540 VGND VGND VPWR VPWR sky130_fd_sc_hd__fill_1
XFILLER_24_551 VGND VGND VPWR VPWR sky130_fd_sc_hd__decap_3
XFILLER_70_178 VGND VGND VPWR VPWR sky130_fd_sc_hd__decap_3
XFILLER_11_212 VGND VGND VPWR VPWR sky130_fd_sc_hd__fill_2
XFILLER_11_223 VGND VGND VPWR VPWR sky130_fd_sc_hd__fill_1
XFILLER_34_88 VGND VGND VPWR VPWR sky130_fd_sc_hd__decap_3
XFILLER_11_234 VGND VGND VPWR VPWR sky130_fd_sc_hd__decap_3
XFILLER_50_65 VGND VGND VPWR VPWR sky130_fd_sc_hd__decap_3
XFILLER_3_422 VGND VGND VPWR VPWR sky130_fd_sc_hd__decap_3
XFILLER_78_234 VGND VGND VPWR VPWR sky130_fd_sc_hd__fill_2
XFILLER_78_245 VGND VGND VPWR VPWR sky130_fd_sc_hd__decap_3
XFILLER_66_418 VGND VGND VPWR VPWR sky130_fd_sc_hd__fill_2
XFILLER_15_9 VGND VGND VPWR VPWR sky130_fd_sc_hd__fill_1
XTAP_TAPCELL_ROW_6_282 VGND VPWR sky130_fd_sc_hd__tapvpwrvgnd_1
XFILLER_46_120 VGND VGND VPWR VPWR sky130_fd_sc_hd__decap_3
XFILLER_19_389 VGND VGND VPWR VPWR sky130_fd_sc_hd__decap_3
XFILLER_34_315 VGND VGND VPWR VPWR sky130_fd_sc_hd__decap_3
XFILLER_46_186 VGND VGND VPWR VPWR sky130_fd_sc_hd__decap_3
XFILLER_46_197 VGND VGND VPWR VPWR sky130_fd_sc_hd__decap_3
XFILLER_61_178 VGND VGND VPWR VPWR sky130_fd_sc_hd__decap_3
XFILLER_91_94 VGND VGND VPWR VPWR sky130_fd_sc_hd__fill_2
XTAP_TAPCELL_ROW_60_858 VGND VPWR sky130_fd_sc_hd__tapvpwrvgnd_1
X_4570_ _4559_/X _4560_/Y _4571_/B1 _4569_/X VGND VGND VPWR VPWR _7320_/D sky130_fd_sc_hd__o2bb2a_2
X_3521_ _3472_/Y _3475_/B _3414_/B VGND VGND VPWR VPWR _3521_/Y sky130_fd_sc_hd__a21oi_4
Xplace1405 _3809_/A VGND VGND VPWR VPWR _4212_/A sky130_fd_sc_hd__buf_2
Xplace1416 _6412_/B1 VGND VGND VPWR VPWR _6411_/B1 sky130_fd_sc_hd__buf_2
Xplace1427 _4232_/D VGND VGND VPWR VPWR _4562_/D1 sky130_fd_sc_hd__buf_2
Xplace1438 _3957_/X VGND VGND VPWR VPWR _4579_/A sky130_fd_sc_hd__buf_2
Xplace1449 _3855_/Y VGND VGND VPWR VPWR _4662_/B1 sky130_fd_sc_hd__buf_2
X_3452_ _3826_/A _4510_/B _3826_/C _3455_/A _5839_/A2 VGND VGND VPWR VPWR _3541_/A
+ sky130_fd_sc_hd__o32a_4
XFILLER_103_309 VGND VGND VPWR VPWR sky130_fd_sc_hd__fill_2
X_6171_ _6947_/Q _6171_/A2 _6171_/B1 _6975_/Q _6170_/X VGND VGND VPWR VPWR _6171_/X
+ sky130_fd_sc_hd__o221a_2
XFILLER_69_212 VGND VGND VPWR VPWR sky130_fd_sc_hd__fill_1
XFILLER_69_223 VGND VGND VPWR VPWR sky130_fd_sc_hd__fill_1
XFILLER_69_234 VGND VGND VPWR VPWR sky130_fd_sc_hd__decap_3
XFILLER_57_418 VGND VGND VPWR VPWR sky130_fd_sc_hd__decap_3
X_5053_ _5053_/A0 _4650_/X _5059_/S VGND VGND VPWR VPWR _6993_/D sky130_fd_sc_hd__mux2_2
XTAP_TAPCELL_ROW_68_936 VGND VPWR sky130_fd_sc_hd__tapvpwrvgnd_1
XFILLER_37_142 VGND VGND VPWR VPWR sky130_fd_sc_hd__decap_3
X_4004_ _7425_/Q _4004_/A2 _4004_/B1 _7329_/Q _4003_/X VGND VGND VPWR VPWR _4004_/X
+ sky130_fd_sc_hd__a221o_2
XFILLER_37_164 VGND VGND VPWR VPWR sky130_fd_sc_hd__decap_3
XFILLER_37_175 VGND VGND VPWR VPWR sky130_fd_sc_hd__fill_2
XPHY_EDGE_ROW_9_Left_113 VGND VGND VPWR VPWR sky130_fd_sc_hd__decap_3
XFILLER_52_145 VGND VGND VPWR VPWR sky130_fd_sc_hd__decap_3
X_5955_ _5950_/X _5765_/X _6048_/A _5954_/X VGND VGND VPWR VPWR _5962_/B sky130_fd_sc_hd__o22a_2
XFILLER_21_532 VGND VGND VPWR VPWR sky130_fd_sc_hd__decap_3
XFILLER_21_576 VGND VGND VPWR VPWR sky130_fd_sc_hd__decap_3
XFILLER_21_598 VGND VGND VPWR VPWR sky130_fd_sc_hd__decap_3
X_7556_ clkload9/A _7556_/D place2033/X VGND VGND VPWR VPWR _7556_/Q sky130_fd_sc_hd__dfrtp_2
X_4768_ _4720_/C _4613_/X _6010_/D _4767_/X VGND VGND VPWR VPWR _4768_/Y sky130_fd_sc_hd__a31oi_2
XFILLER_20_24 VGND VGND VPWR VPWR sky130_fd_sc_hd__decap_3
X_7487_ clkload7/A _7487_/D place2026/X VGND VGND VPWR VPWR _7487_/Q sky130_fd_sc_hd__dfrtp_2
X_6507_ _6507_/A1 _7018_/Q _6934_/Q _6507_/B2 VGND VGND VPWR VPWR _6507_/X sky130_fd_sc_hd__o22a_2
X_4699_ _4733_/B1 _4755_/A _4727_/D _4697_/X _4698_/Y VGND VGND VPWR VPWR _4699_/X
+ sky130_fd_sc_hd__o311a_2
X_3719_ _7353_/Q _3781_/B1 _3718_/X VGND VGND VPWR VPWR _3719_/Y sky130_fd_sc_hd__a21oi_2
XFILLER_20_68 VGND VGND VPWR VPWR sky130_fd_sc_hd__decap_3
X_6438_ _6436_/X _6437_/X _4639_/Y VGND VGND VPWR VPWR _6438_/X sky130_fd_sc_hd__a21o_2
Xplace1972 _3939_/B1 VGND VGND VPWR VPWR _4503_/C sky130_fd_sc_hd__buf_2
Xplace1961 _7323_/Q VGND VGND VPWR VPWR _7581_/D sky130_fd_sc_hd__buf_2
Xplace1950 _7371_/Q VGND VGND VPWR VPWR _3842_/A sky130_fd_sc_hd__buf_2
Xplace1994 _4337_/B VGND VGND VPWR VPWR _4448_/C sky130_fd_sc_hd__buf_2
Xplace1983 _7295_/Q VGND VGND VPWR VPWR _3443_/C sky130_fd_sc_hd__buf_6
X_6369_ _6369_/A1 _6412_/A2 _6412_/A3 _6412_/B1 _7399_/Q VGND VGND VPWR VPWR _6369_/X
+ sky130_fd_sc_hd__a32o_2
XFILLER_0_458 VGND VGND VPWR VPWR sky130_fd_sc_hd__fill_1
XFILLER_102_353 VGND VGND VPWR VPWR sky130_fd_sc_hd__fill_2
XFILLER_48_418 VGND VGND VPWR VPWR sky130_fd_sc_hd__fill_2
Xhold2630 _7113_/Q VGND VGND VPWR VPWR _5342_/A0 sky130_fd_sc_hd__dlygate4sd3_1
Xhold2641 _7277_/Q VGND VGND VPWR VPWR _5701_/A0 sky130_fd_sc_hd__dlygate4sd3_1
Xhold2652 _7128_/Q VGND VGND VPWR VPWR _5376_/A0 sky130_fd_sc_hd__dlygate4sd3_1
Xhold2663 _7043_/Q VGND VGND VPWR VPWR _5162_/A0 sky130_fd_sc_hd__dlygate4sd3_1
Xhold2674 _7143_/Q VGND VGND VPWR VPWR _5408_/A0 sky130_fd_sc_hd__dlygate4sd3_1
XFILLER_56_440 VGND VGND VPWR VPWR sky130_fd_sc_hd__decap_3
Xhold2685 _7083_/Q VGND VGND VPWR VPWR _5265_/A0 sky130_fd_sc_hd__dlygate4sd3_1
Xhold2696 _7052_/Q VGND VGND VPWR VPWR _5181_/A0 sky130_fd_sc_hd__dlygate4sd3_1
XTAP_TAPCELL_ROW_3_252 VGND VPWR sky130_fd_sc_hd__tapvpwrvgnd_1
XFILLER_28_164 VGND VGND VPWR VPWR sky130_fd_sc_hd__decap_3
XFILLER_16_348 VGND VGND VPWR VPWR sky130_fd_sc_hd__decap_3
XFILLER_28_197 VGND VGND VPWR VPWR sky130_fd_sc_hd__decap_3
XFILLER_43_101 VGND VGND VPWR VPWR sky130_fd_sc_hd__decap_3
XFILLER_56_495 VGND VGND VPWR VPWR sky130_fd_sc_hd__decap_3
XFILLER_83_281 VGND VGND VPWR VPWR sky130_fd_sc_hd__fill_1
XFILLER_24_392 VGND VGND VPWR VPWR sky130_fd_sc_hd__decap_3
XFILLER_61_31 VGND VGND VPWR VPWR sky130_fd_sc_hd__decap_3
XANTENNA_8 _6198_/X VGND VGND VPWR VPWR sky130_fd_sc_hd__diode_2
XFILLER_6_26 VGND VGND VPWR VPWR sky130_fd_sc_hd__fill_2
XFILLER_6_59 VGND VGND VPWR VPWR sky130_fd_sc_hd__fill_2
XFILLER_3_252 VGND VGND VPWR VPWR sky130_fd_sc_hd__fill_2
XFILLER_3_274 VGND VGND VPWR VPWR sky130_fd_sc_hd__decap_3
XFILLER_3_285 VGND VGND VPWR VPWR sky130_fd_sc_hd__decap_3
XFILLER_47_440 VGND VGND VPWR VPWR sky130_fd_sc_hd__decap_3
XFILLER_86_94 VGND VGND VPWR VPWR sky130_fd_sc_hd__decap_3
XTAP_TAPCELL_ROW_65_906 VGND VPWR sky130_fd_sc_hd__tapvpwrvgnd_1
XFILLER_19_142 VGND VGND VPWR VPWR sky130_fd_sc_hd__decap_3
XFILLER_47_462 VGND VGND VPWR VPWR sky130_fd_sc_hd__decap_3
XTAP_TAPCELL_ROW_37_608 VGND VPWR sky130_fd_sc_hd__tapvpwrvgnd_1
XFILLER_19_175 VGND VGND VPWR VPWR sky130_fd_sc_hd__decap_3
XFILLER_62_421 VGND VGND VPWR VPWR sky130_fd_sc_hd__decap_3
XFILLER_22_307 VGND VGND VPWR VPWR sky130_fd_sc_hd__fill_1
XFILLER_34_167 VGND VGND VPWR VPWR sky130_fd_sc_hd__decap_3
XFILLER_15_370 VGND VGND VPWR VPWR sky130_fd_sc_hd__decap_3
XFILLER_22_329 VGND VGND VPWR VPWR sky130_fd_sc_hd__decap_3
XFILLER_62_498 VGND VGND VPWR VPWR sky130_fd_sc_hd__fill_1
XFILLER_96_3 VGND VGND VPWR VPWR sky130_fd_sc_hd__decap_3
X_5740_ _7581_/D _4675_/A _6565_/B _5739_/X VGND VGND VPWR VPWR _7323_/D sky130_fd_sc_hd__a31o_2
XTAP_TAPCELL_ROW_73_994 VGND VPWR sky130_fd_sc_hd__tapvpwrvgnd_1
XTAP_TAPCELL_ROW_45_696 VGND VPWR sky130_fd_sc_hd__tapvpwrvgnd_1
XTAP_TAPCELL_ROW_17_398 VGND VPWR sky130_fd_sc_hd__tapvpwrvgnd_1
X_7410_ _7507_/CLK _7410_/D place2048/X VGND VGND VPWR VPWR _7410_/Q sky130_fd_sc_hd__dfrtp_2
X_5671_ _5671_/A _5671_/B _5671_/C VGND VGND VPWR VPWR _5728_/S sky130_fd_sc_hd__and3_2
X_4622_ _4675_/B _6437_/B1 _3905_/C VGND VGND VPWR VPWR _4622_/Y sky130_fd_sc_hd__o21ai_2
X_7341_ _7579_/CLK _7341_/D place2044/X VGND VGND VPWR VPWR _7341_/Q sky130_fd_sc_hd__dfrtp_2
X_4553_ _7318_/Q _4558_/B _4558_/D VGND VGND VPWR VPWR _4553_/Y sky130_fd_sc_hd__nand3_2
XTAP_TAPCELL_ROW_77_1031 VGND VPWR sky130_fd_sc_hd__tapvpwrvgnd_1
Xplace1202 _4905_/X VGND VGND VPWR VPWR _4958_/S sky130_fd_sc_hd__buf_2
Xplace1213 _4672_/S VGND VGND VPWR VPWR _4665_/S sky130_fd_sc_hd__buf_2
Xplace1224 _4020_/Y VGND VGND VPWR VPWR _6436_/C sky130_fd_sc_hd__buf_2
X_7272_ _7272_/CLK _7272_/D VGND VGND VPWR VPWR _7272_/Q sky130_fd_sc_hd__dfxtp_2
X_4484_ _4482_/X _4483_/X _4559_/A VGND VGND VPWR VPWR _4484_/Y sky130_fd_sc_hd__a21oi_2
X_3504_ _3504_/A _3981_/A VGND VGND VPWR VPWR _3504_/Y sky130_fd_sc_hd__nor2_2
Xplace1235 _5423_/S VGND VGND VPWR VPWR _5391_/S sky130_fd_sc_hd__buf_2
Xplace1246 _4114_/Y VGND VGND VPWR VPWR _6208_/A2 sky130_fd_sc_hd__buf_2
Xplace1257 _6070_/A2 VGND VGND VPWR VPWR _6457_/C1 sky130_fd_sc_hd__buf_2
Xplace1268 _6451_/B1 VGND VGND VPWR VPWR _6455_/A1 sky130_fd_sc_hd__buf_2
X_6223_ _6221_/Y _6566_/A2 _6222_/Y VGND VGND VPWR VPWR _6223_/Y sky130_fd_sc_hd__a21oi_2
X_3435_ _3500_/B _3435_/A2 _3433_/Y _4023_/A VGND VGND VPWR VPWR _3435_/Y sky130_fd_sc_hd__o211ai_4
Xplace1279 _5960_/B2 VGND VGND VPWR VPWR _6473_/A1 sky130_fd_sc_hd__buf_2
XFILLER_97_340 VGND VGND VPWR VPWR sky130_fd_sc_hd__fill_1
X_6154_ _6154_/A1 _6917_/Q _7253_/Q _6154_/B2 VGND VGND VPWR VPWR _6154_/X sky130_fd_sc_hd__o22a_2
X_6085_ _4187_/X _6161_/A2 _6084_/Y _6184_/C1 VGND VGND VPWR VPWR _6085_/X sky130_fd_sc_hd__a211o_4
XFILLER_85_557 VGND VGND VPWR VPWR sky130_fd_sc_hd__decap_3
X_5036_ _5036_/A0 _5221_/A1 _5059_/S VGND VGND VPWR VPWR _6985_/D sky130_fd_sc_hd__mux2_2
XTAP_TAPCELL_ROW_0_211 VGND VPWR sky130_fd_sc_hd__tapvpwrvgnd_1
XFILLER_65_281 VGND VGND VPWR VPWR sky130_fd_sc_hd__fill_2
XTAP_TAPCELL_ROW_0_222 VGND VPWR sky130_fd_sc_hd__tapvpwrvgnd_1
XFILLER_80_251 VGND VGND VPWR VPWR sky130_fd_sc_hd__fill_1
X_6987_ _7266_/CLK _6987_/D VGND VGND VPWR VPWR _6987_/Q sky130_fd_sc_hd__dfxtp_2
XFILLER_25_189 VGND VGND VPWR VPWR sky130_fd_sc_hd__decap_3
XFILLER_80_284 VGND VGND VPWR VPWR sky130_fd_sc_hd__fill_2
X_5938_ _5935_/X _5937_/X _5778_/X VGND VGND VPWR VPWR _5939_/B sky130_fd_sc_hd__a21oi_2
XFILLER_21_340 VGND VGND VPWR VPWR sky130_fd_sc_hd__decap_3
XFILLER_21_351 VGND VGND VPWR VPWR sky130_fd_sc_hd__decap_3
XFILLER_21_384 VGND VGND VPWR VPWR sky130_fd_sc_hd__fill_1
X_7608_ _7608_/CLK _7608_/D place2049/X VGND VGND VPWR VPWR _7608_/Q sky130_fd_sc_hd__dfrtp_2
X_7539_ _7606_/CLK _7539_/D place2068/X VGND VGND VPWR VPWR _7539_/Q sky130_fd_sc_hd__dfrtp_2
XTAP_TAPCELL_ROW_8_311 VGND VPWR sky130_fd_sc_hd__tapvpwrvgnd_1
Xplace1780 _6229_/A1 VGND VGND VPWR VPWR _6559_/A1 sky130_fd_sc_hd__buf_2
XFILLER_0_222 VGND VGND VPWR VPWR sky130_fd_sc_hd__fill_2
Xplace1791 _3519_/B VGND VGND VPWR VPWR _3559_/A1 sky130_fd_sc_hd__buf_2
XFILLER_102_150 VGND VGND VPWR VPWR sky130_fd_sc_hd__fill_2
XFILLER_48_248 VGND VGND VPWR VPWR sky130_fd_sc_hd__decap_3
XFILLER_48_259 VGND VGND VPWR VPWR sky130_fd_sc_hd__decap_3
Xhold2482 _7154_/Q VGND VGND VPWR VPWR _5433_/A0 sky130_fd_sc_hd__dlygate4sd3_1
Xhold2471 _6854_/Q VGND VGND VPWR VPWR _4658_/A0 sky130_fd_sc_hd__dlygate4sd3_1
Xhold2460 _6962_/Q VGND VGND VPWR VPWR _4986_/A0 sky130_fd_sc_hd__dlygate4sd3_1
Xhold2493 _7013_/Q VGND VGND VPWR VPWR _5097_/A0 sky130_fd_sc_hd__dlygate4sd3_1
XFILLER_44_421 VGND VGND VPWR VPWR sky130_fd_sc_hd__fill_2
XFILLER_44_432 VGND VGND VPWR VPWR sky130_fd_sc_hd__fill_2
XFILLER_16_156 VGND VGND VPWR VPWR sky130_fd_sc_hd__fill_1
XFILLER_71_240 VGND VGND VPWR VPWR sky130_fd_sc_hd__decap_3
XFILLER_71_262 VGND VGND VPWR VPWR sky130_fd_sc_hd__decap_3
XFILLER_71_284 VGND VGND VPWR VPWR sky130_fd_sc_hd__fill_2
XFILLER_31_148 VGND VGND VPWR VPWR sky130_fd_sc_hd__decap_3
XTAP_TAPCELL_ROW_70_953 VGND VPWR sky130_fd_sc_hd__tapvpwrvgnd_1
XFILLER_8_300 VGND VGND VPWR VPWR sky130_fd_sc_hd__decap_3
XTAP_TAPCELL_ROW_42_666 VGND VPWR sky130_fd_sc_hd__tapvpwrvgnd_1
XTAP_TAPCELL_ROW_14_368 VGND VPWR sky130_fd_sc_hd__tapvpwrvgnd_1
XFILLER_79_340 VGND VGND VPWR VPWR sky130_fd_sc_hd__fill_2
XFILLER_11_3 VGND VGND VPWR VPWR sky130_fd_sc_hd__decap_3
XFILLER_39_237 VGND VGND VPWR VPWR sky130_fd_sc_hd__decap_3
XFILLER_54_218 VGND VGND VPWR VPWR sky130_fd_sc_hd__decap_3
XFILLER_35_432 VGND VGND VPWR VPWR sky130_fd_sc_hd__decap_3
XFILLER_94_398 VGND VGND VPWR VPWR sky130_fd_sc_hd__fill_2
X_6910_ _7247_/CLK _6910_/D VGND VGND VPWR VPWR _6910_/Q sky130_fd_sc_hd__dfxtp_2
XFILLER_35_465 VGND VGND VPWR VPWR sky130_fd_sc_hd__fill_1
XFILLER_62_251 VGND VGND VPWR VPWR sky130_fd_sc_hd__fill_1
XFILLER_35_476 VGND VGND VPWR VPWR sky130_fd_sc_hd__decap_3
XFILLER_50_424 VGND VGND VPWR VPWR sky130_fd_sc_hd__decap_3
XFILLER_22_137 VGND VGND VPWR VPWR sky130_fd_sc_hd__decap_3
X_3984_ _7358_/Q _3948_/B _3984_/A3 _3984_/B1 _7518_/Q VGND VGND VPWR VPWR _3984_/X
+ sky130_fd_sc_hd__a32o_2
XTAP_TAPCELL_ROW_83_1090 VGND VPWR sky130_fd_sc_hd__tapvpwrvgnd_1
XPHY_EDGE_ROW_99_Left_203 VGND VGND VPWR VPWR sky130_fd_sc_hd__decap_3
XFILLER_30_181 VGND VGND VPWR VPWR sky130_fd_sc_hd__decap_3
X_5654_ _5654_/A0 _5715_/A1 _5654_/S VGND VGND VPWR VPWR _7256_/D sky130_fd_sc_hd__mux2_2
X_7324_ clkload7/A _7324_/D place2020/X VGND VGND VPWR VPWR _7324_/Q sky130_fd_sc_hd__dfrtp_2
X_5585_ _5585_/A0 _4700_/X _5593_/S VGND VGND VPWR VPWR _7224_/D sky130_fd_sc_hd__mux2_2
XFILLER_89_137 VGND VGND VPWR VPWR sky130_fd_sc_hd__fill_2
X_7255_ _7575_/CLK _7255_/D VGND VGND VPWR VPWR _7255_/Q sky130_fd_sc_hd__dfxtp_2
X_4467_ _4306_/A _4306_/B _4306_/C _7595_/D _4508_/B VGND VGND VPWR VPWR _4467_/X
+ sky130_fd_sc_hd__a311o_2
Xplace1087 _4277_/Y VGND VGND VPWR VPWR _6559_/D1 sky130_fd_sc_hd__buf_2
Xplace1098 _4251_/A VGND VGND VPWR VPWR _6200_/A1 sky130_fd_sc_hd__buf_2
X_7186_ _7241_/CLK _7186_/D VGND VGND VPWR VPWR _7186_/Q sky130_fd_sc_hd__dfxtp_2
X_6206_ _7203_/Q _6394_/A1 _7231_/Q _6455_/A1 VGND VGND VPWR VPWR _6206_/X sky130_fd_sc_hd__o22a_2
X_4398_ _4398_/A _4398_/B _4398_/C VGND VGND VPWR VPWR _4398_/Y sky130_fd_sc_hd__nand3_2
X_3418_ _7294_/Q _7292_/Q VGND VGND VPWR VPWR _3442_/B sky130_fd_sc_hd__nor2_4
X_6137_ _6136_/X _6135_/X _6153_/B1 _6457_/C1 VGND VGND VPWR VPWR _6141_/A sky130_fd_sc_hd__a211o_4
XFILLER_73_505 VGND VGND VPWR VPWR sky130_fd_sc_hd__decap_3
X_6068_ _6504_/A2 _6881_/Q _7273_/Q _6501_/A1 VGND VGND VPWR VPWR _6068_/X sky130_fd_sc_hd__o22a_2
XFILLER_26_12 VGND VGND VPWR VPWR sky130_fd_sc_hd__decap_3
XFILLER_26_45 VGND VGND VPWR VPWR sky130_fd_sc_hd__decap_3
XFILLER_53_240 VGND VGND VPWR VPWR sky130_fd_sc_hd__fill_1
XFILLER_26_498 VGND VGND VPWR VPWR sky130_fd_sc_hd__decap_3
XFILLER_53_284 VGND VGND VPWR VPWR sky130_fd_sc_hd__fill_2
XFILLER_13_148 VGND VGND VPWR VPWR sky130_fd_sc_hd__decap_3
XFILLER_9_108 VGND VGND VPWR VPWR sky130_fd_sc_hd__decap_3
XFILLER_9_119 VGND VGND VPWR VPWR sky130_fd_sc_hd__fill_2
XFILLER_21_181 VGND VGND VPWR VPWR sky130_fd_sc_hd__decap_3
XFILLER_42_55 VGND VGND VPWR VPWR sky130_fd_sc_hd__fill_2
XTAP_TAPCELL_ROW_11_338 VGND VPWR sky130_fd_sc_hd__tapvpwrvgnd_1
XFILLER_42_88 VGND VGND VPWR VPWR sky130_fd_sc_hd__decap_3
XTAP_TAPCELL_ROW_97_1237 VGND VPWR sky130_fd_sc_hd__tapvpwrvgnd_1
XFILLER_5_314 VGND VGND VPWR VPWR sky130_fd_sc_hd__fill_1
XFILLER_5_369 VGND VGND VPWR VPWR sky130_fd_sc_hd__decap_3
XFILLER_103_481 VGND VGND VPWR VPWR sky130_fd_sc_hd__fill_2
XFILLER_49_557 VGND VGND VPWR VPWR sky130_fd_sc_hd__decap_3
XFILLER_49_579 VGND VGND VPWR VPWR sky130_fd_sc_hd__decap_3
XTAP_TAPCELL_ROW_47_714 VGND VPWR sky130_fd_sc_hd__tapvpwrvgnd_1
XFILLER_29_270 VGND VGND VPWR VPWR sky130_fd_sc_hd__decap_3
XFILLER_29_281 VGND VGND VPWR VPWR sky130_fd_sc_hd__decap_3
XFILLER_36_218 VGND VGND VPWR VPWR sky130_fd_sc_hd__fill_1
XTAP_TAPCELL_ROW_19_427 VGND VPWR sky130_fd_sc_hd__tapvpwrvgnd_1
XFILLER_17_443 VGND VGND VPWR VPWR sky130_fd_sc_hd__decap_3
XFILLER_44_262 VGND VGND VPWR VPWR sky130_fd_sc_hd__decap_3
XFILLER_44_273 VGND VGND VPWR VPWR sky130_fd_sc_hd__decap_3
XFILLER_32_457 VGND VGND VPWR VPWR sky130_fd_sc_hd__decap_3
XFILLER_44_284 VGND VGND VPWR VPWR sky130_fd_sc_hd__fill_2
XFILLER_20_608 VGND VGND VPWR VPWR sky130_fd_sc_hd__decap_3
XFILLER_8_141 VGND VGND VPWR VPWR sky130_fd_sc_hd__fill_1
XFILLER_59_3 VGND VGND VPWR VPWR sky130_fd_sc_hd__fill_2
X_5370_ _5370_/A0 _5614_/A1 _5391_/S VGND VGND VPWR VPWR _7125_/D sky130_fd_sc_hd__mux2_2
XTAP_TAPCELL_ROW_74_1001 VGND VPWR sky130_fd_sc_hd__tapvpwrvgnd_1
X_4321_ _4473_/B _4321_/B _4321_/C _4473_/A VGND VGND VPWR VPWR _6720_/S sky130_fd_sc_hd__or4_2
XFILLER_87_608 VGND VGND VPWR VPWR sky130_fd_sc_hd__decap_3
X_7040_ _7264_/CLK _7040_/D VGND VGND VPWR VPWR _7040_/Q sky130_fd_sc_hd__dfxtp_2
X_4252_ _7315_/Q _3738_/A _4567_/B VGND VGND VPWR VPWR _4252_/Y sky130_fd_sc_hd__a21oi_2
XFILLER_101_418 VGND VGND VPWR VPWR sky130_fd_sc_hd__fill_1
XFILLER_67_332 VGND VGND VPWR VPWR sky130_fd_sc_hd__decap_3
X_4183_ _3887_/B _4183_/A2 _4176_/X _4250_/C1 _4186_/A2 VGND VGND VPWR VPWR _4183_/Y
+ sky130_fd_sc_hd__a311oi_4
XFILLER_27_207 VGND VGND VPWR VPWR sky130_fd_sc_hd__fill_1
XFILLER_94_151 VGND VGND VPWR VPWR sky130_fd_sc_hd__decap_3
XFILLER_27_218 VGND VGND VPWR VPWR sky130_fd_sc_hd__decap_3
XFILLER_82_324 VGND VGND VPWR VPWR sky130_fd_sc_hd__fill_1
XFILLER_70_508 VGND VGND VPWR VPWR sky130_fd_sc_hd__fill_1
XFILLER_82_368 VGND VGND VPWR VPWR sky130_fd_sc_hd__decap_3
XFILLER_35_251 VGND VGND VPWR VPWR sky130_fd_sc_hd__decap_3
XFILLER_23_446 VGND VGND VPWR VPWR sky130_fd_sc_hd__fill_2
XFILLER_35_284 VGND VGND VPWR VPWR sky130_fd_sc_hd__decap_3
XFILLER_50_210 VGND VGND VPWR VPWR sky130_fd_sc_hd__decap_3
XFILLER_90_390 VGND VGND VPWR VPWR sky130_fd_sc_hd__decap_3
X_6824_ _6838_/A _6824_/B VGND VGND VPWR VPWR _7570_/D sky130_fd_sc_hd__and2_2
XFILLER_10_107 VGND VGND VPWR VPWR sky130_fd_sc_hd__fill_1
X_3967_ _7392_/Q _3993_/B1 _3966_/X VGND VGND VPWR VPWR _3969_/B sky130_fd_sc_hd__a21oi_2
XFILLER_10_118 VGND VGND VPWR VPWR sky130_fd_sc_hd__fill_1
XFILLER_10_129 VGND VGND VPWR VPWR sky130_fd_sc_hd__decap_3
XFILLER_50_298 VGND VGND VPWR VPWR sky130_fd_sc_hd__fill_1
Xclkbuf_leaf_30_clk clkbuf_3_6__f_clk/X VGND VGND VPWR VPWR _7509_/CLK sky130_fd_sc_hd__clkbuf_16
X_3898_ _3995_/A1 _3898_/A2 _7365_/Q _3936_/B1 _7557_/Q VGND VGND VPWR VPWR _3898_/X
+ sky130_fd_sc_hd__a32o_2
X_5637_ _5637_/A0 _5637_/A1 _5637_/S VGND VGND VPWR VPWR _7248_/D sky130_fd_sc_hd__mux2_2
X_5568_ _5568_/A0 _5690_/A1 _5574_/S VGND VGND VPWR VPWR _7216_/D sky130_fd_sc_hd__mux2_2
XFILLER_2_317 VGND VGND VPWR VPWR sky130_fd_sc_hd__decap_3
X_7307_ _7610_/CLK _7307_/D place2055/X VGND VGND VPWR VPWR _7307_/Q sky130_fd_sc_hd__dfrtp_2
X_4519_ _7312_/Q _4514_/B _4532_/A VGND VGND VPWR VPWR _4519_/X sky130_fd_sc_hd__a21o_2
X_7238_ _7266_/CLK _7238_/D VGND VGND VPWR VPWR _7238_/Q sky130_fd_sc_hd__dfxtp_2
XTAP_TAPCELL_ROW_92_1189 VGND VPWR sky130_fd_sc_hd__tapvpwrvgnd_1
XFILLER_58_321 VGND VGND VPWR VPWR sky130_fd_sc_hd__fill_2
X_7169_ _7509_/CLK _7169_/D VGND VGND VPWR VPWR _7169_/Q sky130_fd_sc_hd__dfxtp_2
XFILLER_37_11 VGND VGND VPWR VPWR sky130_fd_sc_hd__fill_1
XFILLER_58_365 VGND VGND VPWR VPWR sky130_fd_sc_hd__decap_3
XFILLER_58_376 VGND VGND VPWR VPWR sky130_fd_sc_hd__fill_2
XFILLER_39_590 VGND VGND VPWR VPWR sky130_fd_sc_hd__decap_3
XFILLER_73_324 VGND VGND VPWR VPWR sky130_fd_sc_hd__decap_3
XFILLER_37_99 VGND VGND VPWR VPWR sky130_fd_sc_hd__decap_3
XFILLER_26_262 VGND VGND VPWR VPWR sky130_fd_sc_hd__fill_1
XFILLER_53_54 VGND VGND VPWR VPWR sky130_fd_sc_hd__fill_2
XFILLER_81_390 VGND VGND VPWR VPWR sky130_fd_sc_hd__fill_2
XTAP_TAPCELL_ROW_52_772 VGND VPWR sky130_fd_sc_hd__tapvpwrvgnd_1
XFILLER_41_276 VGND VGND VPWR VPWR sky130_fd_sc_hd__decap_3
XFILLER_41_287 VGND VGND VPWR VPWR sky130_fd_sc_hd__decap_3
XTAP_TAPCELL_ROW_24_474 VGND VPWR sky130_fd_sc_hd__tapvpwrvgnd_1
Xclkbuf_leaf_21_clk clkload0/A VGND VGND VPWR VPWR _7290_/CLK sky130_fd_sc_hd__clkbuf_16
XTAP_TAPCELL_ROW_101_1285 VGND VPWR sky130_fd_sc_hd__tapvpwrvgnd_1
XFILLER_5_100 VGND VGND VPWR VPWR sky130_fd_sc_hd__decap_3
XFILLER_5_144 VGND VGND VPWR VPWR sky130_fd_sc_hd__decap_3
XFILLER_49_332 VGND VGND VPWR VPWR sky130_fd_sc_hd__decap_3
XFILLER_60_541 VGND VGND VPWR VPWR sky130_fd_sc_hd__decap_3
X_4870_ _4870_/A0 _5637_/A1 _4870_/S VGND VGND VPWR VPWR _6912_/D sky130_fd_sc_hd__mux2_2
XFILLER_32_265 VGND VGND VPWR VPWR sky130_fd_sc_hd__decap_3
X_3821_ _3821_/A _3821_/B VGND VGND VPWR VPWR _4209_/A sky130_fd_sc_hd__nand2_2
XFILLER_20_427 VGND VGND VPWR VPWR sky130_fd_sc_hd__decap_3
XTAP_TAPCELL_ROW_80_1060 VGND VPWR sky130_fd_sc_hd__tapvpwrvgnd_1
Xclkbuf_leaf_12_clk clkbuf_leaf_8_clk/A VGND VGND VPWR VPWR _7243_/CLK sky130_fd_sc_hd__clkbuf_16
X_3752_ _3750_/X _4561_/B1 _4151_/A _3751_/Y VGND VGND VPWR VPWR _3752_/X sky130_fd_sc_hd__a2bb2o_2
X_6471_ _6048_/A _6461_/X _6470_/X VGND VGND VPWR VPWR _6471_/Y sky130_fd_sc_hd__o21ai_2
X_3683_ _4261_/A _4261_/C _3682_/X VGND VGND VPWR VPWR _3683_/Y sky130_fd_sc_hd__o21ai_2
X_5353_ _5353_/A0 _5353_/A1 _5363_/S VGND VGND VPWR VPWR _7118_/D sky130_fd_sc_hd__mux2_2
XFILLER_101_204 VGND VGND VPWR VPWR sky130_fd_sc_hd__decap_3
X_5284_ _5284_/A0 _5351_/A1 _5299_/S VGND VGND VPWR VPWR _7089_/D sky130_fd_sc_hd__mux2_2
X_7023_ _7247_/CLK _7023_/D VGND VGND VPWR VPWR _7023_/Q sky130_fd_sc_hd__dfxtp_2
X_4235_ _4235_/A _4235_/B _4235_/C VGND VGND VPWR VPWR _4235_/Y sky130_fd_sc_hd__nor3_2
XFILLER_67_140 VGND VGND VPWR VPWR sky130_fd_sc_hd__fill_1
X_4166_ _4166_/A1 _4164_/X _4165_/Y VGND VGND VPWR VPWR _4166_/Y sky130_fd_sc_hd__a21oi_2
XFILLER_55_313 VGND VGND VPWR VPWR sky130_fd_sc_hd__fill_2
XFILLER_83_611 VGND VGND VPWR VPWR sky130_fd_sc_hd__fill_1
X_4097_ _3957_/X _4579_/B _4579_/C _4579_/D VGND VGND VPWR VPWR _4097_/X sky130_fd_sc_hd__a22o_4
XFILLER_70_327 VGND VGND VPWR VPWR sky130_fd_sc_hd__fill_1
XFILLER_23_210 VGND VGND VPWR VPWR sky130_fd_sc_hd__decap_3
XFILLER_36_582 VGND VGND VPWR VPWR sky130_fd_sc_hd__fill_2
XFILLER_23_243 VGND VGND VPWR VPWR sky130_fd_sc_hd__decap_3
X_6807_ _6840_/A _6807_/B VGND VGND VPWR VPWR _7562_/D sky130_fd_sc_hd__and2_2
XFILLER_11_416 VGND VGND VPWR VPWR sky130_fd_sc_hd__fill_2
XFILLER_11_449 VGND VGND VPWR VPWR sky130_fd_sc_hd__decap_3
XTAP_TAPCELL_ROW_21_444 VGND VPWR sky130_fd_sc_hd__tapvpwrvgnd_1
XTAP_TAPCELL_ROW_94_1207 VGND VPWR sky130_fd_sc_hd__tapvpwrvgnd_1
XFILLER_2_114 VGND VGND VPWR VPWR sky130_fd_sc_hd__fill_1
XFILLER_19_505 VGND VGND VPWR VPWR sky130_fd_sc_hd__decap_3
XFILLER_46_302 VGND VGND VPWR VPWR sky130_fd_sc_hd__decap_3
XPHY_EDGE_ROW_45_Left_149 VGND VGND VPWR VPWR sky130_fd_sc_hd__decap_3
XTAP_TAPCELL_ROW_57_820 VGND VPWR sky130_fd_sc_hd__tapvpwrvgnd_1
XFILLER_46_346 VGND VGND VPWR VPWR sky130_fd_sc_hd__decap_3
XFILLER_14_221 VGND VGND VPWR VPWR sky130_fd_sc_hd__decap_3
XTAP_TAPCELL_ROW_103_1314 VGND VPWR sky130_fd_sc_hd__tapvpwrvgnd_1
XTAP_TAPCELL_ROW_103_1303 VGND VPWR sky130_fd_sc_hd__tapvpwrvgnd_1
XFILLER_42_563 VGND VGND VPWR VPWR sky130_fd_sc_hd__decap_3
XFILLER_14_298 VGND VGND VPWR VPWR sky130_fd_sc_hd__decap_3
XPHY_EDGE_ROW_54_Left_158 VGND VGND VPWR VPWR sky130_fd_sc_hd__decap_3
XFILLER_6_475 VGND VGND VPWR VPWR sky130_fd_sc_hd__fill_1
XFILLER_6_486 VGND VGND VPWR VPWR sky130_fd_sc_hd__decap_3
Xplace1609 _3466_/Y VGND VGND VPWR VPWR place1609/X sky130_fd_sc_hd__buf_8
XPHY_EDGE_ROW_63_Left_167 VGND VGND VPWR VPWR sky130_fd_sc_hd__decap_3
Xclkbuf_leaf_1_clk clkbuf_leaf_3_clk/A VGND VGND VPWR VPWR clkload7/A sky130_fd_sc_hd__clkbuf_16
X_4020_ _4020_/A VGND VGND VPWR VPWR _4020_/Y sky130_fd_sc_hd__inv_2
XFILLER_37_302 VGND VGND VPWR VPWR sky130_fd_sc_hd__decap_3
XFILLER_77_493 VGND VGND VPWR VPWR sky130_fd_sc_hd__fill_1
XFILLER_37_335 VGND VGND VPWR VPWR sky130_fd_sc_hd__fill_1
XFILLER_25_508 VGND VGND VPWR VPWR sky130_fd_sc_hd__fill_1
XFILLER_64_176 VGND VGND VPWR VPWR sky130_fd_sc_hd__decap_3
X_5971_ _5969_/Y _5970_/Y _5304_/B VGND VGND VPWR VPWR _5978_/B sky130_fd_sc_hd__o21ai_2
XFILLER_52_338 VGND VGND VPWR VPWR sky130_fd_sc_hd__fill_1
X_4922_ _4922_/A0 _5688_/A1 _4952_/S VGND VGND VPWR VPWR _6935_/D sky130_fd_sc_hd__mux2_2
XTAP_TAPCELL_ROW_63_889 VGND VPWR sky130_fd_sc_hd__tapvpwrvgnd_1
XPHY_EDGE_ROW_72_Left_176 VGND VGND VPWR VPWR sky130_fd_sc_hd__decap_3
X_4853_ _4853_/A0 _5681_/A1 _4868_/S VGND VGND VPWR VPWR _6904_/D sky130_fd_sc_hd__mux2_2
X_7572_ _7577_/CLK _7572_/D place2013/X VGND VGND VPWR VPWR _7572_/Q sky130_fd_sc_hd__dfrtp_2
X_3804_ _6328_/B2 _3855_/A2 _3812_/B1 _7468_/Q VGND VGND VPWR VPWR _3805_/D sky130_fd_sc_hd__a22oi_2
X_3735_ _7482_/Q _3769_/B1 _3907_/B1 _7418_/Q _3734_/X VGND VGND VPWR VPWR _3735_/X
+ sky130_fd_sc_hd__a221o_2
X_6454_ _6926_/Q _4780_/C _4970_/D _6453_/X VGND VGND VPWR VPWR _6454_/X sky130_fd_sc_hd__o31a_2
X_6385_ _6692_/A0 _6411_/A2 _6388_/A3 _6407_/S _7411_/Q VGND VGND VPWR VPWR _7411_/D
+ sky130_fd_sc_hd__a32o_2
XPHY_EDGE_ROW_81_Left_185 VGND VGND VPWR VPWR sky130_fd_sc_hd__decap_3
X_5336_ _5336_/A0 _5336_/A1 _5357_/S VGND VGND VPWR VPWR _7110_/D sky130_fd_sc_hd__mux2_2
Xhold2801 _6409_/X VGND VGND VPWR VPWR _7416_/D sky130_fd_sc_hd__dlygate4sd3_1
Xhold2812 _6892_/Q VGND VGND VPWR VPWR _4825_/A0 sky130_fd_sc_hd__dlygate4sd3_1
Xhold2823 _7554_/Q VGND VGND VPWR VPWR _6791_/B sky130_fd_sc_hd__dlygate4sd3_1
Xhold2834 _7569_/Q VGND VGND VPWR VPWR _6822_/B sky130_fd_sc_hd__dlygate4sd3_1
Xhold2845 _7532_/Q VGND VGND VPWR VPWR _6744_/A1 sky130_fd_sc_hd__dlygate4sd3_1
Xhold2856 _7575_/Q VGND VGND VPWR VPWR _6834_/B sky130_fd_sc_hd__dlygate4sd3_1
X_7006_ _7287_/CLK _7006_/D VGND VGND VPWR VPWR _7006_/Q sky130_fd_sc_hd__dfxtp_2
X_4218_ _6088_/A _4510_/C _4220_/B _4217_/B _4217_/Y VGND VGND VPWR VPWR _4218_/X
+ sky130_fd_sc_hd__o221a_2
Xhold2867 _7566_/Q VGND VGND VPWR VPWR _6816_/B sky130_fd_sc_hd__dlygate4sd3_1
Xhold2878 _7354_/Q VGND VGND VPWR VPWR _6296_/B sky130_fd_sc_hd__dlygate4sd3_1
Xhold2889 _7565_/Q VGND VGND VPWR VPWR _6814_/B sky130_fd_sc_hd__dlygate4sd3_1
X_5198_ _5198_/A0 _5593_/A1 _5213_/S VGND VGND VPWR VPWR _7060_/D sky130_fd_sc_hd__mux2_2
XFILLER_28_335 VGND VGND VPWR VPWR sky130_fd_sc_hd__decap_3
X_4149_ _4152_/A _4149_/B _4152_/B VGND VGND VPWR VPWR _4149_/X sky130_fd_sc_hd__and3_2
XFILLER_16_519 VGND VGND VPWR VPWR sky130_fd_sc_hd__fill_1
XFILLER_83_463 VGND VGND VPWR VPWR sky130_fd_sc_hd__fill_1
XPHY_EDGE_ROW_90_Left_194 VGND VGND VPWR VPWR sky130_fd_sc_hd__decap_3
XFILLER_24_574 VGND VGND VPWR VPWR sky130_fd_sc_hd__decap_3
XFILLER_51_360 VGND VGND VPWR VPWR sky130_fd_sc_hd__fill_1
XFILLER_51_382 VGND VGND VPWR VPWR sky130_fd_sc_hd__fill_2
XTAP_TAPCELL_ROW_34_580 VGND VPWR sky130_fd_sc_hd__tapvpwrvgnd_1
XFILLER_11_279 VGND VGND VPWR VPWR sky130_fd_sc_hd__fill_1
Xclkload0 clkload0/A VGND VGND VPWR VPWR clkload0/X sky130_fd_sc_hd__clkbuf_16
XFILLER_3_467 VGND VGND VPWR VPWR sky130_fd_sc_hd__decap_3
XFILLER_93_205 VGND VGND VPWR VPWR sky130_fd_sc_hd__fill_2
XTAP_TAPCELL_ROW_6_283 VGND VPWR sky130_fd_sc_hd__tapvpwrvgnd_1
XFILLER_19_335 VGND VGND VPWR VPWR sky130_fd_sc_hd__fill_1
XFILLER_19_346 VGND VGND VPWR VPWR sky130_fd_sc_hd__decap_3
XFILLER_46_132 VGND VGND VPWR VPWR sky130_fd_sc_hd__decap_3
XFILLER_34_327 VGND VGND VPWR VPWR sky130_fd_sc_hd__decap_3
XFILLER_61_102 VGND VGND VPWR VPWR sky130_fd_sc_hd__fill_1
XFILLER_61_113 VGND VGND VPWR VPWR sky130_fd_sc_hd__decap_3
XFILLER_61_146 VGND VGND VPWR VPWR sky130_fd_sc_hd__decap_3
XFILLER_30_500 VGND VGND VPWR VPWR sky130_fd_sc_hd__decap_3
XFILLER_42_371 VGND VGND VPWR VPWR sky130_fd_sc_hd__decap_3
XTAP_TAPCELL_ROW_60_848 VGND VPWR sky130_fd_sc_hd__tapvpwrvgnd_1
XFILLER_30_533 VGND VGND VPWR VPWR sky130_fd_sc_hd__decap_3
XFILLER_30_577 VGND VGND VPWR VPWR sky130_fd_sc_hd__decap_3
X_3520_ _4319_/A1 _3462_/B _3522_/A2 _3416_/Y VGND VGND VPWR VPWR _3520_/X sky130_fd_sc_hd__a31o_2
Xplace1406 _4236_/D VGND VGND VPWR VPWR _4220_/B sky130_fd_sc_hd__buf_2
Xplace1417 _6407_/S VGND VGND VPWR VPWR _6410_/B1 sky130_fd_sc_hd__buf_2
Xplace1428 _4151_/C VGND VGND VPWR VPWR _4612_/A1 sky130_fd_sc_hd__buf_2
Xplace1439 _3935_/Y VGND VGND VPWR VPWR _4436_/A1 sky130_fd_sc_hd__buf_2
XFILLER_41_3 VGND VGND VPWR VPWR sky130_fd_sc_hd__decap_3
X_6170_ _4970_/A _4970_/B _4970_/C _7003_/Q _6186_/C1 VGND VGND VPWR VPWR _6170_/X
+ sky130_fd_sc_hd__a311o_2
XFILLER_69_257 VGND VGND VPWR VPWR sky130_fd_sc_hd__decap_3
XFILLER_38_611 VGND VGND VPWR VPWR sky130_fd_sc_hd__fill_1
XFILLER_69_279 VGND VGND VPWR VPWR sky130_fd_sc_hd__fill_1
XFILLER_97_588 VGND VGND VPWR VPWR sky130_fd_sc_hd__decap_3
XTAP_TAPCELL_ROW_68_937 VGND VPWR sky130_fd_sc_hd__tapvpwrvgnd_1
X_4003_ _4003_/A1 _4003_/A2 _7361_/Q _4312_/B _7553_/Q VGND VGND VPWR VPWR _4003_/X
+ sky130_fd_sc_hd__a32o_2
XFILLER_1_60 VGND VGND VPWR VPWR sky130_fd_sc_hd__decap_3
XFILLER_53_603 VGND VGND VPWR VPWR sky130_fd_sc_hd__fill_1
X_5954_ _7044_/Q _6476_/A1 _5951_/X _5953_/X VGND VGND VPWR VPWR _5954_/X sky130_fd_sc_hd__o211a_2
XFILLER_21_511 VGND VGND VPWR VPWR sky130_fd_sc_hd__decap_3
XFILLER_33_382 VGND VGND VPWR VPWR sky130_fd_sc_hd__decap_3
XFILLER_52_179 VGND VGND VPWR VPWR sky130_fd_sc_hd__decap_3
X_5885_ _7093_/Q _6204_/A2 _6455_/A1 _7121_/Q _5884_/X VGND VGND VPWR VPWR _5885_/X
+ sky130_fd_sc_hd__o221a_2
X_4905_ _4905_/A _5610_/B _5093_/C VGND VGND VPWR VPWR _4905_/X sky130_fd_sc_hd__and3_2
XFILLER_33_393 VGND VGND VPWR VPWR sky130_fd_sc_hd__decap_3
X_4836_ _4836_/A0 _5296_/A1 _4838_/S VGND VGND VPWR VPWR _6897_/D sky130_fd_sc_hd__mux2_2
X_7555_ clkload9/A _7555_/D place2033/X VGND VGND VPWR VPWR _7555_/Q sky130_fd_sc_hd__dfrtp_2
XTAP_TAPCELL_ROW_31_550 VGND VPWR sky130_fd_sc_hd__tapvpwrvgnd_1
X_6506_ _6506_/A1 _6506_/A2 _6502_/X _6505_/X VGND VGND VPWR VPWR _6506_/X sky130_fd_sc_hd__o31a_2
X_4767_ _4734_/X _4297_/B _4767_/B1 _4767_/B2 VGND VGND VPWR VPWR _4767_/X sky130_fd_sc_hd__a2bb2o_2
X_7486_ clkload7/A _7486_/D place2020/X VGND VGND VPWR VPWR _7486_/Q sky130_fd_sc_hd__dfrtp_2
X_4698_ _4698_/A1 _4726_/A2 _4726_/B1 VGND VGND VPWR VPWR _4698_/Y sky130_fd_sc_hd__o21ai_2
X_3718_ _7417_/Q _6662_/S _3718_/B1 _7449_/Q _3717_/X VGND VGND VPWR VPWR _3718_/X
+ sky130_fd_sc_hd__a221o_2
XFILLER_20_47 VGND VGND VPWR VPWR sky130_fd_sc_hd__fill_2
X_6437_ _4637_/A _6489_/A1 _4637_/B _6437_/B1 _6055_/X VGND VGND VPWR VPWR _6437_/X
+ sky130_fd_sc_hd__a311o_2
X_3649_ _4253_/A _4253_/C _4253_/B VGND VGND VPWR VPWR _4249_/A sky130_fd_sc_hd__or3_2
Xplace1973 _7296_/Q VGND VGND VPWR VPWR _3939_/B1 sky130_fd_sc_hd__buf_2
Xplace1962 _7319_/Q VGND VGND VPWR VPWR _4558_/B sky130_fd_sc_hd__buf_2
Xplace1951 _7368_/Q VGND VGND VPWR VPWR _6321_/B2 sky130_fd_sc_hd__buf_2
Xplace1940 _7403_/Q VGND VGND VPWR VPWR _6373_/B2 sky130_fd_sc_hd__buf_2
X_6368_ _6664_/A0 _6412_/A2 _6412_/A3 _6412_/B1 _7398_/Q VGND VGND VPWR VPWR _6368_/X
+ sky130_fd_sc_hd__a32o_2
Xplace1995 _3473_/A VGND VGND VPWR VPWR _4337_/B sky130_fd_sc_hd__buf_4
Xplace1984 place1984/A VGND VGND VPWR VPWR _3487_/B sky130_fd_sc_hd__buf_2
X_5319_ _5319_/A0 _5564_/A1 _5329_/S VGND VGND VPWR VPWR _7102_/D sky130_fd_sc_hd__mux2_2
Xhold2631 _6941_/Q VGND VGND VPWR VPWR _4935_/A0 sky130_fd_sc_hd__dlygate4sd3_1
Xhold2620 _7078_/Q VGND VGND VPWR VPWR _5249_/A0 sky130_fd_sc_hd__dlygate4sd3_1
XFILLER_102_365 VGND VGND VPWR VPWR sky130_fd_sc_hd__decap_3
XFILLER_29_611 VGND VGND VPWR VPWR sky130_fd_sc_hd__fill_1
Xhold2642 _7278_/Q VGND VGND VPWR VPWR _5703_/A0 sky130_fd_sc_hd__dlygate4sd3_1
Xhold2653 _6924_/Q VGND VGND VPWR VPWR _4896_/A0 sky130_fd_sc_hd__dlygate4sd3_1
Xhold2664 _6878_/Q VGND VGND VPWR VPWR _4796_/A0 sky130_fd_sc_hd__dlygate4sd3_1
XFILLER_29_89 VGND VGND VPWR VPWR sky130_fd_sc_hd__decap_3
Xhold2675 _6931_/Q VGND VGND VPWR VPWR _4913_/A0 sky130_fd_sc_hd__dlygate4sd3_1
Xhold2686 _7280_/Q VGND VGND VPWR VPWR _5707_/A0 sky130_fd_sc_hd__dlygate4sd3_1
Xhold2697 _7120_/Q VGND VGND VPWR VPWR _5357_/A0 sky130_fd_sc_hd__dlygate4sd3_1
XTAP_TAPCELL_ROW_3_253 VGND VPWR sky130_fd_sc_hd__tapvpwrvgnd_1
XFILLER_16_305 VGND VGND VPWR VPWR sky130_fd_sc_hd__decap_3
XFILLER_43_146 VGND VGND VPWR VPWR sky130_fd_sc_hd__decap_3
XFILLER_31_319 VGND VGND VPWR VPWR sky130_fd_sc_hd__decap_3
XFILLER_12_533 VGND VGND VPWR VPWR sky130_fd_sc_hd__decap_3
XFILLER_24_382 VGND VGND VPWR VPWR sky130_fd_sc_hd__decap_3
XANTENNA_9 _4135_/X VGND VGND VPWR VPWR sky130_fd_sc_hd__diode_2
XFILLER_3_231 VGND VGND VPWR VPWR sky130_fd_sc_hd__fill_2
XFILLER_86_73 VGND VGND VPWR VPWR sky130_fd_sc_hd__fill_2
XFILLER_19_121 VGND VGND VPWR VPWR sky130_fd_sc_hd__decap_3
XFILLER_94_547 VGND VGND VPWR VPWR sky130_fd_sc_hd__fill_2
XFILLER_94_558 VGND VGND VPWR VPWR sky130_fd_sc_hd__decap_3
XFILLER_19_154 VGND VGND VPWR VPWR sky130_fd_sc_hd__decap_3
XFILLER_35_603 VGND VGND VPWR VPWR sky130_fd_sc_hd__decap_3
XTAP_TAPCELL_ROW_65_907 VGND VPWR sky130_fd_sc_hd__tapvpwrvgnd_1
XTAP_TAPCELL_ROW_37_609 VGND VPWR sky130_fd_sc_hd__tapvpwrvgnd_1
XFILLER_19_198 VGND VGND VPWR VPWR sky130_fd_sc_hd__decap_3
XFILLER_74_271 VGND VGND VPWR VPWR sky130_fd_sc_hd__fill_1
XTAP_TAPCELL_ROW_45_697 VGND VPWR sky130_fd_sc_hd__tapvpwrvgnd_1
XFILLER_30_330 VGND VGND VPWR VPWR sky130_fd_sc_hd__decap_3
XTAP_TAPCELL_ROW_17_399 VGND VPWR sky130_fd_sc_hd__tapvpwrvgnd_1
XFILLER_30_363 VGND VGND VPWR VPWR sky130_fd_sc_hd__fill_1
XFILLER_30_374 VGND VGND VPWR VPWR sky130_fd_sc_hd__decap_3
XFILLER_30_396 VGND VGND VPWR VPWR sky130_fd_sc_hd__decap_3
X_7340_ _7514_/CLK _7340_/D place2012/X VGND VGND VPWR VPWR _7340_/Q sky130_fd_sc_hd__dfrtp_2
X_4552_ _7316_/Q _4542_/B _4548_/A _4542_/C _4558_/B VGND VGND VPWR VPWR _4552_/X
+ sky130_fd_sc_hd__a41o_2
Xplace1203 _4902_/S VGND VGND VPWR VPWR _4896_/S sky130_fd_sc_hd__buf_2
Xplace1214 _4776_/S VGND VGND VPWR VPWR _4672_/S sky130_fd_sc_hd__buf_2
Xplace1225 _5772_/Y VGND VGND VPWR VPWR _6478_/B1 sky130_fd_sc_hd__clkbuf_4
X_7271_ _7273_/CLK _7271_/D VGND VGND VPWR VPWR _7271_/Q sky130_fd_sc_hd__dfxtp_2
X_4483_ _4495_/A _4478_/B _7308_/Q VGND VGND VPWR VPWR _4483_/X sky130_fd_sc_hd__a21bo_2
X_3503_ _7388_/Q _3978_/B _4576_/B1 _6416_/A0 _3502_/Y VGND VGND VPWR VPWR _3504_/A
+ sky130_fd_sc_hd__a221oi_4
XTAP_TAPCELL_ROW_77_1032 VGND VPWR sky130_fd_sc_hd__tapvpwrvgnd_1
Xplace1236 _5425_/S VGND VGND VPWR VPWR _5423_/S sky130_fd_sc_hd__buf_2
Xplace1247 _4735_/D VGND VGND VPWR VPWR _6437_/B1 sky130_fd_sc_hd__buf_2
Xplace1258 _6070_/A2 VGND VGND VPWR VPWR _6512_/C1 sky130_fd_sc_hd__buf_2
X_6222_ _7610_/Q _6560_/B VGND VGND VPWR VPWR _6222_/Y sky130_fd_sc_hd__nor2_2
X_3434_ _7292_/Q _3435_/A2 place1984/A VGND VGND VPWR VPWR _4023_/A sky130_fd_sc_hd__a21boi_2
Xplace1269 _6396_/A1 VGND VGND VPWR VPWR _6399_/A1 sky130_fd_sc_hd__buf_2
XFILLER_97_330 VGND VGND VPWR VPWR sky130_fd_sc_hd__decap_3
X_6153_ _6151_/X _6152_/X _6153_/B1 _6156_/C1 VGND VGND VPWR VPWR _6153_/X sky130_fd_sc_hd__a211o_2
XFILLER_85_503 VGND VGND VPWR VPWR sky130_fd_sc_hd__fill_1
X_6084_ _6178_/A1 _6081_/Y _6178_/A3 _6083_/Y _6404_/B1 VGND VGND VPWR VPWR _6084_/Y
+ sky130_fd_sc_hd__a311oi_4
XTAP_TAPCELL_ROW_88_1150 VGND VPWR sky130_fd_sc_hd__tapvpwrvgnd_1
XTAP_TAPCELL_ROW_0_212 VGND VPWR sky130_fd_sc_hd__tapvpwrvgnd_1
XFILLER_53_411 VGND VGND VPWR VPWR sky130_fd_sc_hd__decap_3
XTAP_TAPCELL_ROW_0_223 VGND VPWR sky130_fd_sc_hd__tapvpwrvgnd_1
XFILLER_15_14 VGND VGND VPWR VPWR sky130_fd_sc_hd__decap_3
XFILLER_41_606 VGND VGND VPWR VPWR sky130_fd_sc_hd__decap_3
XFILLER_53_455 VGND VGND VPWR VPWR sky130_fd_sc_hd__decap_3
X_6986_ _7275_/CLK _6986_/D VGND VGND VPWR VPWR _6986_/Q sky130_fd_sc_hd__dfxtp_2
XFILLER_13_319 VGND VGND VPWR VPWR sky130_fd_sc_hd__decap_3
XFILLER_15_47 VGND VGND VPWR VPWR sky130_fd_sc_hd__decap_3
X_5937_ _5960_/B2 _7014_/Q _6930_/Q _6483_/B2 VGND VGND VPWR VPWR _5937_/X sky130_fd_sc_hd__o22a_2
XFILLER_15_69 VGND VGND VPWR VPWR sky130_fd_sc_hd__decap_3
X_7607_ _7608_/CLK _7607_/D place2053/X VGND VGND VPWR VPWR _7607_/Q sky130_fd_sc_hd__dfrtp_2
XFILLER_21_396 VGND VGND VPWR VPWR sky130_fd_sc_hd__decap_3
X_5799_ _7185_/Q _6504_/A2 _7213_/Q _6504_/B2 VGND VGND VPWR VPWR _5799_/X sky130_fd_sc_hd__o22a_2
X_4819_ _4819_/A0 _5709_/A1 _4840_/S VGND VGND VPWR VPWR _6889_/D sky130_fd_sc_hd__mux2_2
XFILLER_31_57 VGND VGND VPWR VPWR sky130_fd_sc_hd__decap_3
XFILLER_5_529 VGND VGND VPWR VPWR sky130_fd_sc_hd__decap_3
X_7538_ _7606_/CLK _7538_/D place2051/X VGND VGND VPWR VPWR _7538_/Q sky130_fd_sc_hd__dfrtp_2
XFILLER_31_79 VGND VGND VPWR VPWR sky130_fd_sc_hd__fill_1
X_7469_ _7610_/CLK _7469_/D place2066/X VGND VGND VPWR VPWR _7469_/Q sky130_fd_sc_hd__dfrtp_2
XTAP_TAPCELL_ROW_8_312 VGND VPWR sky130_fd_sc_hd__tapvpwrvgnd_1
Xplace1770 _3541_/D VGND VGND VPWR VPWR _3975_/A sky130_fd_sc_hd__buf_2
Xplace1781 _5841_/B VGND VGND VPWR VPWR _6229_/A1 sky130_fd_sc_hd__buf_2
Xplace1792 _4468_/C1 VGND VGND VPWR VPWR _4571_/B1 sky130_fd_sc_hd__buf_2
XFILLER_0_256 VGND VGND VPWR VPWR sky130_fd_sc_hd__decap_3
XFILLER_0_267 VGND VGND VPWR VPWR sky130_fd_sc_hd__fill_1
XFILLER_48_205 VGND VGND VPWR VPWR sky130_fd_sc_hd__decap_3
XFILLER_76_514 VGND VGND VPWR VPWR sky130_fd_sc_hd__fill_1
XFILLER_88_363 VGND VGND VPWR VPWR sky130_fd_sc_hd__fill_1
XFILLER_29_430 VGND VGND VPWR VPWR sky130_fd_sc_hd__decap_3
Xhold2472 _7094_/Q VGND VGND VPWR VPWR _5299_/A0 sky130_fd_sc_hd__dlygate4sd3_1
Xhold2461 _6873_/Q VGND VGND VPWR VPWR _4785_/A0 sky130_fd_sc_hd__dlygate4sd3_1
Xhold2450 _7075_/Q VGND VGND VPWR VPWR _5240_/A0 sky130_fd_sc_hd__dlygate4sd3_1
XFILLER_29_452 VGND VGND VPWR VPWR sky130_fd_sc_hd__decap_3
XFILLER_63_219 VGND VGND VPWR VPWR sky130_fd_sc_hd__decap_3
XFILLER_91_517 VGND VGND VPWR VPWR sky130_fd_sc_hd__fill_2
Xhold2494 _7175_/Q VGND VGND VPWR VPWR _5478_/A0 sky130_fd_sc_hd__dlygate4sd3_1
Xhold2483 _6861_/Q VGND VGND VPWR VPWR _4709_/A0 sky130_fd_sc_hd__dlygate4sd3_1
XFILLER_29_485 VGND VGND VPWR VPWR sky130_fd_sc_hd__decap_3
XFILLER_32_606 VGND VGND VPWR VPWR sky130_fd_sc_hd__decap_3
XFILLER_44_455 VGND VGND VPWR VPWR sky130_fd_sc_hd__decap_3
XPHY_EDGE_ROW_19_Right_19 VGND VGND VPWR VPWR sky130_fd_sc_hd__decap_3
XFILLER_31_105 VGND VGND VPWR VPWR sky130_fd_sc_hd__decap_3
XFILLER_44_477 VGND VGND VPWR VPWR sky130_fd_sc_hd__decap_3
XFILLER_71_274 VGND VGND VPWR VPWR sky130_fd_sc_hd__decap_3
XTAP_TAPCELL_ROW_70_954 VGND VPWR sky130_fd_sc_hd__tapvpwrvgnd_1
XFILLER_8_312 VGND VGND VPWR VPWR sky130_fd_sc_hd__decap_3
XTAP_TAPCELL_ROW_42_667 VGND VPWR sky130_fd_sc_hd__tapvpwrvgnd_1
XTAP_TAPCELL_ROW_14_369 VGND VPWR sky130_fd_sc_hd__tapvpwrvgnd_1
XFILLER_8_356 VGND VGND VPWR VPWR sky130_fd_sc_hd__decap_3
Xclkbuf_3_1__f_clk clkbuf_0_clk/X VGND VGND VPWR VPWR clkbuf_leaf_3_clk/A sky130_fd_sc_hd__clkbuf_8
XPHY_EDGE_ROW_28_Right_28 VGND VGND VPWR VPWR sky130_fd_sc_hd__decap_3
XFILLER_39_205 VGND VGND VPWR VPWR sky130_fd_sc_hd__decap_3
XFILLER_39_216 VGND VGND VPWR VPWR sky130_fd_sc_hd__decap_3
XFILLER_79_363 VGND VGND VPWR VPWR sky130_fd_sc_hd__decap_3
XFILLER_39_249 VGND VGND VPWR VPWR sky130_fd_sc_hd__decap_3
XFILLER_79_396 VGND VGND VPWR VPWR sky130_fd_sc_hd__decap_3
XPHY_EDGE_ROW_37_Right_37 VGND VGND VPWR VPWR sky130_fd_sc_hd__decap_3
X_6840_ _6840_/A _6840_/B VGND VGND VPWR VPWR _7578_/D sky130_fd_sc_hd__and2_2
XFILLER_35_499 VGND VGND VPWR VPWR sky130_fd_sc_hd__decap_3
XFILLER_50_403 VGND VGND VPWR VPWR sky130_fd_sc_hd__decap_3
X_6771_ _6220_/X _6771_/A1 _6773_/S VGND VGND VPWR VPWR _7545_/D sky130_fd_sc_hd__mux2_2
XFILLER_50_436 VGND VGND VPWR VPWR sky130_fd_sc_hd__fill_2
X_5722_ _5722_/A0 _4751_/Y _5730_/S VGND VGND VPWR VPWR _7287_/D sky130_fd_sc_hd__mux2_2
X_3983_ _7390_/Q _3983_/B VGND VGND VPWR VPWR _4393_/B sky130_fd_sc_hd__nand2_4
XFILLER_15_190 VGND VGND VPWR VPWR sky130_fd_sc_hd__decap_3
XTAP_TAPCELL_ROW_83_1091 VGND VPWR sky130_fd_sc_hd__tapvpwrvgnd_1
XPHY_EDGE_ROW_46_Right_46 VGND VGND VPWR VPWR sky130_fd_sc_hd__decap_3
XFILLER_7_81 VGND VGND VPWR VPWR sky130_fd_sc_hd__decap_3
X_7323_ clkload2/A _7323_/D place2029/X VGND VGND VPWR VPWR _7323_/Q sky130_fd_sc_hd__dfrtp_2
X_4535_ _4534_/Y _4535_/A1 _4539_/S VGND VGND VPWR VPWR _7315_/D sky130_fd_sc_hd__mux2_2
X_7254_ _7282_/CLK _7254_/D VGND VGND VPWR VPWR _7254_/Q sky130_fd_sc_hd__dfxtp_2
X_4466_ _4472_/D _4466_/B VGND VGND VPWR VPWR _4466_/X sky130_fd_sc_hd__xor2_2
Xplace1088 _4276_/X VGND VGND VPWR VPWR _6559_/C1 sky130_fd_sc_hd__buf_2
Xplace1099 _4243_/X VGND VGND VPWR VPWR _6184_/A1 sky130_fd_sc_hd__buf_2
X_7185_ _7241_/CLK _7185_/D VGND VGND VPWR VPWR _7185_/Q sky130_fd_sc_hd__dfxtp_2
X_6205_ _6401_/B2 _7175_/Q _7147_/Q _6393_/B2 VGND VGND VPWR VPWR _6205_/X sky130_fd_sc_hd__o22a_2
X_4397_ _4393_/X _4395_/Y _4396_/Y VGND VGND VPWR VPWR _4397_/Y sky130_fd_sc_hd__o21ai_2
X_3417_ _3421_/C _3414_/B _3473_/A _3414_/A _3481_/B VGND VGND VPWR VPWR _3417_/Y
+ sky130_fd_sc_hd__a41oi_2
XFILLER_100_611 VGND VGND VPWR VPWR sky130_fd_sc_hd__fill_1
XFILLER_85_300 VGND VGND VPWR VPWR sky130_fd_sc_hd__fill_1
X_6136_ _7000_/Q _6136_/A2 _6972_/Q _6401_/B2 VGND VGND VPWR VPWR _6136_/X sky130_fd_sc_hd__o22a_4
XPHY_EDGE_ROW_55_Right_55 VGND VGND VPWR VPWR sky130_fd_sc_hd__decap_3
X_6067_ _6507_/A1 _6909_/Q _7245_/Q _6507_/B2 VGND VGND VPWR VPWR _6067_/X sky130_fd_sc_hd__o22a_2
XFILLER_38_271 VGND VGND VPWR VPWR sky130_fd_sc_hd__decap_3
X_5018_ _5018_/A0 _5351_/A1 _5028_/S VGND VGND VPWR VPWR _6977_/D sky130_fd_sc_hd__mux2_2
XFILLER_26_477 VGND VGND VPWR VPWR sky130_fd_sc_hd__fill_2
XFILLER_41_447 VGND VGND VPWR VPWR sky130_fd_sc_hd__fill_1
X_6969_ _7280_/CLK _6969_/D VGND VGND VPWR VPWR _6969_/Q sky130_fd_sc_hd__dfxtp_2
XFILLER_42_78 VGND VGND VPWR VPWR sky130_fd_sc_hd__fill_2
XPHY_EDGE_ROW_64_Right_64 VGND VGND VPWR VPWR sky130_fd_sc_hd__decap_3
XFILLER_21_193 VGND VGND VPWR VPWR sky130_fd_sc_hd__decap_3
XTAP_TAPCELL_ROW_97_1238 VGND VPWR sky130_fd_sc_hd__tapvpwrvgnd_1
XTAP_TAPCELL_ROW_11_339 VGND VPWR sky130_fd_sc_hd__tapvpwrvgnd_1
XFILLER_5_337 VGND VGND VPWR VPWR sky130_fd_sc_hd__fill_1
XFILLER_1_576 VGND VGND VPWR VPWR sky130_fd_sc_hd__decap_3
XFILLER_67_20 VGND VGND VPWR VPWR sky130_fd_sc_hd__fill_1
XFILLER_49_525 VGND VGND VPWR VPWR sky130_fd_sc_hd__decap_3
XFILLER_49_536 VGND VGND VPWR VPWR sky130_fd_sc_hd__decap_3
XFILLER_67_53 VGND VGND VPWR VPWR sky130_fd_sc_hd__decap_3
XPHY_EDGE_ROW_73_Right_73 VGND VGND VPWR VPWR sky130_fd_sc_hd__decap_3
XFILLER_49_569 VGND VGND VPWR VPWR sky130_fd_sc_hd__decap_3
XFILLER_67_86 VGND VGND VPWR VPWR sky130_fd_sc_hd__fill_1
XFILLER_57_580 VGND VGND VPWR VPWR sky130_fd_sc_hd__fill_2
XTAP_TAPCELL_ROW_47_715 VGND VPWR sky130_fd_sc_hd__tapvpwrvgnd_1
XFILLER_29_293 VGND VGND VPWR VPWR sky130_fd_sc_hd__decap_3
XFILLER_32_436 VGND VGND VPWR VPWR sky130_fd_sc_hd__decap_3
XFILLER_44_296 VGND VGND VPWR VPWR sky130_fd_sc_hd__decap_3
XPHY_EDGE_ROW_82_Right_82 VGND VGND VPWR VPWR sky130_fd_sc_hd__decap_3
XFILLER_12_160 VGND VGND VPWR VPWR sky130_fd_sc_hd__decap_3
XFILLER_73_6 VGND VGND VPWR VPWR sky130_fd_sc_hd__fill_1
XFILLER_8_153 VGND VGND VPWR VPWR sky130_fd_sc_hd__decap_3
XFILLER_8_197 VGND VGND VPWR VPWR sky130_fd_sc_hd__decap_3
XTAP_TAPCELL_ROW_74_1002 VGND VPWR sky130_fd_sc_hd__tapvpwrvgnd_1
XFILLER_4_381 VGND VGND VPWR VPWR sky130_fd_sc_hd__decap_3
X_4251_ _4251_/A _4251_/B VGND VGND VPWR VPWR _4251_/Y sky130_fd_sc_hd__nor2_2
XPHY_EDGE_ROW_91_Right_91 VGND VGND VPWR VPWR sky130_fd_sc_hd__decap_3
X_4182_ _4176_/X _4183_/A2 _3887_/B VGND VGND VPWR VPWR _4185_/C sky130_fd_sc_hd__a21oi_2
XFILLER_94_141 VGND VGND VPWR VPWR sky130_fd_sc_hd__fill_1
XTAP_TAPCELL_ROW_85_1120 VGND VPWR sky130_fd_sc_hd__tapvpwrvgnd_1
XFILLER_35_263 VGND VGND VPWR VPWR sky130_fd_sc_hd__decap_3
XFILLER_50_222 VGND VGND VPWR VPWR sky130_fd_sc_hd__decap_3
XFILLER_50_233 VGND VGND VPWR VPWR sky130_fd_sc_hd__decap_3
XFILLER_23_458 VGND VGND VPWR VPWR sky130_fd_sc_hd__decap_3
X_6754_ _6162_/X _7537_/Q _6773_/S VGND VGND VPWR VPWR _7537_/D sky130_fd_sc_hd__mux2_4
X_3966_ _6310_/B2 _3948_/B _3948_/C _4009_/B1 _7424_/Q VGND VGND VPWR VPWR _3966_/X
+ sky130_fd_sc_hd__a32o_2
XFILLER_31_480 VGND VGND VPWR VPWR sky130_fd_sc_hd__decap_3
X_6685_ _6685_/A0 _6159_/X _6687_/S VGND VGND VPWR VPWR _7504_/D sky130_fd_sc_hd__mux2_2
X_5705_ _5705_/A0 _5705_/A1 _5711_/S VGND VGND VPWR VPWR _7279_/D sky130_fd_sc_hd__mux2_2
XFILLER_12_15 VGND VGND VPWR VPWR sky130_fd_sc_hd__fill_1
XFILLER_12_59 VGND VGND VPWR VPWR sky130_fd_sc_hd__fill_2
XFILLER_2_307 VGND VGND VPWR VPWR sky130_fd_sc_hd__fill_1
X_7306_ _7611_/CLK _7306_/D place2054/X VGND VGND VPWR VPWR _7306_/Q sky130_fd_sc_hd__dfrtp_2
X_5498_ _5498_/A0 _4727_/C _5547_/S VGND VGND VPWR VPWR _7184_/D sky130_fd_sc_hd__mux2_2
XFILLER_78_609 VGND VGND VPWR VPWR sky130_fd_sc_hd__decap_3
X_7237_ _7393_/CLK _7237_/D VGND VGND VPWR VPWR _7237_/Q sky130_fd_sc_hd__dfxtp_2
X_4449_ _4561_/A1 _4448_/X _4449_/B1 VGND VGND VPWR VPWR _4460_/B sky130_fd_sc_hd__a21oi_2
XFILLER_58_333 VGND VGND VPWR VPWR sky130_fd_sc_hd__decap_3
X_7168_ _7407_/CLK _7168_/D VGND VGND VPWR VPWR _7168_/Q sky130_fd_sc_hd__dfxtp_2
XFILLER_58_355 VGND VGND VPWR VPWR sky130_fd_sc_hd__fill_1
X_7099_ _7272_/CLK _7099_/D VGND VGND VPWR VPWR _7099_/Q sky130_fd_sc_hd__dfxtp_2
X_6119_ _6138_/A1 _6915_/Q _7251_/Q _6154_/B2 VGND VGND VPWR VPWR _6119_/X sky130_fd_sc_hd__o22a_2
XFILLER_37_45 VGND VGND VPWR VPWR sky130_fd_sc_hd__fill_2
XFILLER_46_528 VGND VGND VPWR VPWR sky130_fd_sc_hd__decap_3
XFILLER_46_539 VGND VGND VPWR VPWR sky130_fd_sc_hd__decap_3
XFILLER_73_314 VGND VGND VPWR VPWR sky130_fd_sc_hd__fill_1
XFILLER_26_285 VGND VGND VPWR VPWR sky130_fd_sc_hd__fill_1
XFILLER_53_77 VGND VGND VPWR VPWR sky130_fd_sc_hd__decap_3
XFILLER_22_480 VGND VGND VPWR VPWR sky130_fd_sc_hd__decap_3
XTAP_TAPCELL_ROW_52_773 VGND VPWR sky130_fd_sc_hd__tapvpwrvgnd_1
XTAP_TAPCELL_ROW_24_475 VGND VPWR sky130_fd_sc_hd__tapvpwrvgnd_1
XTAP_TAPCELL_ROW_101_1286 VGND VPWR sky130_fd_sc_hd__tapvpwrvgnd_1
XFILLER_5_156 VGND VGND VPWR VPWR sky130_fd_sc_hd__decap_3
XFILLER_96_406 VGND VGND VPWR VPWR sky130_fd_sc_hd__decap_3
XFILLER_1_384 VGND VGND VPWR VPWR sky130_fd_sc_hd__fill_1
XFILLER_103_290 VGND VGND VPWR VPWR sky130_fd_sc_hd__fill_2
XFILLER_64_347 VGND VGND VPWR VPWR sky130_fd_sc_hd__fill_1
XFILLER_91_144 VGND VGND VPWR VPWR sky130_fd_sc_hd__decap_3
XFILLER_45_561 VGND VGND VPWR VPWR sky130_fd_sc_hd__decap_3
XFILLER_91_177 VGND VGND VPWR VPWR sky130_fd_sc_hd__fill_1
XFILLER_32_211 VGND VGND VPWR VPWR sky130_fd_sc_hd__decap_3
XFILLER_32_233 VGND VGND VPWR VPWR sky130_fd_sc_hd__decap_3
X_3820_ _7308_/Q _3698_/B _4151_/A _3818_/C _3818_/B VGND VGND VPWR VPWR _3821_/B
+ sky130_fd_sc_hd__a221o_2
XFILLER_32_277 VGND VGND VPWR VPWR sky130_fd_sc_hd__decap_3
X_3751_ _3751_/A VGND VGND VPWR VPWR _3751_/Y sky130_fd_sc_hd__inv_2
XTAP_TAPCELL_ROW_80_1061 VGND VPWR sky130_fd_sc_hd__tapvpwrvgnd_1
XFILLER_71_3 VGND VGND VPWR VPWR sky130_fd_sc_hd__decap_3
X_6470_ _6463_/X _6478_/B1 _5765_/X _6466_/X _6469_/X VGND VGND VPWR VPWR _6470_/X
+ sky130_fd_sc_hd__o221a_2
X_3682_ _7316_/Q _3761_/B _3761_/C _3680_/Y VGND VGND VPWR VPWR _3682_/X sky130_fd_sc_hd__a31o_2
X_5421_ _5421_/A0 _5726_/A1 _5423_/S VGND VGND VPWR VPWR _7149_/D sky130_fd_sc_hd__mux2_2
X_7022_ _7247_/CLK _7022_/D VGND VGND VPWR VPWR _7022_/Q sky130_fd_sc_hd__dfxtp_2
X_4234_ _6163_/C _4233_/B _4238_/B VGND VGND VPWR VPWR _4235_/C sky130_fd_sc_hd__a21oi_2
X_4165_ _4166_/A1 _4164_/X _6163_/A VGND VGND VPWR VPWR _4165_/Y sky130_fd_sc_hd__o21ai_2
XFILLER_28_539 VGND VGND VPWR VPWR sky130_fd_sc_hd__fill_1
XFILLER_55_325 VGND VGND VPWR VPWR sky130_fd_sc_hd__fill_1
X_4096_ _4093_/X _4094_/Y _4095_/X _3583_/Y VGND VGND VPWR VPWR _4096_/Y sky130_fd_sc_hd__o22ai_4
XFILLER_23_222 VGND VGND VPWR VPWR sky130_fd_sc_hd__fill_2
XFILLER_23_255 VGND VGND VPWR VPWR sky130_fd_sc_hd__decap_3
XFILLER_51_553 VGND VGND VPWR VPWR sky130_fd_sc_hd__decap_3
XFILLER_23_288 VGND VGND VPWR VPWR sky130_fd_sc_hd__fill_2
X_4998_ _4998_/A0 _5637_/A1 _4998_/S VGND VGND VPWR VPWR _6968_/D sky130_fd_sc_hd__mux2_2
X_6737_ _6078_/X _6737_/A1 _6775_/S VGND VGND VPWR VPWR _7529_/D sky130_fd_sc_hd__mux2_2
X_3949_ _7391_/Q _3949_/A2 _3901_/C _3948_/X VGND VGND VPWR VPWR _3951_/A sky130_fd_sc_hd__a31oi_4
XTAP_TAPCELL_ROW_21_445 VGND VPWR sky130_fd_sc_hd__tapvpwrvgnd_1
X_6668_ _6668_/A0 _6074_/X _6675_/S VGND VGND VPWR VPWR _7496_/D sky130_fd_sc_hd__mux2_2
XTAP_TAPCELL_ROW_94_1208 VGND VPWR sky130_fd_sc_hd__tapvpwrvgnd_1
XFILLER_3_605 VGND VGND VPWR VPWR sky130_fd_sc_hd__decap_3
XFILLER_3_6 VGND VGND VPWR VPWR sky130_fd_sc_hd__fill_2
XFILLER_2_159 VGND VGND VPWR VPWR sky130_fd_sc_hd__decap_3
XFILLER_58_141 VGND VGND VPWR VPWR sky130_fd_sc_hd__decap_3
XFILLER_46_325 VGND VGND VPWR VPWR sky130_fd_sc_hd__decap_3
XPHY_EDGE_ROW_100_Left_204 VGND VGND VPWR VPWR sky130_fd_sc_hd__decap_3
XTAP_TAPCELL_ROW_57_821 VGND VPWR sky130_fd_sc_hd__tapvpwrvgnd_1
XFILLER_46_358 VGND VGND VPWR VPWR sky130_fd_sc_hd__decap_3
XFILLER_73_133 VGND VGND VPWR VPWR sky130_fd_sc_hd__fill_1
XTAP_TAPCELL_ROW_29_523 VGND VPWR sky130_fd_sc_hd__tapvpwrvgnd_1
XFILLER_27_561 VGND VGND VPWR VPWR sky130_fd_sc_hd__decap_3
XFILLER_14_200 VGND VGND VPWR VPWR sky130_fd_sc_hd__fill_2
XFILLER_14_211 VGND VGND VPWR VPWR sky130_fd_sc_hd__fill_2
XFILLER_27_594 VGND VGND VPWR VPWR sky130_fd_sc_hd__decap_3
XFILLER_42_531 VGND VGND VPWR VPWR sky130_fd_sc_hd__fill_1
XFILLER_61_328 VGND VGND VPWR VPWR sky130_fd_sc_hd__decap_3
XTAP_TAPCELL_ROW_103_1315 VGND VPWR sky130_fd_sc_hd__tapvpwrvgnd_1
XTAP_TAPCELL_ROW_103_1304 VGND VPWR sky130_fd_sc_hd__tapvpwrvgnd_1
XFILLER_14_233 VGND VGND VPWR VPWR sky130_fd_sc_hd__decap_3
XFILLER_14_266 VGND VGND VPWR VPWR sky130_fd_sc_hd__fill_2
XFILLER_9_49 VGND VGND VPWR VPWR sky130_fd_sc_hd__decap_3
XFILLER_6_421 VGND VGND VPWR VPWR sky130_fd_sc_hd__decap_3
XFILLER_37_314 VGND VGND VPWR VPWR sky130_fd_sc_hd__decap_3
XFILLER_37_347 VGND VGND VPWR VPWR sky130_fd_sc_hd__decap_3
XFILLER_49_185 VGND VGND VPWR VPWR sky130_fd_sc_hd__decap_3
X_5970_ _6168_/B2 _7116_/Q _6864_/Q _6173_/B2 VGND VGND VPWR VPWR _5970_/Y sky130_fd_sc_hd__o22ai_2
XFILLER_33_520 VGND VGND VPWR VPWR sky130_fd_sc_hd__decap_3
XFILLER_45_380 VGND VGND VPWR VPWR sky130_fd_sc_hd__decap_3
XFILLER_64_188 VGND VGND VPWR VPWR sky130_fd_sc_hd__fill_1
XFILLER_100_19 VGND VGND VPWR VPWR sky130_fd_sc_hd__fill_1
XFILLER_20_203 VGND VGND VPWR VPWR sky130_fd_sc_hd__decap_3
XFILLER_60_372 VGND VGND VPWR VPWR sky130_fd_sc_hd__decap_3
X_3803_ _7404_/Q _3803_/B VGND VGND VPWR VPWR _3805_/C sky130_fd_sc_hd__nand2_2
X_7571_ _7575_/CLK _7571_/D place2035/X VGND VGND VPWR VPWR _7571_/Q sky130_fd_sc_hd__dfrtp_2
X_4783_ _4783_/A0 _5673_/A1 _4808_/S VGND VGND VPWR VPWR _6872_/D sky130_fd_sc_hd__mux2_2
X_6522_ _7432_/Q _6074_/X _6529_/S VGND VGND VPWR VPWR _7432_/D sky130_fd_sc_hd__mux2_2
X_3734_ _7386_/Q _3776_/A2 _3776_/A3 _3893_/A2 _7546_/Q VGND VGND VPWR VPWR _3734_/X
+ sky130_fd_sc_hd__a32o_2
XFILLER_9_281 VGND VGND VPWR VPWR sky130_fd_sc_hd__decap_3
X_6453_ _7262_/Q _6455_/B2 _6453_/B1 _7290_/Q _6452_/X VGND VGND VPWR VPWR _6453_/X
+ sky130_fd_sc_hd__o221a_2
X_3665_ _7447_/Q _3718_/B1 _3664_/X VGND VGND VPWR VPWR _3665_/Y sky130_fd_sc_hd__a21oi_2
X_5404_ _5404_/A0 _4707_/X _5410_/S VGND VGND VPWR VPWR _7141_/D sky130_fd_sc_hd__mux2_2
X_6384_ _6689_/A0 _6411_/A2 _6388_/A3 _6407_/S _7410_/Q VGND VGND VPWR VPWR _7410_/D
+ sky130_fd_sc_hd__a32o_2
XFILLER_0_608 VGND VGND VPWR VPWR sky130_fd_sc_hd__decap_3
Xhold2802 _7002_/Q VGND VGND VPWR VPWR _5072_/A0 sky130_fd_sc_hd__dlygate4sd3_1
Xhold2813 _7322_/Q VGND VGND VPWR VPWR _7580_/D sky130_fd_sc_hd__dlygate4sd3_1
XFILLER_87_258 VGND VGND VPWR VPWR sky130_fd_sc_hd__fill_2
Xhold2824 _7561_/Q VGND VGND VPWR VPWR _6805_/B sky130_fd_sc_hd__dlygate4sd3_1
Xhold2835 _7333_/Q VGND VGND VPWR VPWR _6252_/B sky130_fd_sc_hd__dlygate4sd3_1
Xhold2846 _7355_/Q VGND VGND VPWR VPWR _6298_/B sky130_fd_sc_hd__dlygate4sd3_1
Xhold2857 _7349_/Q VGND VGND VPWR VPWR _6286_/B sky130_fd_sc_hd__dlygate4sd3_1
X_7005_ _7290_/CLK _7005_/D VGND VGND VPWR VPWR _7005_/Q sky130_fd_sc_hd__dfxtp_2
X_4217_ _4220_/B _4217_/B VGND VGND VPWR VPWR _4217_/Y sky130_fd_sc_hd__nand2_2
XFILLER_68_483 VGND VGND VPWR VPWR sky130_fd_sc_hd__fill_1
Xhold2868 _7574_/Q VGND VGND VPWR VPWR _6832_/B sky130_fd_sc_hd__dlygate4sd3_1
Xhold2879 _7510_/Q VGND VGND VPWR VPWR _6698_/A0 sky130_fd_sc_hd__dlygate4sd3_1
XFILLER_55_111 VGND VGND VPWR VPWR sky130_fd_sc_hd__fill_1
X_4148_ _4148_/A _4148_/B VGND VGND VPWR VPWR _4154_/A sky130_fd_sc_hd__nand2_2
XFILLER_16_509 VGND VGND VPWR VPWR sky130_fd_sc_hd__fill_2
X_4079_ _4079_/A _4085_/D VGND VGND VPWR VPWR _7606_/D sky130_fd_sc_hd__nor2_2
XFILLER_24_520 VGND VGND VPWR VPWR sky130_fd_sc_hd__decap_3
XFILLER_43_328 VGND VGND VPWR VPWR sky130_fd_sc_hd__decap_3
XFILLER_11_203 VGND VGND VPWR VPWR sky130_fd_sc_hd__decap_3
XFILLER_11_225 VGND VGND VPWR VPWR sky130_fd_sc_hd__decap_3
XTAP_TAPCELL_ROW_34_581 VGND VPWR sky130_fd_sc_hd__tapvpwrvgnd_1
Xclkload1 clkload1/A VGND VGND VPWR VPWR clkload1/X sky130_fd_sc_hd__clkbuf_16
XFILLER_3_402 VGND VGND VPWR VPWR sky130_fd_sc_hd__decap_3
XFILLER_50_78 VGND VGND VPWR VPWR sky130_fd_sc_hd__decap_3
XFILLER_1_3 VGND VGND VPWR VPWR sky130_fd_sc_hd__decap_3
XFILLER_3_446 VGND VGND VPWR VPWR sky130_fd_sc_hd__fill_2
XFILLER_3_479 VGND VGND VPWR VPWR sky130_fd_sc_hd__fill_1
XFILLER_19_314 VGND VGND VPWR VPWR sky130_fd_sc_hd__fill_2
XTAP_TAPCELL_ROW_6_284 VGND VPWR sky130_fd_sc_hd__tapvpwrvgnd_1
XFILLER_34_306 VGND VGND VPWR VPWR sky130_fd_sc_hd__fill_2
XFILLER_46_144 VGND VGND VPWR VPWR sky130_fd_sc_hd__decap_3
XFILLER_46_177 VGND VGND VPWR VPWR sky130_fd_sc_hd__decap_3
XFILLER_61_125 VGND VGND VPWR VPWR sky130_fd_sc_hd__decap_3
XFILLER_27_391 VGND VGND VPWR VPWR sky130_fd_sc_hd__fill_1
XFILLER_61_158 VGND VGND VPWR VPWR sky130_fd_sc_hd__fill_1
XFILLER_61_169 VGND VGND VPWR VPWR sky130_fd_sc_hd__decap_3
XFILLER_91_85 VGND VGND VPWR VPWR sky130_fd_sc_hd__fill_1
XFILLER_30_523 VGND VGND VPWR VPWR sky130_fd_sc_hd__decap_3
XTAP_TAPCELL_ROW_60_849 VGND VPWR sky130_fd_sc_hd__tapvpwrvgnd_1
XFILLER_10_291 VGND VGND VPWR VPWR sky130_fd_sc_hd__decap_3
XFILLER_6_251 VGND VGND VPWR VPWR sky130_fd_sc_hd__fill_1
Xplace1407 _4236_/C VGND VGND VPWR VPWR _4238_/B sky130_fd_sc_hd__buf_2
XFILLER_6_295 VGND VGND VPWR VPWR sky130_fd_sc_hd__decap_3
Xplace1418 _6412_/B1 VGND VGND VPWR VPWR _6407_/S sky130_fd_sc_hd__buf_2
Xplace1429 _4108_/Y VGND VGND VPWR VPWR _4111_/A1 sky130_fd_sc_hd__buf_2
X_3450_ _3435_/Y _3436_/Y _3508_/C _3437_/X VGND VGND VPWR VPWR _3509_/B sky130_fd_sc_hd__a31oi_4
XFILLER_97_501 VGND VGND VPWR VPWR sky130_fd_sc_hd__decap_3
XFILLER_34_3 VGND VGND VPWR VPWR sky130_fd_sc_hd__fill_1
XFILLER_69_225 VGND VGND VPWR VPWR sky130_fd_sc_hd__decap_3
X_5120_ _5120_/A0 _5637_/A1 _5120_/S VGND VGND VPWR VPWR _7024_/D sky130_fd_sc_hd__mux2_2
X_5051_ _5051_/A0 _5446_/A1 _5057_/S VGND VGND VPWR VPWR _6992_/D sky130_fd_sc_hd__mux2_2
X_4002_ _4002_/A _4002_/B VGND VGND VPWR VPWR _4133_/B sky130_fd_sc_hd__nor2_2
XTAP_TAPCELL_ROW_68_938 VGND VPWR sky130_fd_sc_hd__tapvpwrvgnd_1
XFILLER_25_306 VGND VGND VPWR VPWR sky130_fd_sc_hd__decap_3
XFILLER_25_328 VGND VGND VPWR VPWR sky130_fd_sc_hd__decap_3
XFILLER_37_199 VGND VGND VPWR VPWR sky130_fd_sc_hd__decap_3
XFILLER_52_125 VGND VGND VPWR VPWR sky130_fd_sc_hd__decap_3
XFILLER_52_158 VGND VGND VPWR VPWR sky130_fd_sc_hd__decap_3
X_5953_ _5960_/B2 _7100_/Q _6848_/Q _6424_/B2 VGND VGND VPWR VPWR _5953_/X sky130_fd_sc_hd__o22a_2
XFILLER_40_309 VGND VGND VPWR VPWR sky130_fd_sc_hd__fill_1
X_5884_ _6448_/A1 _7065_/Q _6869_/Q _6448_/B2 VGND VGND VPWR VPWR _5884_/X sky130_fd_sc_hd__o22a_2
X_4904_ _4904_/A _4904_/B _4904_/C VGND VGND VPWR VPWR _5093_/C sky130_fd_sc_hd__and3_2
XFILLER_21_523 VGND VGND VPWR VPWR sky130_fd_sc_hd__decap_3
XFILLER_21_567 VGND VGND VPWR VPWR sky130_fd_sc_hd__decap_3
X_7554_ clkload9/A _7554_/D place2033/X VGND VGND VPWR VPWR _7554_/Q sky130_fd_sc_hd__dfrtp_2
XTAP_TAPCELL_ROW_31_551 VGND VPWR sky130_fd_sc_hd__tapvpwrvgnd_1
X_6505_ _6503_/X _6504_/X _6505_/B1 _6506_/A2 VGND VGND VPWR VPWR _6505_/X sky130_fd_sc_hd__a211o_2
X_3717_ _3717_/A1 _3792_/A2 _7385_/Q _3792_/B1 _7577_/Q VGND VGND VPWR VPWR _3717_/X
+ sky130_fd_sc_hd__a32o_2
XFILLER_20_15 VGND VGND VPWR VPWR sky130_fd_sc_hd__decap_3
X_7485_ clkload7/A _7485_/D place2026/X VGND VGND VPWR VPWR _7485_/Q sky130_fd_sc_hd__dfrtp_2
X_4697_ _7407_/Q _4725_/A2 _4697_/B1 _5979_/A VGND VGND VPWR VPWR _4697_/X sky130_fd_sc_hd__a211o_2
Xplace1930 _7518_/Q VGND VGND VPWR VPWR _6714_/A1 sky130_fd_sc_hd__buf_2
X_6436_ _6436_/A _6436_/B _6436_/C _6142_/B VGND VGND VPWR VPWR _6436_/X sky130_fd_sc_hd__or4b_2
X_3648_ _7314_/Q _4237_/A _4567_/D VGND VGND VPWR VPWR _4253_/B sky130_fd_sc_hd__a21oi_2
Xplace1963 _7318_/Q VGND VGND VPWR VPWR _4548_/A sky130_fd_sc_hd__buf_2
Xplace1952 _7366_/Q VGND VGND VPWR VPWR _6319_/B2 sky130_fd_sc_hd__buf_2
Xplace1941 _7402_/Q VGND VGND VPWR VPWR _6372_/B2 sky130_fd_sc_hd__buf_2
X_6367_ _6662_/A0 _6412_/A2 _6412_/A3 _6412_/B1 _6367_/B2 VGND VGND VPWR VPWR _7397_/D
+ sky130_fd_sc_hd__a32o_2
X_3579_ _3561_/A _3561_/B _3572_/X _3578_/Y _3576_/Y VGND VGND VPWR VPWR _3579_/X
+ sky130_fd_sc_hd__o2111a_2
XFILLER_0_405 VGND VGND VPWR VPWR sky130_fd_sc_hd__decap_3
Xplace1996 _7293_/Q VGND VGND VPWR VPWR _3473_/A sky130_fd_sc_hd__buf_4
Xplace1985 _7294_/Q VGND VGND VPWR VPWR _3522_/A2 sky130_fd_sc_hd__buf_2
Xplace1974 _7296_/Q VGND VGND VPWR VPWR _3481_/B sky130_fd_sc_hd__buf_2
XFILLER_0_449 VGND VGND VPWR VPWR sky130_fd_sc_hd__decap_3
XFILLER_29_24 VGND VGND VPWR VPWR sky130_fd_sc_hd__decap_3
Xhold2621 _7048_/Q VGND VGND VPWR VPWR _5173_/A0 sky130_fd_sc_hd__dlygate4sd3_1
Xhold2610 _7281_/Q VGND VGND VPWR VPWR _5709_/A0 sky130_fd_sc_hd__dlygate4sd3_1
X_6298_ _6298_/A _6298_/B VGND VGND VPWR VPWR _7355_/D sky130_fd_sc_hd__and2_2
XFILLER_102_388 VGND VGND VPWR VPWR sky130_fd_sc_hd__decap_3
XFILLER_29_57 VGND VGND VPWR VPWR sky130_fd_sc_hd__decap_3
Xhold2643 _6980_/Q VGND VGND VPWR VPWR _5024_/A0 sky130_fd_sc_hd__dlygate4sd3_1
Xhold2654 _7124_/Q VGND VGND VPWR VPWR _5368_/A0 sky130_fd_sc_hd__dlygate4sd3_1
Xhold2665 _7105_/Q VGND VGND VPWR VPWR _5325_/A0 sky130_fd_sc_hd__dlygate4sd3_1
Xhold2632 _7040_/Q VGND VGND VPWR VPWR _5156_/A0 sky130_fd_sc_hd__dlygate4sd3_1
X_5249_ _5249_/A0 _5572_/A1 _5255_/S VGND VGND VPWR VPWR _7078_/D sky130_fd_sc_hd__mux2_2
XFILLER_56_431 VGND VGND VPWR VPWR sky130_fd_sc_hd__decap_3
Xhold2676 _7179_/Q VGND VGND VPWR VPWR _5486_/A0 sky130_fd_sc_hd__dlygate4sd3_1
Xhold2687 _6975_/Q VGND VGND VPWR VPWR _5013_/A0 sky130_fd_sc_hd__dlygate4sd3_1
Xhold2698 _6850_/Q VGND VGND VPWR VPWR _4627_/A0 sky130_fd_sc_hd__dlygate4sd3_1
XFILLER_28_155 VGND VGND VPWR VPWR sky130_fd_sc_hd__decap_3
XTAP_TAPCELL_ROW_3_254 VGND VPWR sky130_fd_sc_hd__tapvpwrvgnd_1
XFILLER_16_317 VGND VGND VPWR VPWR sky130_fd_sc_hd__decap_3
XFILLER_16_339 VGND VGND VPWR VPWR sky130_fd_sc_hd__fill_1
XFILLER_28_177 VGND VGND VPWR VPWR sky130_fd_sc_hd__decap_3
XFILLER_43_125 VGND VGND VPWR VPWR sky130_fd_sc_hd__decap_3
XFILLER_56_486 VGND VGND VPWR VPWR sky130_fd_sc_hd__decap_3
XFILLER_71_412 VGND VGND VPWR VPWR sky130_fd_sc_hd__fill_1
XFILLER_43_169 VGND VGND VPWR VPWR sky130_fd_sc_hd__decap_3
XFILLER_71_478 VGND VGND VPWR VPWR sky130_fd_sc_hd__decap_3
XFILLER_51_180 VGND VGND VPWR VPWR sky130_fd_sc_hd__fill_2
XFILLER_12_589 VGND VGND VPWR VPWR sky130_fd_sc_hd__fill_2
XFILLER_61_66 VGND VGND VPWR VPWR sky130_fd_sc_hd__decap_3
XFILLER_8_516 VGND VGND VPWR VPWR sky130_fd_sc_hd__fill_1
XFILLER_61_99 VGND VGND VPWR VPWR sky130_fd_sc_hd__decap_3
XFILLER_66_217 VGND VGND VPWR VPWR sky130_fd_sc_hd__decap_3
XFILLER_19_111 VGND VGND VPWR VPWR sky130_fd_sc_hd__fill_1
XFILLER_47_431 VGND VGND VPWR VPWR sky130_fd_sc_hd__decap_3
XFILLER_86_85 VGND VGND VPWR VPWR sky130_fd_sc_hd__fill_1
XFILLER_19_133 VGND VGND VPWR VPWR sky130_fd_sc_hd__decap_3
XTAP_TAPCELL_ROW_65_908 VGND VPWR sky130_fd_sc_hd__tapvpwrvgnd_1
XFILLER_19_166 VGND VGND VPWR VPWR sky130_fd_sc_hd__fill_2
XFILLER_47_486 VGND VGND VPWR VPWR sky130_fd_sc_hd__decap_3
XFILLER_22_309 VGND VGND VPWR VPWR sky130_fd_sc_hd__decap_3
XTAP_TAPCELL_ROW_73_985 VGND VPWR sky130_fd_sc_hd__tapvpwrvgnd_1
XTAP_TAPCELL_ROW_45_698 VGND VPWR sky130_fd_sc_hd__tapvpwrvgnd_1
XFILLER_30_386 VGND VGND VPWR VPWR sky130_fd_sc_hd__fill_1
Xplace1204 _4900_/S VGND VGND VPWR VPWR _4902_/S sky130_fd_sc_hd__buf_2
Xplace1215 _4475_/S VGND VGND VPWR VPWR _4388_/S sky130_fd_sc_hd__buf_2
X_7270_ _7274_/CLK _7270_/D VGND VGND VPWR VPWR _7270_/Q sky130_fd_sc_hd__dfxtp_2
X_4482_ _7308_/Q _4482_/B _4482_/C _4495_/A VGND VGND VPWR VPWR _4482_/X sky130_fd_sc_hd__or4b_2
X_3502_ _3502_/A _3502_/B VGND VGND VPWR VPWR _3502_/Y sky130_fd_sc_hd__nand2_2
XTAP_TAPCELL_ROW_77_1033 VGND VPWR sky130_fd_sc_hd__tapvpwrvgnd_1
Xplace1226 _5772_/Y VGND VGND VPWR VPWR _6395_/B1 sky130_fd_sc_hd__buf_2
Xplace1237 _5425_/S VGND VGND VPWR VPWR _5410_/S sky130_fd_sc_hd__buf_2
Xplace1248 _4020_/A VGND VGND VPWR VPWR _4735_/D sky130_fd_sc_hd__buf_6
Xplace1259 _4114_/A VGND VGND VPWR VPWR _6070_/A2 sky130_fd_sc_hd__buf_2
X_6221_ _6559_/A1 _6347_/D _6559_/B1 _4289_/Y _6221_/D1 VGND VGND VPWR VPWR _6221_/Y
+ sky130_fd_sc_hd__o2111ai_2
X_3433_ _3433_/A _3443_/C VGND VGND VPWR VPWR _3433_/Y sky130_fd_sc_hd__nand2_2
X_6152_ _6175_/A2 _7001_/Q _6973_/Q _6165_/A1 VGND VGND VPWR VPWR _6152_/X sky130_fd_sc_hd__o22a_2
X_5103_ _5103_/A0 _5376_/A1 _5120_/S VGND VGND VPWR VPWR _7016_/D sky130_fd_sc_hd__mux2_2
X_6083_ _6089_/A1 _6082_/X _6083_/B1 VGND VGND VPWR VPWR _6083_/Y sky130_fd_sc_hd__o21ai_4
XFILLER_57_228 VGND VGND VPWR VPWR sky130_fd_sc_hd__decap_3
X_5034_ _5034_/A0 _5673_/A1 _5091_/S VGND VGND VPWR VPWR _6984_/D sky130_fd_sc_hd__mux2_2
XTAP_TAPCELL_ROW_88_1151 VGND VPWR sky130_fd_sc_hd__tapvpwrvgnd_1
XFILLER_65_261 VGND VGND VPWR VPWR sky130_fd_sc_hd__decap_3
XTAP_TAPCELL_ROW_0_224 VGND VPWR sky130_fd_sc_hd__tapvpwrvgnd_1
XTAP_TAPCELL_ROW_0_213 VGND VPWR sky130_fd_sc_hd__tapvpwrvgnd_1
XFILLER_25_136 VGND VGND VPWR VPWR sky130_fd_sc_hd__decap_3
X_6985_ _7490_/CLK _6985_/D VGND VGND VPWR VPWR _6985_/Q sky130_fd_sc_hd__dfxtp_2
XFILLER_25_169 VGND VGND VPWR VPWR sky130_fd_sc_hd__decap_3
XFILLER_53_478 VGND VGND VPWR VPWR sky130_fd_sc_hd__decap_3
XFILLER_80_253 VGND VGND VPWR VPWR sky130_fd_sc_hd__fill_2
XFILLER_33_191 VGND VGND VPWR VPWR sky130_fd_sc_hd__decap_3
X_7606_ _7606_/CLK _7606_/D place2051/X VGND VGND VPWR VPWR _7606_/Q sky130_fd_sc_hd__dfrtp_2
XFILLER_31_47 VGND VGND VPWR VPWR sky130_fd_sc_hd__decap_3
X_7537_ _7611_/CLK _7537_/D place2058/X VGND VGND VPWR VPWR _7537_/Q sky130_fd_sc_hd__dfrtp_2
X_4749_ _4734_/X _4751_/A2 _4767_/B1 _4767_/B2 VGND VGND VPWR VPWR _4749_/X sky130_fd_sc_hd__a2bb2o_2
X_7468_ clkload3/A _7468_/D place2057/X VGND VGND VPWR VPWR _7468_/Q sky130_fd_sc_hd__dfrtp_2
XTAP_TAPCELL_ROW_8_302 VGND VPWR sky130_fd_sc_hd__tapvpwrvgnd_1
Xplace1760 _6662_/S VGND VGND VPWR VPWR _6704_/S sky130_fd_sc_hd__buf_2
Xplace1771 _3975_/C VGND VGND VPWR VPWR _6789_/A sky130_fd_sc_hd__buf_2
X_7399_ _7493_/CLK _7399_/D place2042/X VGND VGND VPWR VPWR _7399_/Q sky130_fd_sc_hd__dfrtp_2
XFILLER_0_213 VGND VGND VPWR VPWR sky130_fd_sc_hd__fill_1
XFILLER_0_246 VGND VGND VPWR VPWR sky130_fd_sc_hd__decap_3
Xplace1793 _3561_/B VGND VGND VPWR VPWR _4468_/C1 sky130_fd_sc_hd__buf_2
Xplace1782 _3440_/X VGND VGND VPWR VPWR _5841_/B sky130_fd_sc_hd__buf_2
XFILLER_0_279 VGND VGND VPWR VPWR sky130_fd_sc_hd__fill_1
Xhold2440 _7243_/Q VGND VGND VPWR VPWR _5627_/A0 sky130_fd_sc_hd__dlygate4sd3_1
Xhold2473 _7290_/Q VGND VGND VPWR VPWR _5728_/A0 sky130_fd_sc_hd__dlygate4sd3_1
Xhold2462 _6874_/Q VGND VGND VPWR VPWR _4787_/A0 sky130_fd_sc_hd__dlygate4sd3_1
Xhold2451 _7093_/Q VGND VGND VPWR VPWR _5296_/A0 sky130_fd_sc_hd__dlygate4sd3_1
XFILLER_29_442 VGND VGND VPWR VPWR sky130_fd_sc_hd__decap_3
XFILLER_29_464 VGND VGND VPWR VPWR sky130_fd_sc_hd__fill_2
Xhold2495 _6933_/Q VGND VGND VPWR VPWR _4918_/A0 sky130_fd_sc_hd__dlygate4sd3_1
Xhold2484 _6905_/Q VGND VGND VPWR VPWR _4856_/A0 sky130_fd_sc_hd__dlygate4sd3_1
XFILLER_29_497 VGND VGND VPWR VPWR sky130_fd_sc_hd__decap_3
XFILLER_56_88 VGND VGND VPWR VPWR sky130_fd_sc_hd__decap_3
XFILLER_84_592 VGND VGND VPWR VPWR sky130_fd_sc_hd__decap_3
XFILLER_71_231 VGND VGND VPWR VPWR sky130_fd_sc_hd__fill_2
XFILLER_16_169 VGND VGND VPWR VPWR sky130_fd_sc_hd__decap_3
XFILLER_44_467 VGND VGND VPWR VPWR sky130_fd_sc_hd__decap_3
XFILLER_24_180 VGND VGND VPWR VPWR sky130_fd_sc_hd__decap_3
XTAP_TAPCELL_ROW_70_955 VGND VPWR sky130_fd_sc_hd__tapvpwrvgnd_1
XFILLER_24_191 VGND VGND VPWR VPWR sky130_fd_sc_hd__decap_3
XTAP_TAPCELL_ROW_42_668 VGND VPWR sky130_fd_sc_hd__tapvpwrvgnd_1
XFILLER_8_379 VGND VGND VPWR VPWR sky130_fd_sc_hd__fill_1
XFILLER_4_541 VGND VGND VPWR VPWR sky130_fd_sc_hd__fill_2
XFILLER_4_574 VGND VGND VPWR VPWR sky130_fd_sc_hd__decap_3
XFILLER_39_228 VGND VGND VPWR VPWR sky130_fd_sc_hd__decap_3
XFILLER_54_209 VGND VGND VPWR VPWR sky130_fd_sc_hd__decap_3
XFILLER_35_423 VGND VGND VPWR VPWR sky130_fd_sc_hd__decap_3
XFILLER_75_592 VGND VGND VPWR VPWR sky130_fd_sc_hd__decap_3
XFILLER_47_294 VGND VGND VPWR VPWR sky130_fd_sc_hd__decap_3
XFILLER_62_231 VGND VGND VPWR VPWR sky130_fd_sc_hd__decap_3
XFILLER_22_106 VGND VGND VPWR VPWR sky130_fd_sc_hd__fill_1
XFILLER_23_607 VGND VGND VPWR VPWR sky130_fd_sc_hd__decap_3
X_3982_ _3982_/A _3982_/B VGND VGND VPWR VPWR _3988_/A sky130_fd_sc_hd__nor2_2
XFILLER_50_459 VGND VGND VPWR VPWR sky130_fd_sc_hd__decap_3
XTAP_TAPCELL_ROW_83_1092 VGND VPWR sky130_fd_sc_hd__tapvpwrvgnd_1
XFILLER_30_161 VGND VGND VPWR VPWR sky130_fd_sc_hd__fill_1
X_5652_ _5652_/A0 _5713_/A1 _5654_/S VGND VGND VPWR VPWR _7255_/D sky130_fd_sc_hd__mux2_2
X_5583_ _5583_/A0 _4693_/X _5593_/S VGND VGND VPWR VPWR _7223_/D sky130_fd_sc_hd__mux2_2
X_4603_ _4603_/A0 _5376_/A1 _4665_/S VGND VGND VPWR VPWR _6848_/D sky130_fd_sc_hd__mux2_2
X_7322_ clkload2/A _7322_/D place2029/X VGND VGND VPWR VPWR _7322_/Q sky130_fd_sc_hd__dfrtp_2
X_4534_ _4538_/S _4531_/Y _4542_/C _4533_/X VGND VGND VPWR VPWR _4534_/Y sky130_fd_sc_hd__o31ai_2
XFILLER_7_390 VGND VGND VPWR VPWR sky130_fd_sc_hd__fill_2
X_7253_ _7509_/CLK _7253_/D VGND VGND VPWR VPWR _7253_/Q sky130_fd_sc_hd__dfxtp_2
X_4465_ _7304_/Q _4482_/B _4456_/Y VGND VGND VPWR VPWR _4466_/B sky130_fd_sc_hd__a21bo_2
Xplace1089 _4269_/C VGND VGND VPWR VPWR _6389_/C sky130_fd_sc_hd__buf_2
X_7184_ _7490_/CLK _7184_/D VGND VGND VPWR VPWR _7184_/Q sky130_fd_sc_hd__dfxtp_2
X_6204_ _7091_/Q _6204_/A2 _6455_/A1 _7119_/Q _6203_/X VGND VGND VPWR VPWR _6204_/X
+ sky130_fd_sc_hd__o221a_2
X_4396_ _4396_/A _4396_/B VGND VGND VPWR VPWR _4396_/Y sky130_fd_sc_hd__nand2_2
X_3416_ _7295_/Q VGND VGND VPWR VPWR _3416_/Y sky130_fd_sc_hd__inv_2
X_6135_ _6146_/B1 _7028_/Q _6944_/Q _6399_/B2 VGND VGND VPWR VPWR _6135_/X sky130_fd_sc_hd__o22a_4
X_6066_ _6965_/Q _6501_/A1 _6064_/X _6065_/X VGND VGND VPWR VPWR _6066_/X sky130_fd_sc_hd__o211a_2
XFILLER_45_209 VGND VGND VPWR VPWR sky130_fd_sc_hd__decap_3
XFILLER_26_456 VGND VGND VPWR VPWR sky130_fd_sc_hd__decap_3
XFILLER_53_220 VGND VGND VPWR VPWR sky130_fd_sc_hd__decap_3
XFILLER_26_489 VGND VGND VPWR VPWR sky130_fd_sc_hd__decap_3
XFILLER_26_58 VGND VGND VPWR VPWR sky130_fd_sc_hd__decap_3
XFILLER_13_139 VGND VGND VPWR VPWR sky130_fd_sc_hd__decap_3
X_6968_ _7241_/CLK _6968_/D VGND VGND VPWR VPWR _6968_/Q sky130_fd_sc_hd__dfxtp_2
XFILLER_41_459 VGND VGND VPWR VPWR sky130_fd_sc_hd__decap_3
X_6899_ _7291_/CLK _6899_/D VGND VGND VPWR VPWR _6899_/Q sky130_fd_sc_hd__dfxtp_2
X_5919_ _6511_/A1 _7190_/Q _7162_/Q _6511_/B2 VGND VGND VPWR VPWR _5919_/X sky130_fd_sc_hd__o22a_2
XFILLER_21_161 VGND VGND VPWR VPWR sky130_fd_sc_hd__decap_3
XTAP_TAPCELL_ROW_97_1239 VGND VPWR sky130_fd_sc_hd__tapvpwrvgnd_1
XFILLER_49_515 VGND VGND VPWR VPWR sky130_fd_sc_hd__fill_1
Xplace1590 _4735_/C VGND VGND VPWR VPWR _4726_/A2 sky130_fd_sc_hd__buf_2
XFILLER_29_261 VGND VGND VPWR VPWR sky130_fd_sc_hd__decap_3
XFILLER_36_209 VGND VGND VPWR VPWR sky130_fd_sc_hd__decap_3
XFILLER_64_529 VGND VGND VPWR VPWR sky130_fd_sc_hd__decap_3
XTAP_TAPCELL_ROW_47_716 VGND VPWR sky130_fd_sc_hd__tapvpwrvgnd_1
XTAP_TAPCELL_ROW_19_418 VGND VPWR sky130_fd_sc_hd__tapvpwrvgnd_1
XFILLER_83_20 VGND VGND VPWR VPWR sky130_fd_sc_hd__decap_3
XFILLER_83_42 VGND VGND VPWR VPWR sky130_fd_sc_hd__fill_2
XFILLER_32_448 VGND VGND VPWR VPWR sky130_fd_sc_hd__decap_3
XFILLER_9_611 VGND VGND VPWR VPWR sky130_fd_sc_hd__fill_1
XFILLER_12_194 VGND VGND VPWR VPWR sky130_fd_sc_hd__fill_2
XFILLER_66_6 VGND VGND VPWR VPWR sky130_fd_sc_hd__fill_1
XFILLER_8_187 VGND VGND VPWR VPWR sky130_fd_sc_hd__decap_3
XTAP_TAPCELL_ROW_74_1003 VGND VPWR sky130_fd_sc_hd__tapvpwrvgnd_1
X_4250_ _4247_/Y _4249_/C _4240_/Y _4254_/A _4250_/C1 VGND VGND VPWR VPWR _4251_/B
+ sky130_fd_sc_hd__a221o_2
XFILLER_67_312 VGND VGND VPWR VPWR sky130_fd_sc_hd__decap_3
XFILLER_67_389 VGND VGND VPWR VPWR sky130_fd_sc_hd__decap_3
XFILLER_82_359 VGND VGND VPWR VPWR sky130_fd_sc_hd__decap_3
XFILLER_94_197 VGND VGND VPWR VPWR sky130_fd_sc_hd__fill_1
X_6822_ _6840_/A _6822_/B VGND VGND VPWR VPWR _7569_/D sky130_fd_sc_hd__and2_2
XFILLER_23_437 VGND VGND VPWR VPWR sky130_fd_sc_hd__decap_3
XFILLER_35_275 VGND VGND VPWR VPWR sky130_fd_sc_hd__decap_3
X_3965_ _7520_/Q _5734_/A _3965_/B1 _7456_/Q VGND VGND VPWR VPWR _3969_/A sky130_fd_sc_hd__a22oi_2
X_3896_ _3946_/B _3896_/B _3896_/C _4279_/D VGND VGND VPWR VPWR _3896_/X sky130_fd_sc_hd__and4b_2
XFILLER_31_492 VGND VGND VPWR VPWR sky130_fd_sc_hd__decap_3
X_5635_ _5635_/A0 _5635_/A1 _5635_/S VGND VGND VPWR VPWR _7247_/D sky130_fd_sc_hd__mux2_2
X_5566_ _5566_/A0 _5566_/A1 _5608_/S VGND VGND VPWR VPWR _7215_/D sky130_fd_sc_hd__mux2_2
X_7305_ _7611_/CLK _7305_/D place2058/X VGND VGND VPWR VPWR _7305_/Q sky130_fd_sc_hd__dfrtp_2
X_4517_ _4516_/X _6756_/A1 _4539_/S VGND VGND VPWR VPWR _7312_/D sky130_fd_sc_hd__mux2_2
X_7236_ _7276_/CLK _7236_/D VGND VGND VPWR VPWR _7236_/Q sky130_fd_sc_hd__dfxtp_2
X_4448_ _4448_/A _4448_/B _4448_/C VGND VGND VPWR VPWR _4448_/X sky130_fd_sc_hd__and3_2
X_7167_ _7407_/CLK _7167_/D VGND VGND VPWR VPWR _7167_/Q sky130_fd_sc_hd__dfxtp_2
X_4379_ _4379_/A _4379_/B _4448_/B VGND VGND VPWR VPWR _4420_/B sky130_fd_sc_hd__and3_2
X_7098_ _7266_/CLK _7098_/D VGND VGND VPWR VPWR _7098_/Q sky130_fd_sc_hd__dfxtp_2
X_6118_ _7083_/Q _6146_/A2 _6146_/B1 _7111_/Q _6117_/X VGND VGND VPWR VPWR _6118_/X
+ sky130_fd_sc_hd__o221a_2
XFILLER_37_57 VGND VGND VPWR VPWR sky130_fd_sc_hd__decap_3
XFILLER_39_570 VGND VGND VPWR VPWR sky130_fd_sc_hd__fill_1
XFILLER_46_518 VGND VGND VPWR VPWR sky130_fd_sc_hd__fill_1
X_6049_ _6484_/B2 _6908_/Q _7244_/Q _6483_/B2 VGND VGND VPWR VPWR _6049_/X sky130_fd_sc_hd__o22a_2
XFILLER_53_45 VGND VGND VPWR VPWR sky130_fd_sc_hd__decap_3
XFILLER_22_470 VGND VGND VPWR VPWR sky130_fd_sc_hd__decap_3
XFILLER_53_89 VGND VGND VPWR VPWR sky130_fd_sc_hd__decap_3
XTAP_TAPCELL_ROW_52_774 VGND VPWR sky130_fd_sc_hd__tapvpwrvgnd_1
XTAP_TAPCELL_ROW_24_476 VGND VPWR sky130_fd_sc_hd__tapvpwrvgnd_1
XFILLER_22_492 VGND VGND VPWR VPWR sky130_fd_sc_hd__decap_3
XTAP_TAPCELL_ROW_101_1287 VGND VPWR sky130_fd_sc_hd__tapvpwrvgnd_1
XFILLER_5_113 VGND VGND VPWR VPWR sky130_fd_sc_hd__decap_3
XFILLER_5_135 VGND VGND VPWR VPWR sky130_fd_sc_hd__decap_3
XFILLER_96_418 VGND VGND VPWR VPWR sky130_fd_sc_hd__fill_2
XFILLER_94_85 VGND VGND VPWR VPWR sky130_fd_sc_hd__fill_1
XFILLER_32_256 VGND VGND VPWR VPWR sky130_fd_sc_hd__decap_3
XFILLER_20_418 VGND VGND VPWR VPWR sky130_fd_sc_hd__fill_2
XFILLER_32_289 VGND VGND VPWR VPWR sky130_fd_sc_hd__fill_2
X_3750_ _7311_/Q _3761_/B _3931_/C VGND VGND VPWR VPWR _3750_/X sky130_fd_sc_hd__and3_2
XTAP_TAPCELL_ROW_80_1062 VGND VPWR sky130_fd_sc_hd__tapvpwrvgnd_1
X_5351_ _5351_/A0 _5351_/A1 _5361_/S VGND VGND VPWR VPWR _7117_/D sky130_fd_sc_hd__mux2_2
XFILLER_4_190 VGND VGND VPWR VPWR sky130_fd_sc_hd__decap_3
X_7021_ _7273_/CLK _7021_/D VGND VGND VPWR VPWR _7021_/Q sky130_fd_sc_hd__dfxtp_2
X_4233_ _4233_/A _4233_/B _4238_/B VGND VGND VPWR VPWR _4235_/B sky130_fd_sc_hd__and3_2
XFILLER_4_94 VGND VGND VPWR VPWR sky130_fd_sc_hd__decap_3
XFILLER_68_610 VGND VGND VPWR VPWR sky130_fd_sc_hd__fill_2
XTAP_TAPCELL_ROW_91_1180 VGND VPWR sky130_fd_sc_hd__tapvpwrvgnd_1
X_4164_ _4157_/B _4164_/B VGND VGND VPWR VPWR _4164_/X sky130_fd_sc_hd__and2b_2
XFILLER_28_518 VGND VGND VPWR VPWR sky130_fd_sc_hd__fill_1
XFILLER_28_529 VGND VGND VPWR VPWR sky130_fd_sc_hd__decap_3
X_4095_ _7323_/Q _3969_/D _4395_/A1 _4095_/B2 _3563_/Y VGND VGND VPWR VPWR _4095_/X
+ sky130_fd_sc_hd__o221a_2
XFILLER_55_348 VGND VGND VPWR VPWR sky130_fd_sc_hd__decap_3
XFILLER_23_234 VGND VGND VPWR VPWR sky130_fd_sc_hd__decap_3
X_6805_ _6805_/A _6805_/B VGND VGND VPWR VPWR _7561_/D sky130_fd_sc_hd__and2_2
XFILLER_23_15 VGND VGND VPWR VPWR sky130_fd_sc_hd__decap_3
XFILLER_23_267 VGND VGND VPWR VPWR sky130_fd_sc_hd__decap_3
X_3948_ _7359_/Q _3948_/B _3948_/C VGND VGND VPWR VPWR _3948_/X sky130_fd_sc_hd__and3_2
XFILLER_99_19 VGND VGND VPWR VPWR sky130_fd_sc_hd__fill_1
X_3879_ _7528_/Q _3879_/A2 _3878_/X VGND VGND VPWR VPWR _3882_/A sky130_fd_sc_hd__a21oi_2
XTAP_TAPCELL_ROW_21_446 VGND VPWR sky130_fd_sc_hd__tapvpwrvgnd_1
X_6598_ _6598_/A0 _6058_/X _6607_/S VGND VGND VPWR VPWR _7463_/D sky130_fd_sc_hd__mux2_2
X_5618_ _5618_/A0 _5679_/A1 _5635_/S VGND VGND VPWR VPWR _7239_/D sky130_fd_sc_hd__mux2_2
XTAP_TAPCELL_ROW_94_1209 VGND VPWR sky130_fd_sc_hd__tapvpwrvgnd_1
X_5549_ _5671_/A _5549_/B _5549_/C VGND VGND VPWR VPWR _5576_/S sky130_fd_sc_hd__and3_2
XFILLER_78_418 VGND VGND VPWR VPWR sky130_fd_sc_hd__fill_2
X_7219_ _7247_/CLK _7219_/D VGND VGND VPWR VPWR _7219_/Q sky130_fd_sc_hd__dfxtp_2
XFILLER_48_67 VGND VGND VPWR VPWR sky130_fd_sc_hd__fill_2
XFILLER_48_78 VGND VGND VPWR VPWR sky130_fd_sc_hd__decap_3
XFILLER_46_337 VGND VGND VPWR VPWR sky130_fd_sc_hd__decap_3
XFILLER_58_197 VGND VGND VPWR VPWR sky130_fd_sc_hd__fill_2
XTAP_TAPCELL_ROW_57_822 VGND VPWR sky130_fd_sc_hd__tapvpwrvgnd_1
XTAP_TAPCELL_ROW_29_524 VGND VPWR sky130_fd_sc_hd__tapvpwrvgnd_1
XFILLER_61_318 VGND VGND VPWR VPWR sky130_fd_sc_hd__decap_3
XFILLER_27_573 VGND VGND VPWR VPWR sky130_fd_sc_hd__decap_3
XFILLER_42_510 VGND VGND VPWR VPWR sky130_fd_sc_hd__decap_3
XTAP_TAPCELL_ROW_103_1316 VGND VPWR sky130_fd_sc_hd__tapvpwrvgnd_1
XTAP_TAPCELL_ROW_103_1305 VGND VPWR sky130_fd_sc_hd__tapvpwrvgnd_1
XFILLER_14_245 VGND VGND VPWR VPWR sky130_fd_sc_hd__decap_3
XFILLER_10_451 VGND VGND VPWR VPWR sky130_fd_sc_hd__decap_3
XFILLER_13_70 VGND VGND VPWR VPWR sky130_fd_sc_hd__decap_3
XFILLER_6_477 VGND VGND VPWR VPWR sky130_fd_sc_hd__decap_3
XFILLER_49_153 VGND VGND VPWR VPWR sky130_fd_sc_hd__decap_3
XFILLER_37_326 VGND VGND VPWR VPWR sky130_fd_sc_hd__decap_3
XFILLER_37_337 VGND VGND VPWR VPWR sky130_fd_sc_hd__fill_1
XFILLER_64_156 VGND VGND VPWR VPWR sky130_fd_sc_hd__fill_2
X_4920_ _4920_/A0 _5686_/A1 _4952_/S VGND VGND VPWR VPWR _6934_/D sky130_fd_sc_hd__mux2_2
XFILLER_33_532 VGND VGND VPWR VPWR sky130_fd_sc_hd__fill_1
XFILLER_33_543 VGND VGND VPWR VPWR sky130_fd_sc_hd__decap_3
X_4851_ _4851_/A0 _5312_/A1 _4868_/S VGND VGND VPWR VPWR _6903_/D sky130_fd_sc_hd__mux2_2
XFILLER_60_362 VGND VGND VPWR VPWR sky130_fd_sc_hd__fill_2
X_3802_ _4510_/A _4510_/B _3802_/C _7532_/Q VGND VGND VPWR VPWR _3805_/B sky130_fd_sc_hd__or4b_4
XFILLER_20_215 VGND VGND VPWR VPWR sky130_fd_sc_hd__decap_3
X_7570_ _7579_/CLK _7570_/D place2012/X VGND VGND VPWR VPWR _7570_/Q sky130_fd_sc_hd__dfrtp_2
X_3733_ _7354_/Q _3733_/A2 _3732_/X VGND VGND VPWR VPWR _3738_/C sky130_fd_sc_hd__a21oi_2
X_6452_ _4970_/A _4970_/B _4970_/C _6898_/Q _4970_/D VGND VGND VPWR VPWR _6452_/X
+ sky130_fd_sc_hd__a311o_2
X_3664_ _7415_/Q _6662_/S _3781_/B1 _7351_/Q _3663_/X VGND VGND VPWR VPWR _3664_/X
+ sky130_fd_sc_hd__a221o_2
Xoutput2100 place216/X VGND VGND VPWR VPWR result[8] sky130_fd_sc_hd__clkdlybuf4s25_1
Xclkload30 _7264_/CLK VGND VGND VPWR VPWR clkload30/Y sky130_fd_sc_hd__inv_6
X_6383_ _6687_/A0 _6411_/A2 _6411_/A3 _6411_/B1 _6383_/B2 VGND VGND VPWR VPWR _7409_/D
+ sky130_fd_sc_hd__a32o_2
X_5334_ _5334_/A0 _5334_/A1 _5357_/S VGND VGND VPWR VPWR _7109_/D sky130_fd_sc_hd__mux2_2
Xhold2803 _7032_/Q VGND VGND VPWR VPWR _5137_/A0 sky130_fd_sc_hd__dlygate4sd3_1
Xhold2814 _6944_/Q VGND VGND VPWR VPWR _4941_/A0 sky130_fd_sc_hd__dlygate4sd3_1
X_5265_ _5265_/A0 _5705_/A1 _5293_/S VGND VGND VPWR VPWR _7083_/D sky130_fd_sc_hd__mux2_2
Xhold2825 _7335_/Q VGND VGND VPWR VPWR _6256_/B sky130_fd_sc_hd__dlygate4sd3_1
Xhold2836 _7341_/Q VGND VGND VPWR VPWR _6269_/B sky130_fd_sc_hd__dlygate4sd3_1
Xhold2847 _7577_/Q VGND VGND VPWR VPWR _6838_/B sky130_fd_sc_hd__dlygate4sd3_1
X_7004_ _7235_/CLK _7004_/D VGND VGND VPWR VPWR _7004_/Q sky130_fd_sc_hd__dfxtp_2
X_5196_ _5196_/A0 _5713_/A1 _5213_/S VGND VGND VPWR VPWR _7059_/D sky130_fd_sc_hd__mux2_2
X_4216_ _4216_/A1 _4194_/Y _4221_/A2 VGND VGND VPWR VPWR _4216_/X sky130_fd_sc_hd__o21a_2
XFILLER_18_15 VGND VGND VPWR VPWR sky130_fd_sc_hd__decap_3
XFILLER_28_315 VGND VGND VPWR VPWR sky130_fd_sc_hd__decap_3
Xhold2858 _7342_/Q VGND VGND VPWR VPWR _6271_/B sky130_fd_sc_hd__dlygate4sd3_1
Xhold2869 _7328_/Q VGND VGND VPWR VPWR _6241_/B sky130_fd_sc_hd__dlygate4sd3_1
X_4147_ _4152_/B _4152_/A _4146_/X VGND VGND VPWR VPWR _4147_/Y sky130_fd_sc_hd__a21boi_2
XFILLER_55_123 VGND VGND VPWR VPWR sky130_fd_sc_hd__decap_3
XFILLER_55_167 VGND VGND VPWR VPWR sky130_fd_sc_hd__fill_1
XFILLER_24_554 VGND VGND VPWR VPWR sky130_fd_sc_hd__decap_3
XFILLER_34_25 VGND VGND VPWR VPWR sky130_fd_sc_hd__decap_3
XFILLER_24_565 VGND VGND VPWR VPWR sky130_fd_sc_hd__decap_3
XFILLER_51_351 VGND VGND VPWR VPWR sky130_fd_sc_hd__fill_1
XFILLER_11_237 VGND VGND VPWR VPWR sky130_fd_sc_hd__decap_3
XTAP_TAPCELL_ROW_34_582 VGND VPWR sky130_fd_sc_hd__tapvpwrvgnd_1
Xclkload2 clkload2/A VGND VGND VPWR VPWR clkload2/X sky130_fd_sc_hd__clkbuf_8
XFILLER_59_55 VGND VGND VPWR VPWR sky130_fd_sc_hd__fill_1
XFILLER_78_248 VGND VGND VPWR VPWR sky130_fd_sc_hd__decap_3
XTAP_TAPCELL_ROW_6_285 VGND VPWR sky130_fd_sc_hd__tapvpwrvgnd_1
XFILLER_101_592 VGND VGND VPWR VPWR sky130_fd_sc_hd__decap_3
XFILLER_19_337 VGND VGND VPWR VPWR sky130_fd_sc_hd__decap_3
XFILLER_46_123 VGND VGND VPWR VPWR sky130_fd_sc_hd__decap_3
XFILLER_74_421 VGND VGND VPWR VPWR sky130_fd_sc_hd__decap_3
XFILLER_34_318 VGND VGND VPWR VPWR sky130_fd_sc_hd__decap_3
XFILLER_46_189 VGND VGND VPWR VPWR sky130_fd_sc_hd__decap_3
XFILLER_42_362 VGND VGND VPWR VPWR sky130_fd_sc_hd__fill_2
XFILLER_24_91 VGND VGND VPWR VPWR sky130_fd_sc_hd__decap_3
Xplace1408 _3762_/Y VGND VGND VPWR VPWR _4228_/D sky130_fd_sc_hd__buf_2
Xplace1419 _6348_/S VGND VGND VPWR VPWR _6412_/B1 sky130_fd_sc_hd__buf_2
XFILLER_2_480 VGND VGND VPWR VPWR sky130_fd_sc_hd__fill_2
XFILLER_2_491 VGND VGND VPWR VPWR sky130_fd_sc_hd__fill_2
XFILLER_69_237 VGND VGND VPWR VPWR sky130_fd_sc_hd__decap_3
XFILLER_27_3 VGND VGND VPWR VPWR sky130_fd_sc_hd__decap_3
X_4001_ _4001_/A _4001_/B VGND VGND VPWR VPWR _4002_/B sky130_fd_sc_hd__and2_2
XTAP_TAPCELL_ROW_68_939 VGND VPWR sky130_fd_sc_hd__tapvpwrvgnd_1
XFILLER_65_410 VGND VGND VPWR VPWR sky130_fd_sc_hd__decap_3
XFILLER_77_281 VGND VGND VPWR VPWR sky130_fd_sc_hd__fill_1
XFILLER_77_292 VGND VGND VPWR VPWR sky130_fd_sc_hd__fill_1
XFILLER_37_145 VGND VGND VPWR VPWR sky130_fd_sc_hd__fill_2
XFILLER_37_167 VGND VGND VPWR VPWR sky130_fd_sc_hd__fill_1
XFILLER_52_104 VGND VGND VPWR VPWR sky130_fd_sc_hd__decap_3
XFILLER_80_457 VGND VGND VPWR VPWR sky130_fd_sc_hd__fill_2
XFILLER_33_340 VGND VGND VPWR VPWR sky130_fd_sc_hd__fill_2
XFILLER_33_373 VGND VGND VPWR VPWR sky130_fd_sc_hd__decap_3
XFILLER_21_535 VGND VGND VPWR VPWR sky130_fd_sc_hd__decap_3
X_4834_ _4834_/A0 _5357_/A1 _4834_/S VGND VGND VPWR VPWR _6896_/D sky130_fd_sc_hd__mux2_2
XFILLER_21_579 VGND VGND VPWR VPWR sky130_fd_sc_hd__fill_1
X_7553_ _7581_/CLK _7553_/D place2022/X VGND VGND VPWR VPWR _7553_/Q sky130_fd_sc_hd__dfrtp_2
X_4765_ _4765_/A0 _5726_/A1 _4771_/S VGND VGND VPWR VPWR _6869_/D sky130_fd_sc_hd__mux2_2
XTAP_TAPCELL_ROW_31_552 VGND VPWR sky130_fd_sc_hd__tapvpwrvgnd_1
X_6504_ _7186_/Q _6504_/A2 _7214_/Q _6504_/B2 VGND VGND VPWR VPWR _6504_/X sky130_fd_sc_hd__o22a_2
X_7484_ clkload7/A _7484_/D place2027/X VGND VGND VPWR VPWR _7484_/Q sky130_fd_sc_hd__dfrtp_2
XFILLER_20_27 VGND VGND VPWR VPWR sky130_fd_sc_hd__fill_1
Xplace1920 _3445_/A VGND VGND VPWR VPWR _3489_/A1 sky130_fd_sc_hd__buf_2
X_6435_ _6435_/A _6435_/B _6435_/C _6435_/D VGND VGND VPWR VPWR _6435_/X sky130_fd_sc_hd__or4_2
X_3647_ _3647_/A _3647_/B _3647_/C VGND VGND VPWR VPWR _4567_/D sky130_fd_sc_hd__nand3_2
Xplace1964 _7317_/Q VGND VGND VPWR VPWR _4542_/B sky130_fd_sc_hd__buf_2
Xplace1953 _7365_/Q VGND VGND VPWR VPWR _6318_/B2 sky130_fd_sc_hd__buf_2
Xplace1942 _7397_/Q VGND VGND VPWR VPWR _6367_/B2 sky130_fd_sc_hd__buf_2
Xplace1931 _7505_/Q VGND VGND VPWR VPWR _6687_/A0 sky130_fd_sc_hd__buf_2
X_3578_ _3578_/A1 _3578_/A2 _7485_/Q _3555_/Y _3578_/D1 VGND VGND VPWR VPWR _3578_/Y
+ sky130_fd_sc_hd__o2111ai_2
XFILLER_0_417 VGND VGND VPWR VPWR sky130_fd_sc_hd__decap_3
Xplace1997 _7293_/Q VGND VGND VPWR VPWR _3462_/B sky130_fd_sc_hd__buf_2
Xplace1986 _3429_/B VGND VGND VPWR VPWR _3414_/B sky130_fd_sc_hd__buf_2
Xplace1975 _4473_/B VGND VGND VPWR VPWR _3485_/C sky130_fd_sc_hd__buf_2
X_5317_ _5317_/A0 _5317_/A1 _5329_/S VGND VGND VPWR VPWR _7101_/D sky130_fd_sc_hd__mux2_2
XFILLER_0_439 VGND VGND VPWR VPWR sky130_fd_sc_hd__decap_3
XFILLER_102_334 VGND VGND VPWR VPWR sky130_fd_sc_hd__fill_2
Xhold2622 _7193_/Q VGND VGND VPWR VPWR _5518_/A0 sky130_fd_sc_hd__dlygate4sd3_1
Xhold2611 _7194_/Q VGND VGND VPWR VPWR _5520_/A0 sky130_fd_sc_hd__dlygate4sd3_1
Xhold2600 _6855_/Q VGND VGND VPWR VPWR _4665_/A0 sky130_fd_sc_hd__dlygate4sd3_1
Xhold2644 _7098_/Q VGND VGND VPWR VPWR _5310_/A0 sky130_fd_sc_hd__dlygate4sd3_1
Xhold2655 _6916_/Q VGND VGND VPWR VPWR _4879_/A0 sky130_fd_sc_hd__dlygate4sd3_1
Xhold2633 _7085_/Q VGND VGND VPWR VPWR _5271_/A0 sky130_fd_sc_hd__dlygate4sd3_1
XFILLER_56_421 VGND VGND VPWR VPWR sky130_fd_sc_hd__decap_3
Xhold2666 _7253_/Q VGND VGND VPWR VPWR _5648_/A0 sky130_fd_sc_hd__dlygate4sd3_1
Xhold2677 _7266_/Q VGND VGND VPWR VPWR _5677_/A0 sky130_fd_sc_hd__dlygate4sd3_1
Xhold2688 _6870_/Q VGND VGND VPWR VPWR _4771_/A0 sky130_fd_sc_hd__dlygate4sd3_1
Xhold2699 _7082_/Q VGND VGND VPWR VPWR _5262_/A0 sky130_fd_sc_hd__dlygate4sd3_1
X_5179_ _5179_/A0 _5635_/A1 _5179_/S VGND VGND VPWR VPWR _7051_/D sky130_fd_sc_hd__mux2_2
XFILLER_56_443 VGND VGND VPWR VPWR sky130_fd_sc_hd__decap_3
XTAP_TAPCELL_ROW_3_255 VGND VPWR sky130_fd_sc_hd__tapvpwrvgnd_1
XTAP_TAPCELL_ROW_39_630 VGND VPWR sky130_fd_sc_hd__tapvpwrvgnd_1
XFILLER_28_167 VGND VGND VPWR VPWR sky130_fd_sc_hd__decap_3
XFILLER_43_104 VGND VGND VPWR VPWR sky130_fd_sc_hd__decap_3
XFILLER_56_498 VGND VGND VPWR VPWR sky130_fd_sc_hd__decap_3
XFILLER_45_57 VGND VGND VPWR VPWR sky130_fd_sc_hd__fill_1
XFILLER_45_79 VGND VGND VPWR VPWR sky130_fd_sc_hd__decap_3
XFILLER_71_446 VGND VGND VPWR VPWR sky130_fd_sc_hd__fill_2
XFILLER_24_395 VGND VGND VPWR VPWR sky130_fd_sc_hd__decap_3
XFILLER_61_34 VGND VGND VPWR VPWR sky130_fd_sc_hd__fill_1
XFILLER_12_557 VGND VGND VPWR VPWR sky130_fd_sc_hd__fill_2
XFILLER_10_71 VGND VGND VPWR VPWR sky130_fd_sc_hd__decap_3
XFILLER_3_277 VGND VGND VPWR VPWR sky130_fd_sc_hd__decap_3
XFILLER_19_145 VGND VGND VPWR VPWR sky130_fd_sc_hd__fill_2
XFILLER_47_443 VGND VGND VPWR VPWR sky130_fd_sc_hd__decap_3
XFILLER_59_292 VGND VGND VPWR VPWR sky130_fd_sc_hd__decap_3
XTAP_TAPCELL_ROW_65_909 VGND VPWR sky130_fd_sc_hd__tapvpwrvgnd_1
XFILLER_19_178 VGND VGND VPWR VPWR sky130_fd_sc_hd__decap_3
XFILLER_47_498 VGND VGND VPWR VPWR sky130_fd_sc_hd__decap_3
XFILLER_34_126 VGND VGND VPWR VPWR sky130_fd_sc_hd__fill_1
XTAP_TAPCELL_ROW_73_986 VGND VPWR sky130_fd_sc_hd__tapvpwrvgnd_1
XFILLER_96_6 VGND VGND VPWR VPWR sky130_fd_sc_hd__decap_3
XTAP_TAPCELL_ROW_45_699 VGND VPWR sky130_fd_sc_hd__tapvpwrvgnd_1
XFILLER_42_192 VGND VGND VPWR VPWR sky130_fd_sc_hd__decap_3
XFILLER_30_365 VGND VGND VPWR VPWR sky130_fd_sc_hd__decap_3
X_4550_ _4549_/X _6769_/A1 _4550_/S VGND VGND VPWR VPWR _7318_/D sky130_fd_sc_hd__mux2_2
Xplace1205 _4870_/S VGND VGND VPWR VPWR _4868_/S sky130_fd_sc_hd__buf_2
Xplace1216 _4325_/Y VGND VGND VPWR VPWR _4475_/S sky130_fd_sc_hd__buf_2
X_4481_ _7306_/Q _4481_/B VGND VGND VPWR VPWR _4482_/C sky130_fd_sc_hd__nand2_2
X_3501_ _4003_/A1 _4003_/A2 _7356_/Q _4312_/B _7548_/Q VGND VGND VPWR VPWR _3502_/A
+ sky130_fd_sc_hd__a32oi_2
XTAP_TAPCELL_ROW_77_1034 VGND VPWR sky130_fd_sc_hd__tapvpwrvgnd_1
Xplace1227 _5765_/X VGND VGND VPWR VPWR _6458_/B2 sky130_fd_sc_hd__clkbuf_4
Xplace1238 _4610_/X VGND VGND VPWR VPWR _4629_/S sky130_fd_sc_hd__buf_2
Xplace1249 _5781_/Y VGND VGND VPWR VPWR _6048_/A sky130_fd_sc_hd__buf_2
X_6220_ _6220_/A1 _6220_/A2 _6220_/B1 _7609_/Q VGND VGND VPWR VPWR _6220_/X sky130_fd_sc_hd__o22a_2
X_6151_ _6154_/A1 _7029_/Q _6945_/Q _6154_/B2 VGND VGND VPWR VPWR _6151_/X sky130_fd_sc_hd__o22a_2
X_6082_ _4639_/A1 _6082_/B _6082_/C _6082_/D VGND VGND VPWR VPWR _6082_/X sky130_fd_sc_hd__and4b_2
XFILLER_65_240 VGND VGND VPWR VPWR sky130_fd_sc_hd__fill_2
XPHY_EDGE_ROW_69_Left_173 VGND VGND VPWR VPWR sky130_fd_sc_hd__decap_3
XTAP_TAPCELL_ROW_88_1152 VGND VPWR sky130_fd_sc_hd__tapvpwrvgnd_1
XTAP_TAPCELL_ROW_36_600 VGND VPWR sky130_fd_sc_hd__tapvpwrvgnd_1
XTAP_TAPCELL_ROW_0_225 VGND VPWR sky130_fd_sc_hd__tapvpwrvgnd_1
XTAP_TAPCELL_ROW_0_214 VGND VPWR sky130_fd_sc_hd__tapvpwrvgnd_1
XFILLER_53_435 VGND VGND VPWR VPWR sky130_fd_sc_hd__decap_3
XFILLER_80_232 VGND VGND VPWR VPWR sky130_fd_sc_hd__fill_2
X_6984_ _7565_/CLK _6984_/D VGND VGND VPWR VPWR _6984_/Q sky130_fd_sc_hd__dfxtp_2
XFILLER_25_159 VGND VGND VPWR VPWR sky130_fd_sc_hd__decap_3
X_5935_ _6502_/A2 _6986_/Q _6958_/Q _6483_/A1 VGND VGND VPWR VPWR _5935_/X sky130_fd_sc_hd__o22a_2
XFILLER_21_310 VGND VGND VPWR VPWR sky130_fd_sc_hd__fill_1
XFILLER_21_332 VGND VGND VPWR VPWR sky130_fd_sc_hd__decap_3
XFILLER_21_343 VGND VGND VPWR VPWR sky130_fd_sc_hd__decap_3
XFILLER_21_354 VGND VGND VPWR VPWR sky130_fd_sc_hd__decap_3
X_7605_ _7606_/CLK _7605_/D place2051/X VGND VGND VPWR VPWR _7605_/Q sky130_fd_sc_hd__dfrtp_2
X_4817_ _4817_/A0 _5707_/A1 _4834_/S VGND VGND VPWR VPWR _6888_/D sky130_fd_sc_hd__mux2_2
XTAP_TAPCELL_ROW_16_390 VGND VPWR sky130_fd_sc_hd__tapvpwrvgnd_1
X_5797_ _5797_/A1 _7157_/Q _7129_/Q _5991_/B2 VGND VGND VPWR VPWR _5797_/X sky130_fd_sc_hd__o22a_2
XFILLER_5_509 VGND VGND VPWR VPWR sky130_fd_sc_hd__decap_3
XPHY_EDGE_ROW_78_Left_182 VGND VGND VPWR VPWR sky130_fd_sc_hd__decap_3
X_7536_ _7606_/CLK _7536_/D place2049/X VGND VGND VPWR VPWR _7536_/Q sky130_fd_sc_hd__dfrtp_2
X_7467_ clkload3/A _7467_/D place2058/X VGND VGND VPWR VPWR _7467_/Q sky130_fd_sc_hd__dfrtp_2
XPHY_EDGE_ROW_1_Right_1 VGND VGND VPWR VPWR sky130_fd_sc_hd__decap_3
X_6418_ _6418_/A0 _5855_/X _6497_/S VGND VGND VPWR VPWR _7421_/D sky130_fd_sc_hd__mux2_2
XTAP_TAPCELL_ROW_8_303 VGND VPWR sky130_fd_sc_hd__tapvpwrvgnd_1
Xplace1750 _3490_/X VGND VGND VPWR VPWR _3855_/B1 sky130_fd_sc_hd__buf_2
Xplace1761 _3855_/A2 VGND VGND VPWR VPWR _6662_/S sky130_fd_sc_hd__buf_6
Xplace1772 _6805_/A VGND VGND VPWR VPWR _6840_/A sky130_fd_sc_hd__buf_2
X_7398_ _7493_/CLK _7398_/D place2014/X VGND VGND VPWR VPWR _7398_/Q sky130_fd_sc_hd__dfrtp_2
XFILLER_0_225 VGND VGND VPWR VPWR sky130_fd_sc_hd__decap_3
Xplace1794 _3536_/A VGND VGND VPWR VPWR _3561_/B sky130_fd_sc_hd__buf_2
Xplace1783 _3598_/A VGND VGND VPWR VPWR _3545_/A sky130_fd_sc_hd__buf_2
Xhold2430 _7234_/Q VGND VGND VPWR VPWR _5606_/A0 sky130_fd_sc_hd__dlygate4sd3_1
XFILLER_102_186 VGND VGND VPWR VPWR sky130_fd_sc_hd__fill_1
XFILLER_102_197 VGND VGND VPWR VPWR sky130_fd_sc_hd__decap_3
XFILLER_29_421 VGND VGND VPWR VPWR sky130_fd_sc_hd__decap_3
Xhold2463 _6907_/Q VGND VGND VPWR VPWR _4860_/A0 sky130_fd_sc_hd__dlygate4sd3_1
Xhold2452 _6848_/Q VGND VGND VPWR VPWR _4603_/A0 sky130_fd_sc_hd__dlygate4sd3_1
Xhold2441 _7017_/Q VGND VGND VPWR VPWR _5106_/A0 sky130_fd_sc_hd__dlygate4sd3_1
XPHY_EDGE_ROW_87_Left_191 VGND VGND VPWR VPWR sky130_fd_sc_hd__decap_3
Xhold2496 _6955_/Q VGND VGND VPWR VPWR _4964_/A0 sky130_fd_sc_hd__dlygate4sd3_1
Xhold2485 _7190_/Q VGND VGND VPWR VPWR _5511_/A0 sky130_fd_sc_hd__dlygate4sd3_1
Xhold2474 _6934_/Q VGND VGND VPWR VPWR _4920_/A0 sky130_fd_sc_hd__dlygate4sd3_1
XFILLER_56_67 VGND VGND VPWR VPWR sky130_fd_sc_hd__fill_2
XFILLER_56_78 VGND VGND VPWR VPWR sky130_fd_sc_hd__decap_3
XFILLER_16_137 VGND VGND VPWR VPWR sky130_fd_sc_hd__decap_3
XFILLER_71_243 VGND VGND VPWR VPWR sky130_fd_sc_hd__decap_3
XFILLER_71_265 VGND VGND VPWR VPWR sky130_fd_sc_hd__decap_3
XFILLER_72_22 VGND VGND VPWR VPWR sky130_fd_sc_hd__decap_3
XFILLER_8_303 VGND VGND VPWR VPWR sky130_fd_sc_hd__decap_3
XTAP_TAPCELL_ROW_70_956 VGND VPWR sky130_fd_sc_hd__tapvpwrvgnd_1
XTAP_TAPCELL_ROW_42_669 VGND VPWR sky130_fd_sc_hd__tapvpwrvgnd_1
XFILLER_4_531 VGND VGND VPWR VPWR sky130_fd_sc_hd__fill_1
XFILLER_99_608 VGND VGND VPWR VPWR sky130_fd_sc_hd__decap_3
XFILLER_4_564 VGND VGND VPWR VPWR sky130_fd_sc_hd__decap_3
XFILLER_4_586 VGND VGND VPWR VPWR sky130_fd_sc_hd__fill_2
XFILLER_11_6 VGND VGND VPWR VPWR sky130_fd_sc_hd__fill_2
XFILLER_75_582 VGND VGND VPWR VPWR sky130_fd_sc_hd__fill_1
XFILLER_35_435 VGND VGND VPWR VPWR sky130_fd_sc_hd__decap_3
XFILLER_62_210 VGND VGND VPWR VPWR sky130_fd_sc_hd__decap_3
XFILLER_35_479 VGND VGND VPWR VPWR sky130_fd_sc_hd__decap_3
X_3981_ _3981_/A _3981_/B VGND VGND VPWR VPWR _4094_/B sky130_fd_sc_hd__nor2_4
XFILLER_50_427 VGND VGND VPWR VPWR sky130_fd_sc_hd__decap_3
X_5720_ _5720_/A0 _5720_/A1 _5728_/S VGND VGND VPWR VPWR _7286_/D sky130_fd_sc_hd__mux2_2
Xclkbuf_leaf_42_clk clkbuf_leaf_3_clk/A VGND VGND VPWR VPWR _7493_/CLK sky130_fd_sc_hd__clkbuf_16
XTAP_TAPCELL_ROW_83_1093 VGND VPWR sky130_fd_sc_hd__tapvpwrvgnd_1
XFILLER_30_151 VGND VGND VPWR VPWR sky130_fd_sc_hd__decap_3
XTAP_TAPCELL_ROW_13_360 VGND VPWR sky130_fd_sc_hd__tapvpwrvgnd_1
XFILLER_30_184 VGND VGND VPWR VPWR sky130_fd_sc_hd__decap_3
X_7321_ _7611_/CLK _7321_/D place2054/X VGND VGND VPWR VPWR _7321_/Q sky130_fd_sc_hd__dfrtp_2
X_4533_ _4533_/A _4533_/B _4533_/C _4533_/D VGND VGND VPWR VPWR _4533_/X sky130_fd_sc_hd__or4_2
X_7252_ _7282_/CLK _7252_/D VGND VGND VPWR VPWR _7252_/Q sky130_fd_sc_hd__dfxtp_2
X_6203_ _6448_/A1 _7063_/Q _6867_/Q _6448_/B2 VGND VGND VPWR VPWR _6203_/X sky130_fd_sc_hd__o22a_2
X_4464_ _7305_/Q _4464_/B VGND VGND VPWR VPWR _4472_/D sky130_fd_sc_hd__xor2_2
X_7183_ _7272_/CLK _7183_/D VGND VGND VPWR VPWR _7183_/Q sky130_fd_sc_hd__dfxtp_2
X_4395_ _4395_/A1 _4394_/Y _4395_/B1 _3931_/B _3545_/A VGND VGND VPWR VPWR _4395_/Y
+ sky130_fd_sc_hd__o2111ai_2
X_3415_ _3414_/B _3413_/Y _3414_/Y _3487_/C VGND VGND VPWR VPWR _3415_/Y sky130_fd_sc_hd__o211ai_2
X_6134_ _6392_/A _6130_/X _6395_/B1 _6133_/X VGND VGND VPWR VPWR _6141_/B sky130_fd_sc_hd__o22a_2
XFILLER_85_324 VGND VGND VPWR VPWR sky130_fd_sc_hd__fill_1
XFILLER_97_195 VGND VGND VPWR VPWR sky130_fd_sc_hd__fill_1
X_6065_ _6507_/A1 _7021_/Q _6937_/Q _6507_/B2 VGND VGND VPWR VPWR _6065_/X sky130_fd_sc_hd__o22a_2
XFILLER_73_508 VGND VGND VPWR VPWR sky130_fd_sc_hd__fill_1
XFILLER_38_240 VGND VGND VPWR VPWR sky130_fd_sc_hd__decap_3
XFILLER_38_262 VGND VGND VPWR VPWR sky130_fd_sc_hd__decap_3
XFILLER_26_48 VGND VGND VPWR VPWR sky130_fd_sc_hd__decap_3
XFILLER_66_593 VGND VGND VPWR VPWR sky130_fd_sc_hd__fill_2
XFILLER_93_390 VGND VGND VPWR VPWR sky130_fd_sc_hd__fill_2
X_6967_ _7275_/CLK _6967_/D VGND VGND VPWR VPWR _6967_/Q sky130_fd_sc_hd__dfxtp_2
XFILLER_41_449 VGND VGND VPWR VPWR sky130_fd_sc_hd__fill_2
X_5918_ _6510_/A1 _7218_/Q _7134_/Q _6510_/B2 VGND VGND VPWR VPWR _5918_/X sky130_fd_sc_hd__o22a_2
Xclkbuf_leaf_33_clk clkbuf_3_2__f_clk/X VGND VGND VPWR VPWR _7579_/CLK sky130_fd_sc_hd__clkbuf_16
X_6898_ _7287_/CLK _6898_/D VGND VGND VPWR VPWR _6898_/Q sky130_fd_sc_hd__dfxtp_2
X_5849_ _6230_/A1 _5848_/X _6231_/A2 _4340_/Y _6231_/A1 VGND VGND VPWR VPWR _6304_/B
+ sky130_fd_sc_hd__o221a_2
XFILLER_21_184 VGND VGND VPWR VPWR sky130_fd_sc_hd__fill_2
X_7519_ clkload6/A _7519_/D place2030/X VGND VGND VPWR VPWR _7519_/Q sky130_fd_sc_hd__dfrtp_2
XFILLER_1_501 VGND VGND VPWR VPWR sky130_fd_sc_hd__decap_3
Xplace1580 _3981_/B VGND VGND VPWR VPWR _4750_/A1 sky130_fd_sc_hd__buf_2
XFILLER_1_556 VGND VGND VPWR VPWR sky130_fd_sc_hd__decap_3
XFILLER_49_505 VGND VGND VPWR VPWR sky130_fd_sc_hd__fill_2
Xplace1591 _4094_/A VGND VGND VPWR VPWR _3982_/A sky130_fd_sc_hd__buf_2
XFILLER_88_195 VGND VGND VPWR VPWR sky130_fd_sc_hd__fill_1
XFILLER_17_402 VGND VGND VPWR VPWR sky130_fd_sc_hd__fill_2
XFILLER_29_240 VGND VGND VPWR VPWR sky130_fd_sc_hd__decap_3
XFILLER_29_273 VGND VGND VPWR VPWR sky130_fd_sc_hd__decap_3
XFILLER_64_519 VGND VGND VPWR VPWR sky130_fd_sc_hd__fill_1
XTAP_TAPCELL_ROW_47_717 VGND VPWR sky130_fd_sc_hd__tapvpwrvgnd_1
XTAP_TAPCELL_ROW_19_419 VGND VPWR sky130_fd_sc_hd__tapvpwrvgnd_1
XFILLER_17_446 VGND VGND VPWR VPWR sky130_fd_sc_hd__fill_2
XFILLER_29_284 VGND VGND VPWR VPWR sky130_fd_sc_hd__decap_3
XFILLER_83_32 VGND VGND VPWR VPWR sky130_fd_sc_hd__fill_1
XFILLER_32_405 VGND VGND VPWR VPWR sky130_fd_sc_hd__decap_3
XFILLER_44_265 VGND VGND VPWR VPWR sky130_fd_sc_hd__fill_1
Xclkbuf_leaf_24_clk clkbuf_3_6__f_clk/X VGND VGND VPWR VPWR _7291_/CLK sky130_fd_sc_hd__clkbuf_16
XFILLER_8_100 VGND VGND VPWR VPWR sky130_fd_sc_hd__decap_3
XFILLER_8_133 VGND VGND VPWR VPWR sky130_fd_sc_hd__decap_3
XFILLER_32_91 VGND VGND VPWR VPWR sky130_fd_sc_hd__decap_3
XFILLER_8_177 VGND VGND VPWR VPWR sky130_fd_sc_hd__fill_1
XTAP_TAPCELL_ROW_10_330 VGND VPWR sky130_fd_sc_hd__tapvpwrvgnd_1
XTAP_TAPCELL_ROW_74_1004 VGND VPWR sky130_fd_sc_hd__tapvpwrvgnd_1
X_4180_ _3832_/A _4180_/A2 _3870_/Y _3886_/A _3887_/C VGND VGND VPWR VPWR _4190_/A
+ sky130_fd_sc_hd__o32a_2
XFILLER_95_611 VGND VGND VPWR VPWR sky130_fd_sc_hd__fill_1
XFILLER_67_335 VGND VGND VPWR VPWR sky130_fd_sc_hd__fill_1
XFILLER_35_210 VGND VGND VPWR VPWR sky130_fd_sc_hd__decap_3
XTAP_TAPCELL_ROW_85_1111 VGND VPWR sky130_fd_sc_hd__tapvpwrvgnd_1
XFILLER_35_254 VGND VGND VPWR VPWR sky130_fd_sc_hd__decap_3
XFILLER_35_287 VGND VGND VPWR VPWR sky130_fd_sc_hd__decap_3
XFILLER_50_213 VGND VGND VPWR VPWR sky130_fd_sc_hd__decap_3
Xclkbuf_leaf_15_clk clkload1/A VGND VGND VPWR VPWR _7217_/CLK sky130_fd_sc_hd__clkbuf_16
X_6752_ _6159_/X _6752_/A1 _6765_/S VGND VGND VPWR VPWR _7536_/D sky130_fd_sc_hd__mux2_2
X_3964_ _7392_/Q _6658_/S _3963_/X VGND VGND VPWR VPWR _3964_/Y sky130_fd_sc_hd__a21oi_2
XFILLER_31_471 VGND VGND VPWR VPWR sky130_fd_sc_hd__decap_3
X_6683_ _6683_/A0 _6144_/X _6687_/S VGND VGND VPWR VPWR _7503_/D sky130_fd_sc_hd__mux2_4
X_5703_ _5703_/A0 _5703_/A1 _5711_/S VGND VGND VPWR VPWR _7278_/D sky130_fd_sc_hd__mux2_2
X_3895_ _7300_/Q _3920_/B _4151_/A _3895_/B2 _3896_/B VGND VGND VPWR VPWR _3895_/Y
+ sky130_fd_sc_hd__a221oi_2
X_7304_ _7611_/CLK _7304_/D place2054/X VGND VGND VPWR VPWR _7304_/Q sky130_fd_sc_hd__dfrtp_2
XFILLER_2_309 VGND VGND VPWR VPWR sky130_fd_sc_hd__fill_2
X_5496_ _5496_/A0 _5679_/A1 _5513_/S VGND VGND VPWR VPWR _7183_/D sky130_fd_sc_hd__mux2_2
X_4516_ _7602_/D _4538_/S _4515_/X VGND VGND VPWR VPWR _4516_/X sky130_fd_sc_hd__a21bo_2
X_7235_ _7235_/CLK _7235_/D VGND VGND VPWR VPWR _7235_/Q sky130_fd_sc_hd__dfxtp_2
X_4447_ _4445_/Y _4446_/X _7593_/D _4388_/S VGND VGND VPWR VPWR _4447_/X sky130_fd_sc_hd__a2bb2o_2
X_7166_ _7509_/CLK _7166_/D VGND VGND VPWR VPWR _7166_/Q sky130_fd_sc_hd__dfxtp_2
XFILLER_58_302 VGND VGND VPWR VPWR sky130_fd_sc_hd__decap_3
XFILLER_85_110 VGND VGND VPWR VPWR sky130_fd_sc_hd__fill_2
X_6117_ _6390_/A1 _7055_/Q _6859_/Q _6390_/B2 VGND VGND VPWR VPWR _6117_/X sky130_fd_sc_hd__o22a_2
X_4378_ _6727_/A1 _4452_/S _4368_/X _4377_/Y VGND VGND VPWR VPWR _7298_/D sky130_fd_sc_hd__a22o_2
XFILLER_100_421 VGND VGND VPWR VPWR sky130_fd_sc_hd__decap_3
XFILLER_58_346 VGND VGND VPWR VPWR sky130_fd_sc_hd__decap_3
X_7097_ _7393_/CLK _7097_/D VGND VGND VPWR VPWR _7097_/Q sky130_fd_sc_hd__dfxtp_2
XFILLER_58_368 VGND VGND VPWR VPWR sky130_fd_sc_hd__fill_1
X_6048_ _6048_/A _6048_/B VGND VGND VPWR VPWR _6055_/B sky130_fd_sc_hd__nor2_2
XFILLER_26_210 VGND VGND VPWR VPWR sky130_fd_sc_hd__decap_3
XFILLER_73_327 VGND VGND VPWR VPWR sky130_fd_sc_hd__fill_1
XFILLER_26_276 VGND VGND VPWR VPWR sky130_fd_sc_hd__decap_3
XFILLER_41_279 VGND VGND VPWR VPWR sky130_fd_sc_hd__fill_1
XTAP_TAPCELL_ROW_52_764 VGND VPWR sky130_fd_sc_hd__tapvpwrvgnd_1
XTAP_TAPCELL_ROW_24_477 VGND VPWR sky130_fd_sc_hd__tapvpwrvgnd_1
XTAP_TAPCELL_ROW_101_1288 VGND VPWR sky130_fd_sc_hd__tapvpwrvgnd_1
XFILLER_5_147 VGND VGND VPWR VPWR sky130_fd_sc_hd__decap_3
XFILLER_5_169 VGND VGND VPWR VPWR sky130_fd_sc_hd__decap_3
XFILLER_49_335 VGND VGND VPWR VPWR sky130_fd_sc_hd__fill_1
XFILLER_17_221 VGND VGND VPWR VPWR sky130_fd_sc_hd__decap_3
XFILLER_45_541 VGND VGND VPWR VPWR sky130_fd_sc_hd__decap_3
XFILLER_60_522 VGND VGND VPWR VPWR sky130_fd_sc_hd__fill_1
XFILLER_60_544 VGND VGND VPWR VPWR sky130_fd_sc_hd__fill_1
XFILLER_60_566 VGND VGND VPWR VPWR sky130_fd_sc_hd__fill_1
XFILLER_32_268 VGND VGND VPWR VPWR sky130_fd_sc_hd__decap_3
XFILLER_13_482 VGND VGND VPWR VPWR sky130_fd_sc_hd__fill_2
Xmax_cap2110 _3497_/Y VGND VGND VPWR VPWR place1841/A sky130_fd_sc_hd__buf_6
XTAP_TAPCELL_ROW_80_1063 VGND VPWR sky130_fd_sc_hd__tapvpwrvgnd_1
X_3680_ _3676_/X _3680_/B _3680_/C VGND VGND VPWR VPWR _3680_/Y sky130_fd_sc_hd__nand3b_2
XFILLER_57_3 VGND VGND VPWR VPWR sky130_fd_sc_hd__decap_3
XFILLER_99_213 VGND VGND VPWR VPWR sky130_fd_sc_hd__decap_3
X_7020_ _7272_/CLK _7020_/D VGND VGND VPWR VPWR _7020_/Q sky130_fd_sc_hd__dfxtp_2
X_4232_ _4237_/A _4232_/B _4237_/C _4232_/D VGND VGND VPWR VPWR _4232_/X sky130_fd_sc_hd__or4_2
XFILLER_101_229 VGND VGND VPWR VPWR sky130_fd_sc_hd__fill_1
XFILLER_99_279 VGND VGND VPWR VPWR sky130_fd_sc_hd__fill_1
Xclkbuf_leaf_4_clk clkbuf_leaf_8_clk/A VGND VGND VPWR VPWR _7490_/CLK sky130_fd_sc_hd__clkbuf_16
XTAP_TAPCELL_ROW_91_1181 VGND VPWR sky130_fd_sc_hd__tapvpwrvgnd_1
X_4163_ _4157_/Y _4163_/A2 _4163_/A3 _6163_/A _4163_/C1 VGND VGND VPWR VPWR _4163_/X
+ sky130_fd_sc_hd__o311a_2
XFILLER_67_176 VGND VGND VPWR VPWR sky130_fd_sc_hd__fill_1
X_4094_ _4094_/A _4094_/B _4094_/C VGND VGND VPWR VPWR _4094_/Y sky130_fd_sc_hd__nor3_4
XFILLER_23_213 VGND VGND VPWR VPWR sky130_fd_sc_hd__decap_3
XFILLER_23_246 VGND VGND VPWR VPWR sky130_fd_sc_hd__decap_3
XFILLER_63_393 VGND VGND VPWR VPWR sky130_fd_sc_hd__fill_2
X_6804_ _6804_/A1 _3455_/A _3652_/C _6804_/B1 VGND VGND VPWR VPWR _7560_/D sky130_fd_sc_hd__a31o_2
X_4996_ _4996_/A0 _5696_/A1 _4998_/S VGND VGND VPWR VPWR _6967_/D sky130_fd_sc_hd__mux2_2
XFILLER_51_588 VGND VGND VPWR VPWR sky130_fd_sc_hd__decap_3
X_6735_ _6074_/X _6735_/A1 _6775_/S VGND VGND VPWR VPWR _7528_/D sky130_fd_sc_hd__mux2_2
X_3947_ _6363_/A2 _3947_/A2 _7487_/Q _4009_/B1 _6442_/A0 VGND VGND VPWR VPWR _3951_/B
+ sky130_fd_sc_hd__a32oi_4
XFILLER_23_49 VGND VGND VPWR VPWR sky130_fd_sc_hd__fill_2
X_6666_ _7495_/Q _6058_/X _6675_/S VGND VGND VPWR VPWR _7495_/D sky130_fd_sc_hd__mux2_2
X_3878_ _3990_/A1 _6322_/A3 _6321_/B2 _3986_/B2 _7464_/Q VGND VGND VPWR VPWR _3878_/X
+ sky130_fd_sc_hd__a32o_2
XTAP_TAPCELL_ROW_21_447 VGND VPWR sky130_fd_sc_hd__tapvpwrvgnd_1
X_7218_ _7247_/CLK _7218_/D VGND VGND VPWR VPWR _7218_/Q sky130_fd_sc_hd__dfxtp_2
X_7149_ _7289_/CLK _7149_/D VGND VGND VPWR VPWR _7149_/Q sky130_fd_sc_hd__dfxtp_2
XFILLER_19_508 VGND VGND VPWR VPWR sky130_fd_sc_hd__decap_3
XFILLER_46_305 VGND VGND VPWR VPWR sky130_fd_sc_hd__decap_3
XFILLER_46_349 VGND VGND VPWR VPWR sky130_fd_sc_hd__decap_3
XTAP_TAPCELL_ROW_57_823 VGND VPWR sky130_fd_sc_hd__tapvpwrvgnd_1
XTAP_TAPCELL_ROW_29_525 VGND VPWR sky130_fd_sc_hd__tapvpwrvgnd_1
XFILLER_42_522 VGND VGND VPWR VPWR sky130_fd_sc_hd__decap_3
XPHY_EDGE_ROW_14_Left_118 VGND VGND VPWR VPWR sky130_fd_sc_hd__decap_3
XTAP_TAPCELL_ROW_103_1317 VGND VPWR sky130_fd_sc_hd__tapvpwrvgnd_1
XTAP_TAPCELL_ROW_103_1306 VGND VPWR sky130_fd_sc_hd__tapvpwrvgnd_1
XFILLER_14_224 VGND VGND VPWR VPWR sky130_fd_sc_hd__decap_3
XFILLER_80_44 VGND VGND VPWR VPWR sky130_fd_sc_hd__decap_3
XFILLER_6_401 VGND VGND VPWR VPWR sky130_fd_sc_hd__decap_3
XFILLER_10_463 VGND VGND VPWR VPWR sky130_fd_sc_hd__decap_3
XFILLER_13_82 VGND VGND VPWR VPWR sky130_fd_sc_hd__decap_3
XFILLER_13_93 VGND VGND VPWR VPWR sky130_fd_sc_hd__decap_3
XPHY_EDGE_ROW_23_Left_127 VGND VGND VPWR VPWR sky130_fd_sc_hd__decap_3
XFILLER_6_489 VGND VGND VPWR VPWR sky130_fd_sc_hd__decap_3
XFILLER_37_305 VGND VGND VPWR VPWR sky130_fd_sc_hd__decap_3
XFILLER_18_530 VGND VGND VPWR VPWR sky130_fd_sc_hd__fill_2
XPHY_EDGE_ROW_32_Left_136 VGND VGND VPWR VPWR sky130_fd_sc_hd__decap_3
Xclkbuf_3_7__f_clk clkbuf_0_clk/X VGND VGND VPWR VPWR clkload1/A sky130_fd_sc_hd__clkbuf_8
XFILLER_33_511 VGND VGND VPWR VPWR sky130_fd_sc_hd__decap_3
XFILLER_52_319 VGND VGND VPWR VPWR sky130_fd_sc_hd__decap_3
XFILLER_64_179 VGND VGND VPWR VPWR sky130_fd_sc_hd__decap_3
X_3801_ _7500_/Q _3881_/B _3810_/B1 _7436_/Q VGND VGND VPWR VPWR _3805_/A sky130_fd_sc_hd__a22oi_2
X_6520_ _6520_/A0 _6058_/X _6569_/S VGND VGND VPWR VPWR _7431_/D sky130_fd_sc_hd__mux2_2
X_4781_ _5671_/A _5671_/B _5488_/B VGND VGND VPWR VPWR _4838_/S sky130_fd_sc_hd__and3_2
XFILLER_20_249 VGND VGND VPWR VPWR sky130_fd_sc_hd__decap_3
X_3732_ _7418_/Q _4725_/A2 _3913_/A2 _7450_/Q _3731_/X VGND VGND VPWR VPWR _3732_/X
+ sky130_fd_sc_hd__a221o_2
XPHY_EDGE_ROW_41_Left_145 VGND VGND VPWR VPWR sky130_fd_sc_hd__decap_3
Xclkload20 _7490_/CLK VGND VGND VPWR VPWR clkload20/Y sky130_fd_sc_hd__clkinv_2
X_6451_ _7094_/Q _6456_/A1 _6451_/B1 _7122_/Q _6450_/X VGND VGND VPWR VPWR _6451_/X
+ sky130_fd_sc_hd__o221a_2
X_3663_ _3717_/A1 _3792_/A2 _7383_/Q _3792_/B1 _7575_/Q VGND VGND VPWR VPWR _3663_/X
+ sky130_fd_sc_hd__a32o_2
Xoutput2101 _4155_/X VGND VGND VPWR VPWR result[9] sky130_fd_sc_hd__clkdlybuf4s25_1
Xclkload31 _7291_/CLK VGND VGND VPWR VPWR clkload31/Y sky130_fd_sc_hd__clkinv_2
X_6382_ _6685_/A0 _6411_/A2 _6388_/A3 _6407_/S _7408_/Q VGND VGND VPWR VPWR _6382_/X
+ sky130_fd_sc_hd__a32o_2
X_5402_ _5402_/A0 _4700_/X _5410_/S VGND VGND VPWR VPWR _7140_/D sky130_fd_sc_hd__mux2_2
XFILLER_102_505 VGND VGND VPWR VPWR sky130_fd_sc_hd__fill_2
XFILLER_87_205 VGND VGND VPWR VPWR sky130_fd_sc_hd__fill_2
Xhold2804 _7028_/Q VGND VGND VPWR VPWR _5129_/A0 sky130_fd_sc_hd__dlygate4sd3_1
Xhold2815 _6972_/Q VGND VGND VPWR VPWR _5007_/A0 sky130_fd_sc_hd__dlygate4sd3_1
Xhold2826 _7352_/Q VGND VGND VPWR VPWR _6292_/B sky130_fd_sc_hd__dlygate4sd3_1
Xhold2837 _7337_/Q VGND VGND VPWR VPWR _6260_/B sky130_fd_sc_hd__dlygate4sd3_1
Xhold2848 _7336_/Q VGND VGND VPWR VPWR _6258_/B sky130_fd_sc_hd__dlygate4sd3_1
X_7003_ _7235_/CLK _7003_/D VGND VGND VPWR VPWR _7003_/Q sky130_fd_sc_hd__dfxtp_2
X_4215_ _4215_/A VGND VGND VPWR VPWR _4215_/Y sky130_fd_sc_hd__inv_2
Xhold2859 _7573_/Q VGND VGND VPWR VPWR _6830_/B sky130_fd_sc_hd__dlygate4sd3_1
X_4146_ _4146_/A1 _4278_/A2 _4510_/C _4152_/B _4152_/A VGND VGND VPWR VPWR _4146_/X
+ sky130_fd_sc_hd__o32a_2
XFILLER_28_338 VGND VGND VPWR VPWR sky130_fd_sc_hd__decap_3
XFILLER_55_113 VGND VGND VPWR VPWR sky130_fd_sc_hd__fill_2
XPHY_EDGE_ROW_50_Left_154 VGND VGND VPWR VPWR sky130_fd_sc_hd__decap_3
X_4077_ _4532_/B _7315_/Q _7316_/Q _4077_/D VGND VGND VPWR VPWR _4085_/D sky130_fd_sc_hd__and4_2
XFILLER_24_577 VGND VGND VPWR VPWR sky130_fd_sc_hd__decap_3
XTAP_TAPCELL_ROW_62_870 VGND VPWR sky130_fd_sc_hd__tapvpwrvgnd_1
X_4979_ _4979_/A0 _5312_/A1 _4998_/S VGND VGND VPWR VPWR _6959_/D sky130_fd_sc_hd__mux2_2
XTAP_TAPCELL_ROW_34_583 VGND VPWR sky130_fd_sc_hd__tapvpwrvgnd_1
Xclkload3 clkload3/A VGND VGND VPWR VPWR clkload3/Y sky130_fd_sc_hd__clkinv_2
X_6718_ _5863_/X _6718_/A1 _6720_/S VGND VGND VPWR VPWR _7520_/D sky130_fd_sc_hd__mux2_2
X_6649_ _7487_/Q _6441_/X _6653_/S VGND VGND VPWR VPWR _7487_/D sky130_fd_sc_hd__mux2_2
XTAP_TAPCELL_ROW_6_286 VGND VPWR sky130_fd_sc_hd__tapvpwrvgnd_1
XFILLER_19_349 VGND VGND VPWR VPWR sky130_fd_sc_hd__decap_3
XFILLER_46_135 VGND VGND VPWR VPWR sky130_fd_sc_hd__fill_1
XFILLER_15_511 VGND VGND VPWR VPWR sky130_fd_sc_hd__decap_3
XFILLER_27_360 VGND VGND VPWR VPWR sky130_fd_sc_hd__decap_3
XFILLER_61_116 VGND VGND VPWR VPWR sky130_fd_sc_hd__fill_1
XFILLER_74_477 VGND VGND VPWR VPWR sky130_fd_sc_hd__fill_2
XFILLER_61_149 VGND VGND VPWR VPWR sky130_fd_sc_hd__decap_3
XFILLER_30_503 VGND VGND VPWR VPWR sky130_fd_sc_hd__decap_3
XFILLER_91_54 VGND VGND VPWR VPWR sky130_fd_sc_hd__fill_2
XFILLER_30_536 VGND VGND VPWR VPWR sky130_fd_sc_hd__decap_3
XFILLER_10_271 VGND VGND VPWR VPWR sky130_fd_sc_hd__decap_3
XFILLER_10_282 VGND VGND VPWR VPWR sky130_fd_sc_hd__decap_3
XFILLER_6_253 VGND VGND VPWR VPWR sky130_fd_sc_hd__decap_3
XFILLER_6_286 VGND VGND VPWR VPWR sky130_fd_sc_hd__decap_3
Xplace1409 _4236_/A VGND VGND VPWR VPWR _4220_/A sky130_fd_sc_hd__buf_4
XFILLER_97_514 VGND VGND VPWR VPWR sky130_fd_sc_hd__decap_3
XFILLER_97_558 VGND VGND VPWR VPWR sky130_fd_sc_hd__fill_2
XFILLER_38_603 VGND VGND VPWR VPWR sky130_fd_sc_hd__fill_2
X_4000_ _4001_/A _4001_/B VGND VGND VPWR VPWR _4002_/A sky130_fd_sc_hd__nor2_2
XFILLER_37_102 VGND VGND VPWR VPWR sky130_fd_sc_hd__fill_1
X_5951_ _6064_/A1 _4582_/A _4582_/B _7072_/Q _6064_/C1 VGND VGND VPWR VPWR _5951_/X
+ sky130_fd_sc_hd__a311o_2
XFILLER_33_330 VGND VGND VPWR VPWR sky130_fd_sc_hd__decap_3
X_4902_ _4902_/A0 _5730_/A1 _4902_/S VGND VGND VPWR VPWR _6927_/D sky130_fd_sc_hd__mux2_2
X_5882_ _6953_/Q _6455_/B2 _5878_/X _5881_/X VGND VGND VPWR VPWR _5882_/X sky130_fd_sc_hd__o211a_2
XFILLER_21_514 VGND VGND VPWR VPWR sky130_fd_sc_hd__decap_3
XFILLER_60_160 VGND VGND VPWR VPWR sky130_fd_sc_hd__fill_1
X_7552_ _7581_/CLK _7552_/D place2022/X VGND VGND VPWR VPWR _7552_/Q sky130_fd_sc_hd__dfrtp_2
XTAP_TAPCELL_ROW_31_553 VGND VPWR sky130_fd_sc_hd__tapvpwrvgnd_1
X_7483_ clkload4/A _7483_/D place2064/X VGND VGND VPWR VPWR _7483_/Q sky130_fd_sc_hd__dfrtp_2
X_6503_ _6511_/B2 _7158_/Q _7130_/Q _6507_/B2 VGND VGND VPWR VPWR _6503_/X sky130_fd_sc_hd__o22a_2
X_3715_ _4281_/B _4281_/C VGND VGND VPWR VPWR _3741_/D sky130_fd_sc_hd__or2_2
X_6434_ _6432_/X _6433_/X _5765_/X VGND VGND VPWR VPWR _6435_/D sky130_fd_sc_hd__a21oi_2
X_4695_ _4695_/A0 _5188_/A1 _4759_/S VGND VGND VPWR VPWR _6859_/D sky130_fd_sc_hd__mux2_2
Xplace1921 _3445_/A VGND VGND VPWR VPWR _3574_/A1 sky130_fd_sc_hd__buf_2
Xplace1910 _4437_/A3 VGND VGND VPWR VPWR _4379_/A sky130_fd_sc_hd__buf_2
X_3646_ _7540_/Q _3812_/A2 _3789_/B1 _7412_/Q VGND VGND VPWR VPWR _3647_/C sky130_fd_sc_hd__a22oi_2
Xplace1954 _7363_/Q VGND VGND VPWR VPWR _6313_/B2 sky130_fd_sc_hd__buf_2
Xplace1943 _7389_/Q VGND VGND VPWR VPWR _3576_/A sky130_fd_sc_hd__buf_2
Xplace1932 _7501_/Q VGND VGND VPWR VPWR _6679_/A0 sky130_fd_sc_hd__buf_2
X_3577_ _3519_/B _3653_/A1 _3577_/A3 _3519_/D _3536_/D VGND VGND VPWR VPWR _3577_/Y
+ sky130_fd_sc_hd__a41oi_4
Xplace1987 _7294_/Q VGND VGND VPWR VPWR _3429_/B sky130_fd_sc_hd__buf_4
Xplace1976 _7296_/Q VGND VGND VPWR VPWR _4473_/B sky130_fd_sc_hd__buf_2
Xplace1965 _7314_/Q VGND VGND VPWR VPWR _4532_/B sky130_fd_sc_hd__buf_2
X_6296_ _6298_/A _6296_/B VGND VGND VPWR VPWR _7354_/D sky130_fd_sc_hd__and2_2
XFILLER_88_558 VGND VGND VPWR VPWR sky130_fd_sc_hd__decap_3
Xplace1998 _7293_/Q VGND VGND VPWR VPWR _3480_/B sky130_fd_sc_hd__buf_6
Xhold2612 _7236_/Q VGND VGND VPWR VPWR _5612_/A0 sky130_fd_sc_hd__dlygate4sd3_1
Xhold2601 _7033_/Q VGND VGND VPWR VPWR _5140_/A0 sky130_fd_sc_hd__dlygate4sd3_1
XFILLER_102_368 VGND VGND VPWR VPWR sky130_fd_sc_hd__decap_3
XFILLER_29_48 VGND VGND VPWR VPWR sky130_fd_sc_hd__decap_3
Xhold2645 _6963_/Q VGND VGND VPWR VPWR _4988_/A0 sky130_fd_sc_hd__dlygate4sd3_1
Xhold2656 _7125_/Q VGND VGND VPWR VPWR _5370_/A0 sky130_fd_sc_hd__dlygate4sd3_1
Xhold2634 _7119_/Q VGND VGND VPWR VPWR _5355_/A0 sky130_fd_sc_hd__dlygate4sd3_1
Xhold2623 _7254_/Q VGND VGND VPWR VPWR _5650_/A0 sky130_fd_sc_hd__dlygate4sd3_1
XFILLER_56_400 VGND VGND VPWR VPWR sky130_fd_sc_hd__decap_3
XFILLER_68_271 VGND VGND VPWR VPWR sky130_fd_sc_hd__decap_3
XFILLER_68_282 VGND VGND VPWR VPWR sky130_fd_sc_hd__decap_3
XFILLER_96_591 VGND VGND VPWR VPWR sky130_fd_sc_hd__decap_3
Xhold2667 _7109_/Q VGND VGND VPWR VPWR _5334_/A0 sky130_fd_sc_hd__dlygate4sd3_1
Xhold2678 _7272_/Q VGND VGND VPWR VPWR _5690_/A0 sky130_fd_sc_hd__dlygate4sd3_1
Xhold2689 _7021_/Q VGND VGND VPWR VPWR _5114_/A0 sky130_fd_sc_hd__dlygate4sd3_1
XFILLER_68_293 VGND VGND VPWR VPWR sky130_fd_sc_hd__decap_3
XTAP_TAPCELL_ROW_3_256 VGND VPWR sky130_fd_sc_hd__tapvpwrvgnd_1
XTAP_TAPCELL_ROW_39_631 VGND VPWR sky130_fd_sc_hd__tapvpwrvgnd_1
XFILLER_45_47 VGND VGND VPWR VPWR sky130_fd_sc_hd__fill_1
XFILLER_43_138 VGND VGND VPWR VPWR sky130_fd_sc_hd__fill_2
XFILLER_43_149 VGND VGND VPWR VPWR sky130_fd_sc_hd__decap_3
XFILLER_71_458 VGND VGND VPWR VPWR sky130_fd_sc_hd__fill_2
XFILLER_101_20 VGND VGND VPWR VPWR sky130_fd_sc_hd__fill_1
XFILLER_36_190 VGND VGND VPWR VPWR sky130_fd_sc_hd__decap_3
XFILLER_24_385 VGND VGND VPWR VPWR sky130_fd_sc_hd__decap_3
XFILLER_20_580 VGND VGND VPWR VPWR sky130_fd_sc_hd__decap_3
XFILLER_3_245 VGND VGND VPWR VPWR sky130_fd_sc_hd__fill_1
XFILLER_10_83 VGND VGND VPWR VPWR sky130_fd_sc_hd__fill_1
XFILLER_19_124 VGND VGND VPWR VPWR sky130_fd_sc_hd__fill_1
XFILLER_19_157 VGND VGND VPWR VPWR sky130_fd_sc_hd__decap_3
XFILLER_34_105 VGND VGND VPWR VPWR sky130_fd_sc_hd__decap_3
XFILLER_35_606 VGND VGND VPWR VPWR sky130_fd_sc_hd__decap_3
XFILLER_27_190 VGND VGND VPWR VPWR sky130_fd_sc_hd__decap_3
XTAP_TAPCELL_ROW_73_987 VGND VPWR sky130_fd_sc_hd__tapvpwrvgnd_1
XFILLER_35_80 VGND VGND VPWR VPWR sky130_fd_sc_hd__decap_3
XFILLER_30_333 VGND VGND VPWR VPWR sky130_fd_sc_hd__decap_3
XFILLER_30_377 VGND VGND VPWR VPWR sky130_fd_sc_hd__decap_3
XFILLER_30_399 VGND VGND VPWR VPWR sky130_fd_sc_hd__decap_3
X_3500_ _6302_/A _3500_/B _3500_/C VGND VGND VPWR VPWR _3500_/Y sky130_fd_sc_hd__nor3_2
Xplace1206 _4900_/S VGND VGND VPWR VPWR _4870_/S sky130_fd_sc_hd__buf_2
X_4480_ _4479_/X _4571_/B1 place1693/X VGND VGND VPWR VPWR _7307_/D sky130_fd_sc_hd__a21bo_2
XTAP_TAPCELL_ROW_77_1035 VGND VPWR sky130_fd_sc_hd__tapvpwrvgnd_1
Xplace1217 _4559_/A VGND VGND VPWR VPWR _4538_/S sky130_fd_sc_hd__buf_2
Xplace1228 _5608_/S VGND VGND VPWR VPWR _5606_/S sky130_fd_sc_hd__buf_2
Xplace1239 _4508_/A VGND VGND VPWR VPWR _4348_/C sky130_fd_sc_hd__buf_2
X_3431_ _3444_/A _3443_/C _3445_/A VGND VGND VPWR VPWR _3499_/A sky130_fd_sc_hd__o21ai_4
X_6150_ _6392_/A _6146_/X _6149_/X _6395_/B1 VGND VGND VPWR VPWR _6150_/X sky130_fd_sc_hd__o22a_2
XFILLER_97_333 VGND VGND VPWR VPWR sky130_fd_sc_hd__decap_3
X_5101_ _5101_/A0 _5162_/A1 _5120_/S VGND VGND VPWR VPWR _7015_/D sky130_fd_sc_hd__mux2_2
X_6081_ _6082_/B _6082_/C _6082_/D VGND VGND VPWR VPWR _6081_/Y sky130_fd_sc_hd__nand3_2
X_5032_ _5427_/A _5488_/B _5093_/C VGND VGND VPWR VPWR _5091_/S sky130_fd_sc_hd__and3_2
XTAP_TAPCELL_ROW_88_1142 VGND VPWR sky130_fd_sc_hd__tapvpwrvgnd_1
XFILLER_38_477 VGND VGND VPWR VPWR sky130_fd_sc_hd__decap_3
XFILLER_53_414 VGND VGND VPWR VPWR sky130_fd_sc_hd__decap_3
XFILLER_93_561 VGND VGND VPWR VPWR sky130_fd_sc_hd__decap_3
XTAP_TAPCELL_ROW_36_601 VGND VPWR sky130_fd_sc_hd__tapvpwrvgnd_1
XTAP_TAPCELL_ROW_0_226 VGND VPWR sky130_fd_sc_hd__tapvpwrvgnd_1
XTAP_TAPCELL_ROW_0_215 VGND VPWR sky130_fd_sc_hd__tapvpwrvgnd_1
XFILLER_65_296 VGND VGND VPWR VPWR sky130_fd_sc_hd__fill_2
XFILLER_80_222 VGND VGND VPWR VPWR sky130_fd_sc_hd__fill_2
X_6983_ _7565_/CLK _6983_/D VGND VGND VPWR VPWR _6983_/Q sky130_fd_sc_hd__dfxtp_2
XFILLER_15_17 VGND VGND VPWR VPWR sky130_fd_sc_hd__fill_1
XFILLER_41_609 VGND VGND VPWR VPWR sky130_fd_sc_hd__decap_3
XFILLER_53_458 VGND VGND VPWR VPWR sky130_fd_sc_hd__decap_3
X_5934_ _6482_/A2 _5927_/Y _4778_/A _5930_/Y _5933_/Y VGND VGND VPWR VPWR _5939_/A
+ sky130_fd_sc_hd__a311o_2
XFILLER_40_119 VGND VGND VPWR VPWR sky130_fd_sc_hd__decap_3
X_7604_ _7606_/CLK _7604_/D place2051/X VGND VGND VPWR VPWR _7604_/Q sky130_fd_sc_hd__dfrtp_2
XTAP_TAPCELL_ROW_16_391 VGND VPWR sky130_fd_sc_hd__tapvpwrvgnd_1
X_5796_ _5792_/X _5795_/X _6458_/B2 VGND VGND VPWR VPWR _5807_/A sky130_fd_sc_hd__a21oi_2
XFILLER_31_38 VGND VGND VPWR VPWR sky130_fd_sc_hd__fill_2
X_7535_ _7608_/CLK _7535_/D place2068/X VGND VGND VPWR VPWR _7535_/Q sky130_fd_sc_hd__dfrtp_2
X_4747_ _4747_/A0 _5720_/A1 _4771_/S VGND VGND VPWR VPWR _6866_/D sky130_fd_sc_hd__mux2_2
XTAP_TAPCELL_ROW_99_1260 VGND VPWR sky130_fd_sc_hd__tapvpwrvgnd_1
X_7466_ _7611_/CLK _7466_/D place2058/X VGND VGND VPWR VPWR _7466_/Q sky130_fd_sc_hd__dfrtp_2
X_7397_ _7493_/CLK _7397_/D place2042/X VGND VGND VPWR VPWR _7397_/Q sky130_fd_sc_hd__dfrtp_2
Xplace1740 _3815_/B1 VGND VGND VPWR VPWR _3792_/B1 sky130_fd_sc_hd__buf_4
Xplace1751 _6675_/S VGND VGND VPWR VPWR _6687_/S sky130_fd_sc_hd__buf_2
Xplace1762 _3811_/A2 VGND VGND VPWR VPWR _6698_/S sky130_fd_sc_hd__buf_2
X_6348_ _5846_/X _7388_/Q _6348_/S VGND VGND VPWR VPWR _7388_/D sky130_fd_sc_hd__mux2_2
XTAP_TAPCELL_ROW_8_304 VGND VPWR sky130_fd_sc_hd__tapvpwrvgnd_1
XFILLER_103_611 VGND VGND VPWR VPWR sky130_fd_sc_hd__fill_1
Xplace1773 _6842_/A VGND VGND VPWR VPWR _6838_/A sky130_fd_sc_hd__buf_2
Xplace1795 _3536_/A VGND VGND VPWR VPWR _3566_/D1 sky130_fd_sc_hd__buf_2
Xplace1784 _3961_/X VGND VGND VPWR VPWR _4356_/B1 sky130_fd_sc_hd__buf_2
XFILLER_0_259 VGND VGND VPWR VPWR sky130_fd_sc_hd__fill_2
XFILLER_48_208 VGND VGND VPWR VPWR sky130_fd_sc_hd__decap_3
Xhold2431 _7255_/Q VGND VGND VPWR VPWR _5652_/A0 sky130_fd_sc_hd__dlygate4sd3_1
Xhold2420 _7215_/Q VGND VGND VPWR VPWR _5566_/A0 sky130_fd_sc_hd__dlygate4sd3_1
X_6279_ _6294_/A _6279_/B VGND VGND VPWR VPWR _7346_/D sky130_fd_sc_hd__and2_2
Xhold2464 _6862_/Q VGND VGND VPWR VPWR _4716_/A0 sky130_fd_sc_hd__dlygate4sd3_1
Xhold2453 _7206_/Q VGND VGND VPWR VPWR _5545_/A0 sky130_fd_sc_hd__dlygate4sd3_1
Xhold2442 _7182_/Q VGND VGND VPWR VPWR _5494_/A0 sky130_fd_sc_hd__dlygate4sd3_1
XFILLER_29_433 VGND VGND VPWR VPWR sky130_fd_sc_hd__decap_3
XFILLER_29_455 VGND VGND VPWR VPWR sky130_fd_sc_hd__decap_3
Xhold2497 _7238_/Q VGND VGND VPWR VPWR _5616_/A0 sky130_fd_sc_hd__dlygate4sd3_1
Xhold2486 _7069_/Q VGND VGND VPWR VPWR _5221_/A0 sky130_fd_sc_hd__dlygate4sd3_1
Xhold2475 _6930_/Q VGND VGND VPWR VPWR _4911_/A0 sky130_fd_sc_hd__dlygate4sd3_1
XFILLER_29_488 VGND VGND VPWR VPWR sky130_fd_sc_hd__decap_3
XFILLER_32_609 VGND VGND VPWR VPWR sky130_fd_sc_hd__decap_3
XFILLER_24_171 VGND VGND VPWR VPWR sky130_fd_sc_hd__decap_3
XFILLER_31_108 VGND VGND VPWR VPWR sky130_fd_sc_hd__decap_3
XFILLER_71_277 VGND VGND VPWR VPWR sky130_fd_sc_hd__decap_3
XTAP_TAPCELL_ROW_70_957 VGND VPWR sky130_fd_sc_hd__tapvpwrvgnd_1
XTAP_TAPCELL_ROW_42_659 VGND VPWR sky130_fd_sc_hd__tapvpwrvgnd_1
XFILLER_8_315 VGND VGND VPWR VPWR sky130_fd_sc_hd__decap_3
XFILLER_8_359 VGND VGND VPWR VPWR sky130_fd_sc_hd__decap_3
XFILLER_39_208 VGND VGND VPWR VPWR sky130_fd_sc_hd__fill_1
XFILLER_39_219 VGND VGND VPWR VPWR sky130_fd_sc_hd__decap_3
XFILLER_75_572 VGND VGND VPWR VPWR sky130_fd_sc_hd__fill_1
XFILLER_50_406 VGND VGND VPWR VPWR sky130_fd_sc_hd__decap_3
X_3980_ _3980_/A _3980_/B _3980_/C VGND VGND VPWR VPWR _3981_/B sky130_fd_sc_hd__nand3_2
XFILLER_43_480 VGND VGND VPWR VPWR sky130_fd_sc_hd__decap_3
XFILLER_15_193 VGND VGND VPWR VPWR sky130_fd_sc_hd__decap_3
Xclkbuf_0_clk clk VGND VGND VPWR VPWR clkbuf_0_clk/X sky130_fd_sc_hd__clkbuf_8
X_5650_ _5650_/A0 _5711_/A1 _5654_/S VGND VGND VPWR VPWR _7254_/D sky130_fd_sc_hd__mux2_2
XTAP_TAPCELL_ROW_83_1094 VGND VPWR sky130_fd_sc_hd__tapvpwrvgnd_1
X_5581_ _5581_/A0 _5703_/A1 _5593_/S VGND VGND VPWR VPWR _7222_/D sky130_fd_sc_hd__mux2_2
XTAP_TAPCELL_ROW_13_361 VGND VPWR sky130_fd_sc_hd__tapvpwrvgnd_1
XFILLER_7_51 VGND VGND VPWR VPWR sky130_fd_sc_hd__decap_3
X_7320_ _7610_/CLK _7320_/D place2055/X VGND VGND VPWR VPWR _7320_/Q sky130_fd_sc_hd__dfrtp_2
X_4532_ _4532_/A _4532_/B _7315_/Q _4532_/D VGND VGND VPWR VPWR _4542_/C sky130_fd_sc_hd__and4_2
XFILLER_7_84 VGND VGND VPWR VPWR sky130_fd_sc_hd__decap_3
X_7251_ _7282_/CLK _7251_/D VGND VGND VPWR VPWR _7251_/Q sky130_fd_sc_hd__dfxtp_2
X_4463_ _4457_/X _4458_/Y _4468_/C1 _4462_/X VGND VGND VPWR VPWR _7304_/D sky130_fd_sc_hd__o2bb2a_2
X_6202_ _4260_/B _4257_/B _6202_/B1 _6564_/D _6559_/B1 VGND VGND VPWR VPWR _6202_/X
+ sky130_fd_sc_hd__o2111a_2
X_3414_ _3414_/A _3414_/B VGND VGND VPWR VPWR _3414_/Y sky130_fd_sc_hd__nand2_2
XPHY_EDGE_ROW_15_Right_15 VGND VGND VPWR VPWR sky130_fd_sc_hd__decap_3
X_7182_ _7393_/CLK _7182_/D VGND VGND VPWR VPWR _7182_/Q sky130_fd_sc_hd__dfxtp_2
X_4394_ _4394_/A _4394_/B VGND VGND VPWR VPWR _4394_/Y sky130_fd_sc_hd__nand2_2
X_6133_ _7224_/Q _6138_/A1 _6131_/X _6132_/X VGND VGND VPWR VPWR _6133_/X sky130_fd_sc_hd__o211a_2
X_6064_ _6064_/A1 _4582_/A _4582_/B _6993_/Q _6064_/C1 VGND VGND VPWR VPWR _6064_/X
+ sky130_fd_sc_hd__a311o_2
XFILLER_85_347 VGND VGND VPWR VPWR sky130_fd_sc_hd__decap_3
X_5015_ _5015_/A0 _5532_/A1 _5030_/S VGND VGND VPWR VPWR _6976_/D sky130_fd_sc_hd__mux2_2
XFILLER_38_274 VGND VGND VPWR VPWR sky130_fd_sc_hd__fill_1
XFILLER_26_469 VGND VGND VPWR VPWR sky130_fd_sc_hd__decap_3
XFILLER_81_542 VGND VGND VPWR VPWR sky130_fd_sc_hd__fill_1
XPHY_EDGE_ROW_24_Right_24 VGND VGND VPWR VPWR sky130_fd_sc_hd__decap_3
X_6966_ _7274_/CLK _6966_/D VGND VGND VPWR VPWR _6966_/Q sky130_fd_sc_hd__dfxtp_2
X_5917_ _5915_/X _5916_/X _4904_/A _6512_/C1 VGND VGND VPWR VPWR _5917_/X sky130_fd_sc_hd__a211o_2
X_6897_ _7290_/CLK _6897_/D VGND VGND VPWR VPWR _6897_/Q sky130_fd_sc_hd__dfxtp_2
X_5848_ _4448_/C _4510_/A _4373_/C _3961_/A VGND VGND VPWR VPWR _5848_/X sky130_fd_sc_hd__o211a_2
XFILLER_21_196 VGND VGND VPWR VPWR sky130_fd_sc_hd__decap_3
X_7518_ clkload2/A _7518_/D place2028/X VGND VGND VPWR VPWR _7518_/Q sky130_fd_sc_hd__dfrtp_2
XPHY_EDGE_ROW_33_Right_33 VGND VGND VPWR VPWR sky130_fd_sc_hd__decap_3
X_7449_ _7507_/CLK _7449_/D place2039/X VGND VGND VPWR VPWR _7449_/Q sky130_fd_sc_hd__dfrtp_2
Xplace1570 _3751_/A VGND VGND VPWR VPWR _4712_/A1 sky130_fd_sc_hd__buf_2
XFILLER_103_441 VGND VGND VPWR VPWR sky130_fd_sc_hd__decap_3
Xplace1581 _3969_/C VGND VGND VPWR VPWR _4398_/C sky130_fd_sc_hd__buf_2
Xplace1592 _3940_/X VGND VGND VPWR VPWR _4012_/C1 sky130_fd_sc_hd__buf_2
XFILLER_49_539 VGND VGND VPWR VPWR sky130_fd_sc_hd__decap_3
XFILLER_76_325 VGND VGND VPWR VPWR sky130_fd_sc_hd__decap_3
XFILLER_76_336 VGND VGND VPWR VPWR sky130_fd_sc_hd__fill_2
XFILLER_76_347 VGND VGND VPWR VPWR sky130_fd_sc_hd__fill_1
XFILLER_29_252 VGND VGND VPWR VPWR sky130_fd_sc_hd__decap_3
XFILLER_91_317 VGND VGND VPWR VPWR sky130_fd_sc_hd__decap_3
XTAP_TAPCELL_ROW_47_718 VGND VPWR sky130_fd_sc_hd__tapvpwrvgnd_1
XFILLER_17_425 VGND VGND VPWR VPWR sky130_fd_sc_hd__fill_2
XFILLER_29_296 VGND VGND VPWR VPWR sky130_fd_sc_hd__decap_3
XFILLER_72_520 VGND VGND VPWR VPWR sky130_fd_sc_hd__decap_3
XPHY_EDGE_ROW_42_Right_42 VGND VGND VPWR VPWR sky130_fd_sc_hd__decap_3
XFILLER_32_417 VGND VGND VPWR VPWR sky130_fd_sc_hd__decap_3
XFILLER_32_439 VGND VGND VPWR VPWR sky130_fd_sc_hd__decap_3
XFILLER_44_299 VGND VGND VPWR VPWR sky130_fd_sc_hd__fill_1
XFILLER_83_88 VGND VGND VPWR VPWR sky130_fd_sc_hd__fill_1
XFILLER_12_141 VGND VGND VPWR VPWR sky130_fd_sc_hd__decap_3
XFILLER_12_163 VGND VGND VPWR VPWR sky130_fd_sc_hd__fill_2
XFILLER_8_112 VGND VGND VPWR VPWR sky130_fd_sc_hd__decap_3
XFILLER_12_174 VGND VGND VPWR VPWR sky130_fd_sc_hd__fill_2
XFILLER_8_156 VGND VGND VPWR VPWR sky130_fd_sc_hd__fill_1
XPHY_EDGE_ROW_51_Right_51 VGND VGND VPWR VPWR sky130_fd_sc_hd__decap_3
XTAP_TAPCELL_ROW_10_331 VGND VPWR sky130_fd_sc_hd__tapvpwrvgnd_1
XTAP_TAPCELL_ROW_74_1005 VGND VPWR sky130_fd_sc_hd__tapvpwrvgnd_1
XFILLER_4_362 VGND VGND VPWR VPWR sky130_fd_sc_hd__fill_2
XFILLER_4_384 VGND VGND VPWR VPWR sky130_fd_sc_hd__decap_3
XPHY_EDGE_ROW_60_Right_60 VGND VGND VPWR VPWR sky130_fd_sc_hd__decap_3
XFILLER_35_222 VGND VGND VPWR VPWR sky130_fd_sc_hd__fill_2
XFILLER_75_380 VGND VGND VPWR VPWR sky130_fd_sc_hd__decap_3
XTAP_TAPCELL_ROW_85_1112 VGND VPWR sky130_fd_sc_hd__tapvpwrvgnd_1
X_6820_ _6842_/A _6820_/B VGND VGND VPWR VPWR _7568_/D sky130_fd_sc_hd__and2_2
XFILLER_35_266 VGND VGND VPWR VPWR sky130_fd_sc_hd__decap_3
XFILLER_16_480 VGND VGND VPWR VPWR sky130_fd_sc_hd__fill_2
XFILLER_50_225 VGND VGND VPWR VPWR sky130_fd_sc_hd__fill_1
XFILLER_50_236 VGND VGND VPWR VPWR sky130_fd_sc_hd__decap_3
X_3963_ _7424_/Q _4004_/A2 _4004_/B1 _7328_/Q _3962_/X VGND VGND VPWR VPWR _3963_/X
+ sky130_fd_sc_hd__a221o_2
XFILLER_31_461 VGND VGND VPWR VPWR sky130_fd_sc_hd__fill_1
X_3894_ _3894_/A _3894_/B _3894_/C VGND VGND VPWR VPWR _3896_/B sky130_fd_sc_hd__nand3_2
XFILLER_31_483 VGND VGND VPWR VPWR sky130_fd_sc_hd__decap_3
X_5633_ _5633_/A0 _5694_/A1 _5635_/S VGND VGND VPWR VPWR _7246_/D sky130_fd_sc_hd__mux2_2
X_5564_ _5564_/A0 _5564_/A1 _5608_/S VGND VGND VPWR VPWR _7214_/D sky130_fd_sc_hd__mux2_2
X_7303_ _7611_/CLK _7303_/D place2054/X VGND VGND VPWR VPWR _7303_/Q sky130_fd_sc_hd__dfrtp_2
X_4515_ _4559_/A _4532_/D _4515_/C VGND VGND VPWR VPWR _4515_/X sky130_fd_sc_hd__or3_2
XTAP_TAPCELL_ROW_96_1230 VGND VPWR sky130_fd_sc_hd__tapvpwrvgnd_1
XPHY_EDGE_ROW_103_Right_103 VGND VGND VPWR VPWR sky130_fd_sc_hd__decap_3
X_7234_ _7289_/CLK _7234_/D VGND VGND VPWR VPWR _7234_/Q sky130_fd_sc_hd__dfxtp_2
X_4446_ _4472_/A _4443_/X _4444_/X _4475_/S VGND VGND VPWR VPWR _4446_/X sky130_fd_sc_hd__a31o_2
X_7165_ _7282_/CLK _7165_/D VGND VGND VPWR VPWR _7165_/Q sky130_fd_sc_hd__dfxtp_2
X_4377_ _4348_/C _4325_/B _4411_/A _4376_/Y VGND VGND VPWR VPWR _4377_/Y sky130_fd_sc_hd__o22ai_2
XFILLER_100_411 VGND VGND VPWR VPWR sky130_fd_sc_hd__fill_1
X_6116_ _7167_/Q _6165_/A1 _6114_/X _6115_/X VGND VGND VPWR VPWR _6116_/X sky130_fd_sc_hd__o211a_2
XFILLER_58_336 VGND VGND VPWR VPWR sky130_fd_sc_hd__decap_3
X_7096_ _7264_/CLK _7096_/D VGND VGND VPWR VPWR _7096_/Q sky130_fd_sc_hd__dfxtp_2
XFILLER_39_561 VGND VGND VPWR VPWR sky130_fd_sc_hd__fill_1
XFILLER_46_509 VGND VGND VPWR VPWR sky130_fd_sc_hd__fill_2
XFILLER_85_166 VGND VGND VPWR VPWR sky130_fd_sc_hd__fill_2
X_6047_ _7076_/Q _6468_/A2 _6510_/A1 _7104_/Q _6046_/X VGND VGND VPWR VPWR _6048_/B
+ sky130_fd_sc_hd__o221a_2
XFILLER_26_222 VGND VGND VPWR VPWR sky130_fd_sc_hd__decap_3
XFILLER_54_542 VGND VGND VPWR VPWR sky130_fd_sc_hd__decap_3
XFILLER_54_597 VGND VGND VPWR VPWR sky130_fd_sc_hd__fill_2
XFILLER_41_225 VGND VGND VPWR VPWR sky130_fd_sc_hd__decap_3
X_6949_ _7276_/CLK _6949_/D VGND VGND VPWR VPWR _6949_/Q sky130_fd_sc_hd__dfxtp_2
XFILLER_22_461 VGND VGND VPWR VPWR sky130_fd_sc_hd__decap_3
XTAP_TAPCELL_ROW_52_765 VGND VPWR sky130_fd_sc_hd__tapvpwrvgnd_1
XTAP_TAPCELL_ROW_24_478 VGND VPWR sky130_fd_sc_hd__tapvpwrvgnd_1
XFILLER_22_483 VGND VGND VPWR VPWR sky130_fd_sc_hd__decap_3
XFILLER_5_159 VGND VGND VPWR VPWR sky130_fd_sc_hd__fill_2
XFILLER_96_409 VGND VGND VPWR VPWR sky130_fd_sc_hd__decap_3
XFILLER_64_306 VGND VGND VPWR VPWR sky130_fd_sc_hd__fill_2
XFILLER_27_70 VGND VGND VPWR VPWR sky130_fd_sc_hd__decap_3
XFILLER_57_391 VGND VGND VPWR VPWR sky130_fd_sc_hd__fill_1
XFILLER_32_214 VGND VGND VPWR VPWR sky130_fd_sc_hd__decap_3
XFILLER_32_236 VGND VGND VPWR VPWR sky130_fd_sc_hd__fill_2
XFILLER_40_280 VGND VGND VPWR VPWR sky130_fd_sc_hd__decap_3
XTAP_TAPCELL_ROW_80_1064 VGND VPWR sky130_fd_sc_hd__tapvpwrvgnd_1
XFILLER_71_6 VGND VGND VPWR VPWR sky130_fd_sc_hd__decap_3
X_5280_ _5280_/A0 _5593_/A1 _5302_/S VGND VGND VPWR VPWR _7088_/D sky130_fd_sc_hd__mux2_2
X_4300_ _6183_/A _6183_/B _4300_/A3 _4295_/Y _4299_/Y VGND VGND VPWR VPWR _4300_/X
+ sky130_fd_sc_hd__o311a_2
X_4231_ _4231_/A _4231_/B VGND VGND VPWR VPWR _4232_/D sky130_fd_sc_hd__and2_2
XFILLER_4_85 VGND VGND VPWR VPWR sky130_fd_sc_hd__decap_3
XTAP_TAPCELL_ROW_91_1182 VGND VPWR sky130_fd_sc_hd__tapvpwrvgnd_1
X_4162_ _4163_/A2 _4149_/X _4157_/Y VGND VGND VPWR VPWR _4164_/B sky130_fd_sc_hd__o21ai_2
XFILLER_67_166 VGND VGND VPWR VPWR sky130_fd_sc_hd__fill_2
X_4093_ _4094_/A _4094_/B _3987_/Y VGND VGND VPWR VPWR _4093_/X sky130_fd_sc_hd__o21a_2
XFILLER_36_520 VGND VGND VPWR VPWR sky130_fd_sc_hd__fill_2
XFILLER_70_309 VGND VGND VPWR VPWR sky130_fd_sc_hd__fill_2
XFILLER_63_361 VGND VGND VPWR VPWR sky130_fd_sc_hd__fill_1
XFILLER_23_225 VGND VGND VPWR VPWR sky130_fd_sc_hd__decap_3
XFILLER_51_556 VGND VGND VPWR VPWR sky130_fd_sc_hd__decap_3
XFILLER_63_383 VGND VGND VPWR VPWR sky130_fd_sc_hd__fill_2
XFILLER_23_258 VGND VGND VPWR VPWR sky130_fd_sc_hd__decap_3
X_3946_ _3946_/A _3946_/B _3946_/C VGND VGND VPWR VPWR _3946_/X sky130_fd_sc_hd__or3_2
X_3877_ _3572_/A3 _3931_/C _3832_/A _3876_/Y VGND VGND VPWR VPWR _3884_/A sky130_fd_sc_hd__o2bb2a_2
XTAP_TAPCELL_ROW_21_448 VGND VPWR sky130_fd_sc_hd__tapvpwrvgnd_1
X_6596_ _6596_/A0 _6040_/X _6607_/S VGND VGND VPWR VPWR _7462_/D sky130_fd_sc_hd__mux2_2
X_5616_ _5616_/A0 _5677_/A1 _5635_/S VGND VGND VPWR VPWR _7238_/D sky130_fd_sc_hd__mux2_2
XFILLER_3_608 VGND VGND VPWR VPWR sky130_fd_sc_hd__decap_3
X_5547_ _5547_/A0 _5608_/A1 _5547_/S VGND VGND VPWR VPWR _7207_/D sky130_fd_sc_hd__mux2_2
X_5478_ _5478_/A0 _5600_/A1 _5486_/S VGND VGND VPWR VPWR _7175_/D sky130_fd_sc_hd__mux2_2
X_7217_ _7217_/CLK _7217_/D VGND VGND VPWR VPWR _7217_/Q sky130_fd_sc_hd__dfxtp_2
X_4429_ _4036_/A _7299_/Q _7300_/Q _7301_/Q _4420_/B VGND VGND VPWR VPWR _4429_/X
+ sky130_fd_sc_hd__o41a_2
XFILLER_48_36 VGND VGND VPWR VPWR sky130_fd_sc_hd__fill_1
X_7148_ _7288_/CLK _7148_/D VGND VGND VPWR VPWR _7148_/Q sky130_fd_sc_hd__dfxtp_2
XFILLER_100_241 VGND VGND VPWR VPWR sky130_fd_sc_hd__decap_3
XFILLER_58_144 VGND VGND VPWR VPWR sky130_fd_sc_hd__decap_3
XFILLER_86_475 VGND VGND VPWR VPWR sky130_fd_sc_hd__fill_1
X_7079_ _7243_/CLK _7079_/D VGND VGND VPWR VPWR _7079_/Q sky130_fd_sc_hd__dfxtp_2
XFILLER_46_328 VGND VGND VPWR VPWR sky130_fd_sc_hd__decap_3
XTAP_TAPCELL_ROW_57_824 VGND VPWR sky130_fd_sc_hd__tapvpwrvgnd_1
XTAP_TAPCELL_ROW_29_526 VGND VPWR sky130_fd_sc_hd__tapvpwrvgnd_1
XFILLER_61_309 VGND VGND VPWR VPWR sky130_fd_sc_hd__decap_3
XFILLER_27_564 VGND VGND VPWR VPWR sky130_fd_sc_hd__decap_3
XTAP_TAPCELL_ROW_103_1307 VGND VPWR sky130_fd_sc_hd__tapvpwrvgnd_1
XFILLER_14_236 VGND VGND VPWR VPWR sky130_fd_sc_hd__fill_2
XTAP_TAPCELL_ROW_103_1318 VGND VPWR sky130_fd_sc_hd__tapvpwrvgnd_1
XFILLER_22_280 VGND VGND VPWR VPWR sky130_fd_sc_hd__decap_3
XFILLER_10_486 VGND VGND VPWR VPWR sky130_fd_sc_hd__fill_1
XFILLER_13_61 VGND VGND VPWR VPWR sky130_fd_sc_hd__decap_3
XFILLER_6_424 VGND VGND VPWR VPWR sky130_fd_sc_hd__fill_2
XFILLER_49_100 VGND VGND VPWR VPWR sky130_fd_sc_hd__decap_3
XFILLER_37_317 VGND VGND VPWR VPWR sky130_fd_sc_hd__decap_3
XFILLER_49_188 VGND VGND VPWR VPWR sky130_fd_sc_hd__decap_3
XFILLER_64_114 VGND VGND VPWR VPWR sky130_fd_sc_hd__fill_2
XFILLER_18_542 VGND VGND VPWR VPWR sky130_fd_sc_hd__decap_3
XFILLER_33_501 VGND VGND VPWR VPWR sky130_fd_sc_hd__decap_3
XFILLER_52_309 VGND VGND VPWR VPWR sky130_fd_sc_hd__fill_2
XFILLER_33_523 VGND VGND VPWR VPWR sky130_fd_sc_hd__decap_3
XFILLER_60_320 VGND VGND VPWR VPWR sky130_fd_sc_hd__decap_3
XFILLER_60_342 VGND VGND VPWR VPWR sky130_fd_sc_hd__decap_3
X_4780_ _4842_/B _4842_/C _4780_/C VGND VGND VPWR VPWR _5488_/B sky130_fd_sc_hd__and3_2
X_3800_ _7404_/Q _6706_/S _3799_/X VGND VGND VPWR VPWR _3807_/C sky130_fd_sc_hd__a21oi_2
XFILLER_20_206 VGND VGND VPWR VPWR sky130_fd_sc_hd__decap_3
XFILLER_60_375 VGND VGND VPWR VPWR sky130_fd_sc_hd__decap_3
X_3731_ _3780_/A1 _3815_/A2 _7386_/Q _3815_/B1 _7578_/Q VGND VGND VPWR VPWR _3731_/X
+ sky130_fd_sc_hd__a32o_2
XFILLER_9_284 VGND VGND VPWR VPWR sky130_fd_sc_hd__decap_3
Xclkload10 _7565_/CLK VGND VGND VPWR VPWR clkload10/Y sky130_fd_sc_hd__inv_4
X_6450_ _6456_/B2 _7066_/Q _6870_/Q _6450_/B2 VGND VGND VPWR VPWR _6450_/X sky130_fd_sc_hd__o22a_2
Xclkload32 _7282_/CLK VGND VGND VPWR VPWR clkload32/Y sky130_fd_sc_hd__clkinvlp_4
Xclkload21 _7393_/CLK VGND VGND VPWR VPWR clkload21/Y sky130_fd_sc_hd__clkinv_1
X_6381_ _6381_/A1 _6410_/A2 _6410_/A3 _6410_/B1 _7407_/Q VGND VGND VPWR VPWR _7407_/D
+ sky130_fd_sc_hd__a32o_2
XTAP_TAPCELL_ROW_93_1200 VGND VPWR sky130_fd_sc_hd__tapvpwrvgnd_1
Xhold2805 _7228_/Q VGND VGND VPWR VPWR _5593_/A0 sky130_fd_sc_hd__dlygate4sd3_1
Xhold2816 _7000_/Q VGND VGND VPWR VPWR _5068_/A0 sky130_fd_sc_hd__dlygate4sd3_1
Xhold2827 _7340_/Q VGND VGND VPWR VPWR _6267_/B sky130_fd_sc_hd__dlygate4sd3_1
Xhold2838 _7522_/Q VGND VGND VPWR VPWR _6722_/A1 sky130_fd_sc_hd__dlygate4sd3_1
X_7002_ _7114_/CLK _7002_/D VGND VGND VPWR VPWR _7002_/Q sky130_fd_sc_hd__dfxtp_2
X_5194_ _5194_/A0 _5344_/A1 _5207_/S VGND VGND VPWR VPWR _7058_/D sky130_fd_sc_hd__mux2_2
X_4214_ place1453/X _4211_/X _4206_/B _4213_/X VGND VGND VPWR VPWR _4215_/A sky130_fd_sc_hd__a2bb2o_2
Xhold2849 _7200_/Q VGND VGND VPWR VPWR _5532_/A0 sky130_fd_sc_hd__dlygate4sd3_1
X_4145_ _4141_/Y _4142_/X _4144_/X _4136_/Y _3944_/Y VGND VGND VPWR VPWR _4168_/A
+ sky130_fd_sc_hd__o32ai_2
XFILLER_18_39 VGND VGND VPWR VPWR sky130_fd_sc_hd__decap_3
XFILLER_55_136 VGND VGND VPWR VPWR sky130_fd_sc_hd__decap_3
X_4076_ _7316_/Q _4533_/C VGND VGND VPWR VPWR _4079_/A sky130_fd_sc_hd__nor2_2
XFILLER_36_361 VGND VGND VPWR VPWR sky130_fd_sc_hd__decap_3
XFILLER_55_169 VGND VGND VPWR VPWR sky130_fd_sc_hd__fill_1
XFILLER_24_523 VGND VGND VPWR VPWR sky130_fd_sc_hd__decap_3
XFILLER_24_545 VGND VGND VPWR VPWR sky130_fd_sc_hd__decap_3
XFILLER_11_206 VGND VGND VPWR VPWR sky130_fd_sc_hd__decap_3
XFILLER_11_228 VGND VGND VPWR VPWR sky130_fd_sc_hd__decap_3
XTAP_TAPCELL_ROW_62_871 VGND VPWR sky130_fd_sc_hd__tapvpwrvgnd_1
XTAP_TAPCELL_ROW_34_584 VGND VPWR sky130_fd_sc_hd__tapvpwrvgnd_1
Xclkload4 clkload4/A VGND VGND VPWR VPWR clkload4/Y sky130_fd_sc_hd__clkinv_4
X_3929_ _7298_/Q _3931_/B _3931_/C _3928_/Y VGND VGND VPWR VPWR _4151_/B sky130_fd_sc_hd__a31o_2
XFILLER_3_405 VGND VGND VPWR VPWR sky130_fd_sc_hd__fill_1
XFILLER_3_416 VGND VGND VPWR VPWR sky130_fd_sc_hd__decap_3
X_6579_ _6579_/A0 _5857_/X _6590_/S VGND VGND VPWR VPWR _7454_/D sky130_fd_sc_hd__mux2_2
XFILLER_1_6 VGND VGND VPWR VPWR sky130_fd_sc_hd__decap_3
XFILLER_59_57 VGND VGND VPWR VPWR sky130_fd_sc_hd__decap_3
XFILLER_59_453 VGND VGND VPWR VPWR sky130_fd_sc_hd__fill_1
XFILLER_59_497 VGND VGND VPWR VPWR sky130_fd_sc_hd__fill_1
XTAP_TAPCELL_ROW_6_287 VGND VPWR sky130_fd_sc_hd__tapvpwrvgnd_1
XFILLER_46_147 VGND VGND VPWR VPWR sky130_fd_sc_hd__decap_3
XFILLER_34_309 VGND VGND VPWR VPWR sky130_fd_sc_hd__decap_3
XFILLER_54_180 VGND VGND VPWR VPWR sky130_fd_sc_hd__decap_3
XFILLER_61_128 VGND VGND VPWR VPWR sky130_fd_sc_hd__decap_3
XFILLER_42_353 VGND VGND VPWR VPWR sky130_fd_sc_hd__decap_3
XFILLER_24_60 VGND VGND VPWR VPWR sky130_fd_sc_hd__decap_3
XFILLER_30_526 VGND VGND VPWR VPWR sky130_fd_sc_hd__decap_3
XFILLER_10_294 VGND VGND VPWR VPWR sky130_fd_sc_hd__decap_3
XFILLER_6_298 VGND VGND VPWR VPWR sky130_fd_sc_hd__decap_3
XFILLER_69_228 VGND VGND VPWR VPWR sky130_fd_sc_hd__decap_3
XFILLER_65_445 VGND VGND VPWR VPWR sky130_fd_sc_hd__decap_3
XFILLER_25_309 VGND VGND VPWR VPWR sky130_fd_sc_hd__decap_3
XFILLER_65_489 VGND VGND VPWR VPWR sky130_fd_sc_hd__fill_1
XFILLER_92_253 VGND VGND VPWR VPWR sky130_fd_sc_hd__decap_3
X_5950_ _7240_/Q _5991_/B2 _5948_/X _5949_/X VGND VGND VPWR VPWR _5950_/X sky130_fd_sc_hd__o211a_2
XFILLER_52_128 VGND VGND VPWR VPWR sky130_fd_sc_hd__decap_3
X_5881_ _7037_/Q _6455_/A1 _6213_/B2 _6981_/Q VGND VGND VPWR VPWR _5881_/X sky130_fd_sc_hd__o22a_2
XFILLER_21_526 VGND VGND VPWR VPWR sky130_fd_sc_hd__decap_3
XFILLER_60_150 VGND VGND VPWR VPWR sky130_fd_sc_hd__fill_1
X_4832_ _4832_/A0 _4751_/Y _4838_/S VGND VGND VPWR VPWR _6895_/D sky130_fd_sc_hd__mux2_2
X_7551_ _7581_/CLK _7551_/D place2022/X VGND VGND VPWR VPWR _7551_/Q sky130_fd_sc_hd__dfrtp_2
X_4763_ _6404_/A2 _4763_/A2 _4762_/X VGND VGND VPWR VPWR _4763_/Y sky130_fd_sc_hd__a21oi_2
X_7482_ _7493_/CLK _7482_/D place2043/X VGND VGND VPWR VPWR _7482_/Q sky130_fd_sc_hd__dfrtp_2
X_6502_ _7074_/Q _6502_/A2 _6502_/B1 _7102_/Q _6501_/X VGND VGND VPWR VPWR _6502_/X
+ sky130_fd_sc_hd__o221a_2
X_3714_ _7318_/Q _3761_/B _3761_/C _3707_/Y _3712_/Y VGND VGND VPWR VPWR _4281_/C
+ sky130_fd_sc_hd__a311oi_2
X_6433_ _6473_/A1 _6901_/Q _7237_/Q _6476_/B2 VGND VGND VPWR VPWR _6433_/X sky130_fd_sc_hd__o22a_2
XFILLER_20_18 VGND VGND VPWR VPWR sky130_fd_sc_hd__decap_3
XFILLER_20_29 VGND VGND VPWR VPWR sky130_fd_sc_hd__decap_3
Xplace1911 _3845_/C VGND VGND VPWR VPWR _4437_/A3 sky130_fd_sc_hd__buf_2
Xplace1900 _3436_/Y VGND VGND VPWR VPWR _4027_/B1 sky130_fd_sc_hd__buf_2
Xplace1955 _7362_/Q VGND VGND VPWR VPWR _6312_/B2 sky130_fd_sc_hd__buf_2
Xplace1944 _7379_/Q VGND VGND VPWR VPWR _6335_/B2 sky130_fd_sc_hd__buf_2
Xplace1933 _7499_/Q VGND VGND VPWR VPWR _6675_/A0 sky130_fd_sc_hd__buf_2
Xplace1922 _6231_/A2 VGND VGND VPWR VPWR _4734_/A2 sky130_fd_sc_hd__buf_2
X_3576_ _3576_/A _3576_/B _3576_/C VGND VGND VPWR VPWR _3576_/Y sky130_fd_sc_hd__nand3_2
Xplace1988 _3444_/C VGND VGND VPWR VPWR _3826_/A sky130_fd_sc_hd__buf_2
Xplace1977 _3843_/B VGND VGND VPWR VPWR _4373_/C sky130_fd_sc_hd__buf_2
Xplace1966 _7313_/Q VGND VGND VPWR VPWR _4532_/A sky130_fd_sc_hd__buf_2
Xplace1999 _3444_/A VGND VGND VPWR VPWR _3628_/A1 sky130_fd_sc_hd__buf_2
Xhold2613 _6923_/Q VGND VGND VPWR VPWR _4894_/A0 sky130_fd_sc_hd__dlygate4sd3_1
Xhold2602 _6911_/Q VGND VGND VPWR VPWR _4868_/A0 sky130_fd_sc_hd__dlygate4sd3_1
X_5246_ _5246_/A0 _5570_/A1 _5299_/S VGND VGND VPWR VPWR _7077_/D sky130_fd_sc_hd__mux2_2
XFILLER_29_27 VGND VGND VPWR VPWR sky130_fd_sc_hd__fill_2
XPHY_EDGE_ROW_89_Right_89 VGND VGND VPWR VPWR sky130_fd_sc_hd__decap_3
Xhold2635 _7137_/Q VGND VGND VPWR VPWR _5396_/A0 sky130_fd_sc_hd__dlygate4sd3_1
Xhold2646 _7225_/Q VGND VGND VPWR VPWR _5587_/A0 sky130_fd_sc_hd__dlygate4sd3_1
Xhold2624 _6932_/Q VGND VGND VPWR VPWR _4915_/A0 sky130_fd_sc_hd__dlygate4sd3_1
XFILLER_56_412 VGND VGND VPWR VPWR sky130_fd_sc_hd__decap_3
XFILLER_68_250 VGND VGND VPWR VPWR sky130_fd_sc_hd__fill_2
Xhold2657 _7136_/Q VGND VGND VPWR VPWR _5393_/A0 sky130_fd_sc_hd__dlygate4sd3_1
Xhold2668 _7112_/Q VGND VGND VPWR VPWR _5340_/A0 sky130_fd_sc_hd__dlygate4sd3_1
Xhold2679 _6896_/Q VGND VGND VPWR VPWR _4834_/A0 sky130_fd_sc_hd__dlygate4sd3_1
X_5177_ _5177_/A0 _5572_/A1 _5179_/S VGND VGND VPWR VPWR _7050_/D sky130_fd_sc_hd__mux2_2
XFILLER_56_434 VGND VGND VPWR VPWR sky130_fd_sc_hd__decap_3
XTAP_TAPCELL_ROW_67_930 VGND VPWR sky130_fd_sc_hd__tapvpwrvgnd_1
XTAP_TAPCELL_ROW_3_257 VGND VPWR sky130_fd_sc_hd__tapvpwrvgnd_1
XTAP_TAPCELL_ROW_39_632 VGND VPWR sky130_fd_sc_hd__tapvpwrvgnd_1
XFILLER_16_309 VGND VGND VPWR VPWR sky130_fd_sc_hd__decap_3
XFILLER_28_158 VGND VGND VPWR VPWR sky130_fd_sc_hd__decap_3
XFILLER_56_489 VGND VGND VPWR VPWR sky130_fd_sc_hd__decap_3
X_4059_ _7309_/Q _7310_/Q _4059_/C VGND VGND VPWR VPWR _4499_/C sky130_fd_sc_hd__and3_2
XFILLER_43_117 VGND VGND VPWR VPWR sky130_fd_sc_hd__fill_1
XFILLER_43_128 VGND VGND VPWR VPWR sky130_fd_sc_hd__fill_1
XFILLER_12_526 VGND VGND VPWR VPWR sky130_fd_sc_hd__decap_3
XFILLER_24_375 VGND VGND VPWR VPWR sky130_fd_sc_hd__fill_1
XFILLER_51_150 VGND VGND VPWR VPWR sky130_fd_sc_hd__decap_3
XPHY_EDGE_ROW_98_Right_98 VGND VGND VPWR VPWR sky130_fd_sc_hd__decap_3
XFILLER_94_518 VGND VGND VPWR VPWR sky130_fd_sc_hd__decap_3
XFILLER_19_136 VGND VGND VPWR VPWR sky130_fd_sc_hd__decap_3
XFILLER_19_71 VGND VGND VPWR VPWR sky130_fd_sc_hd__decap_3
XFILLER_47_434 VGND VGND VPWR VPWR sky130_fd_sc_hd__decap_3
XFILLER_19_169 VGND VGND VPWR VPWR sky130_fd_sc_hd__decap_3
XFILLER_47_489 VGND VGND VPWR VPWR sky130_fd_sc_hd__decap_3
XFILLER_74_297 VGND VGND VPWR VPWR sky130_fd_sc_hd__fill_1
XTAP_TAPCELL_ROW_73_988 VGND VPWR sky130_fd_sc_hd__tapvpwrvgnd_1
XFILLER_15_364 VGND VGND VPWR VPWR sky130_fd_sc_hd__decap_3
XFILLER_30_312 VGND VGND VPWR VPWR sky130_fd_sc_hd__decap_3
XFILLER_42_183 VGND VGND VPWR VPWR sky130_fd_sc_hd__decap_3
XFILLER_7_530 VGND VGND VPWR VPWR sky130_fd_sc_hd__decap_3
Xplace1207 _4840_/S VGND VGND VPWR VPWR _4834_/S sky130_fd_sc_hd__buf_2
XTAP_TAPCELL_ROW_77_1036 VGND VPWR sky130_fd_sc_hd__tapvpwrvgnd_1
Xplace1218 _4325_/Y VGND VGND VPWR VPWR _4559_/A sky130_fd_sc_hd__buf_2
Xplace1229 _5608_/S VGND VGND VPWR VPWR _5593_/S sky130_fd_sc_hd__buf_2
X_3430_ _3421_/B _3459_/B _3429_/Y VGND VGND VPWR VPWR _3430_/Y sky130_fd_sc_hd__a21boi_2
XFILLER_97_301 VGND VGND VPWR VPWR sky130_fd_sc_hd__decap_3
XFILLER_32_3 VGND VGND VPWR VPWR sky130_fd_sc_hd__decap_3
X_6080_ _7594_/Q _6220_/B1 _6079_/X VGND VGND VPWR VPWR _6080_/X sky130_fd_sc_hd__o21a_2
XFILLER_38_445 VGND VGND VPWR VPWR sky130_fd_sc_hd__fill_1
XFILLER_26_607 VGND VGND VPWR VPWR sky130_fd_sc_hd__decap_3
XFILLER_38_467 VGND VGND VPWR VPWR sky130_fd_sc_hd__fill_1
XFILLER_65_264 VGND VGND VPWR VPWR sky130_fd_sc_hd__fill_2
XFILLER_65_275 VGND VGND VPWR VPWR sky130_fd_sc_hd__fill_1
XTAP_TAPCELL_ROW_88_1143 VGND VPWR sky130_fd_sc_hd__tapvpwrvgnd_1
XTAP_TAPCELL_ROW_64_900 VGND VPWR sky130_fd_sc_hd__tapvpwrvgnd_1
XTAP_TAPCELL_ROW_36_602 VGND VPWR sky130_fd_sc_hd__tapvpwrvgnd_1
XTAP_TAPCELL_ROW_0_227 VGND VPWR sky130_fd_sc_hd__tapvpwrvgnd_1
XTAP_TAPCELL_ROW_0_216 VGND VPWR sky130_fd_sc_hd__tapvpwrvgnd_1
XFILLER_25_139 VGND VGND VPWR VPWR sky130_fd_sc_hd__fill_2
X_6982_ _7290_/CLK _6982_/D VGND VGND VPWR VPWR _6982_/Q sky130_fd_sc_hd__dfxtp_2
XFILLER_18_191 VGND VGND VPWR VPWR sky130_fd_sc_hd__decap_3
X_5933_ _5931_/X _5932_/X _6478_/B1 VGND VGND VPWR VPWR _5933_/Y sky130_fd_sc_hd__a21oi_2
XFILLER_21_301 VGND VGND VPWR VPWR sky130_fd_sc_hd__decap_3
XFILLER_33_194 VGND VGND VPWR VPWR sky130_fd_sc_hd__decap_3
X_7603_ _7606_/CLK _7603_/D place2052/X VGND VGND VPWR VPWR _7603_/Q sky130_fd_sc_hd__dfrtp_2
X_4815_ _4815_/A0 _5705_/A1 _4834_/S VGND VGND VPWR VPWR _6887_/D sky130_fd_sc_hd__mux2_2
XTAP_TAPCELL_ROW_44_690 VGND VPWR sky130_fd_sc_hd__tapvpwrvgnd_1
XTAP_TAPCELL_ROW_16_392 VGND VPWR sky130_fd_sc_hd__tapvpwrvgnd_1
XFILLER_21_389 VGND VGND VPWR VPWR sky130_fd_sc_hd__decap_3
X_7534_ _7608_/CLK _7534_/D place2068/X VGND VGND VPWR VPWR _7534_/Q sky130_fd_sc_hd__dfrtp_2
X_5795_ _6504_/A2 _6877_/Q _7269_/Q _5797_/A1 VGND VGND VPWR VPWR _5795_/X sky130_fd_sc_hd__o22a_2
XTAP_TAPCELL_ROW_99_1261 VGND VPWR sky130_fd_sc_hd__tapvpwrvgnd_1
X_7465_ clkload3/A _7465_/D place2063/X VGND VGND VPWR VPWR _7465_/Q sky130_fd_sc_hd__dfrtp_2
X_4677_ _4674_/X _4676_/X _6328_/B2 _4757_/A1 VGND VGND VPWR VPWR _4677_/X sky130_fd_sc_hd__a2bb2o_2
X_7396_ clkload8/A _7396_/D place2026/X VGND VGND VPWR VPWR _7396_/Q sky130_fd_sc_hd__dfrtp_2
X_6416_ _6416_/A0 _5846_/X _6497_/S VGND VGND VPWR VPWR _7420_/D sky130_fd_sc_hd__mux2_2
X_3628_ _3628_/A1 _3628_/A2 _3628_/A3 _3628_/B1 _3628_/C1 VGND VGND VPWR VPWR _3628_/X
+ sky130_fd_sc_hd__o311a_4
Xplace1730 _3860_/A2 VGND VGND VPWR VPWR _3920_/B sky130_fd_sc_hd__buf_4
Xplace1741 _3936_/B1 VGND VGND VPWR VPWR _3815_/B1 sky130_fd_sc_hd__buf_4
Xplace1752 _6664_/S VGND VGND VPWR VPWR _6675_/S sky130_fd_sc_hd__buf_2
Xplace1763 _6706_/S VGND VGND VPWR VPWR _3811_/A2 sky130_fd_sc_hd__clkbuf_4
X_6347_ _6347_/A _6347_/B _6347_/C _6347_/D VGND VGND VPWR VPWR _6348_/S sky130_fd_sc_hd__or4_2
XTAP_TAPCELL_ROW_8_305 VGND VPWR sky130_fd_sc_hd__tapvpwrvgnd_1
XFILLER_88_334 VGND VGND VPWR VPWR sky130_fd_sc_hd__decap_3
Xplace1774 _6805_/A VGND VGND VPWR VPWR _6842_/A sky130_fd_sc_hd__buf_2
Xplace1796 _3509_/A VGND VGND VPWR VPWR _6183_/C sky130_fd_sc_hd__buf_2
Xplace1785 _3845_/X VGND VGND VPWR VPWR _4338_/B1 sky130_fd_sc_hd__buf_2
X_3559_ _3559_/A1 _6180_/A2 _3455_/A _3652_/C _3536_/D VGND VGND VPWR VPWR _3559_/X
+ sky130_fd_sc_hd__a41o_2
XFILLER_0_249 VGND VGND VPWR VPWR sky130_fd_sc_hd__decap_3
XFILLER_102_133 VGND VGND VPWR VPWR sky130_fd_sc_hd__decap_3
Xhold2421 _6951_/Q VGND VGND VPWR VPWR _4956_/A0 sky130_fd_sc_hd__dlygate4sd3_1
Xhold2410 _7178_/Q VGND VGND VPWR VPWR _5484_/A0 sky130_fd_sc_hd__dlygate4sd3_1
Xhold2454 _7057_/Q VGND VGND VPWR VPWR _5192_/A0 sky130_fd_sc_hd__dlygate4sd3_1
Xhold2443 _7289_/Q VGND VGND VPWR VPWR _5726_/A0 sky130_fd_sc_hd__dlygate4sd3_1
Xhold2432 _6903_/Q VGND VGND VPWR VPWR _4851_/A0 sky130_fd_sc_hd__dlygate4sd3_1
XFILLER_29_445 VGND VGND VPWR VPWR sky130_fd_sc_hd__decap_3
Xhold2498 _7273_/Q VGND VGND VPWR VPWR _5692_/A0 sky130_fd_sc_hd__dlygate4sd3_1
Xhold2487 _6867_/Q VGND VGND VPWR VPWR _4753_/A0 sky130_fd_sc_hd__dlygate4sd3_1
Xhold2476 _6970_/Q VGND VGND VPWR VPWR _5003_/A0 sky130_fd_sc_hd__dlygate4sd3_1
Xhold2465 _7110_/Q VGND VGND VPWR VPWR _5336_/A0 sky130_fd_sc_hd__dlygate4sd3_1
XFILLER_56_253 VGND VGND VPWR VPWR sky130_fd_sc_hd__fill_1
XFILLER_56_264 VGND VGND VPWR VPWR sky130_fd_sc_hd__decap_3
XFILLER_56_275 VGND VGND VPWR VPWR sky130_fd_sc_hd__decap_3
XFILLER_71_223 VGND VGND VPWR VPWR sky130_fd_sc_hd__fill_1
XFILLER_24_150 VGND VGND VPWR VPWR sky130_fd_sc_hd__fill_2
XFILLER_24_183 VGND VGND VPWR VPWR sky130_fd_sc_hd__fill_1
XFILLER_24_194 VGND VGND VPWR VPWR sky130_fd_sc_hd__fill_2
XFILLER_52_492 VGND VGND VPWR VPWR sky130_fd_sc_hd__decap_3
XTAP_TAPCELL_ROW_70_958 VGND VPWR sky130_fd_sc_hd__tapvpwrvgnd_1
XFILLER_4_500 VGND VGND VPWR VPWR sky130_fd_sc_hd__decap_3
XFILLER_4_533 VGND VGND VPWR VPWR sky130_fd_sc_hd__fill_1
XFILLER_4_577 VGND VGND VPWR VPWR sky130_fd_sc_hd__fill_1
XFILLER_35_426 VGND VGND VPWR VPWR sky130_fd_sc_hd__decap_3
XFILLER_47_297 VGND VGND VPWR VPWR sky130_fd_sc_hd__decap_3
XFILLER_62_201 VGND VGND VPWR VPWR sky130_fd_sc_hd__decap_3
XFILLER_75_595 VGND VGND VPWR VPWR sky130_fd_sc_hd__fill_1
XFILLER_62_245 VGND VGND VPWR VPWR sky130_fd_sc_hd__decap_3
XFILLER_90_565 VGND VGND VPWR VPWR sky130_fd_sc_hd__decap_3
XFILLER_15_161 VGND VGND VPWR VPWR sky130_fd_sc_hd__fill_1
XFILLER_62_267 VGND VGND VPWR VPWR sky130_fd_sc_hd__decap_3
XFILLER_15_172 VGND VGND VPWR VPWR sky130_fd_sc_hd__decap_3
XTAP_TAPCELL_ROW_83_1095 VGND VPWR sky130_fd_sc_hd__tapvpwrvgnd_1
X_4600_ _4600_/A0 _5162_/A1 _4665_/S VGND VGND VPWR VPWR _6847_/D sky130_fd_sc_hd__mux2_2
XFILLER_30_175 VGND VGND VPWR VPWR sky130_fd_sc_hd__decap_3
XTAP_TAPCELL_ROW_13_362 VGND VPWR sky130_fd_sc_hd__tapvpwrvgnd_1
X_4531_ _7315_/Q _4531_/B VGND VGND VPWR VPWR _4531_/Y sky130_fd_sc_hd__nor2_2
X_7250_ _7509_/CLK _7250_/D VGND VGND VPWR VPWR _7250_/Q sky130_fd_sc_hd__dfxtp_2
X_4462_ _4460_/A _4460_/C _4460_/B _4564_/A _4461_/X VGND VGND VPWR VPWR _4462_/X
+ sky130_fd_sc_hd__o41a_2
X_6201_ _7605_/Q _6179_/B _6200_/Y _6199_/X _6180_/X VGND VGND VPWR VPWR _6201_/X
+ sky130_fd_sc_hd__o221a_4
X_3413_ _4337_/B _3961_/A VGND VGND VPWR VPWR _3413_/Y sky130_fd_sc_hd__nor2b_2
X_7181_ _7393_/CLK _7181_/D VGND VGND VPWR VPWR _7181_/Q sky130_fd_sc_hd__dfxtp_2
X_4393_ _4396_/A _4393_/B _4393_/C _4393_/D VGND VGND VPWR VPWR _4393_/X sky130_fd_sc_hd__and4b_2
X_6132_ _7168_/Q _6436_/A _6465_/C _6465_/D VGND VGND VPWR VPWR _6132_/X sky130_fd_sc_hd__or4_2
XFILLER_58_529 VGND VGND VPWR VPWR sky130_fd_sc_hd__decap_3
X_6063_ _6061_/X _6062_/X _6505_/B1 _6506_/A2 VGND VGND VPWR VPWR _6063_/X sky130_fd_sc_hd__a211o_2
XFILLER_38_220 VGND VGND VPWR VPWR sky130_fd_sc_hd__decap_3
XFILLER_85_337 VGND VGND VPWR VPWR sky130_fd_sc_hd__fill_2
XFILLER_26_404 VGND VGND VPWR VPWR sky130_fd_sc_hd__decap_3
XFILLER_38_253 VGND VGND VPWR VPWR sky130_fd_sc_hd__decap_3
XFILLER_26_437 VGND VGND VPWR VPWR sky130_fd_sc_hd__decap_3
XFILLER_53_223 VGND VGND VPWR VPWR sky130_fd_sc_hd__fill_1
XFILLER_26_459 VGND VGND VPWR VPWR sky130_fd_sc_hd__decap_3
XFILLER_53_245 VGND VGND VPWR VPWR sky130_fd_sc_hd__fill_2
X_6965_ _7241_/CLK _6965_/D VGND VGND VPWR VPWR _6965_/Q sky130_fd_sc_hd__dfxtp_2
XFILLER_34_470 VGND VGND VPWR VPWR sky130_fd_sc_hd__decap_3
X_5916_ _6511_/A1 _6882_/Q _7274_/Q _6511_/B2 VGND VGND VPWR VPWR _5916_/X sky130_fd_sc_hd__o22a_2
X_6896_ _7280_/CLK _6896_/D VGND VGND VPWR VPWR _6896_/Q sky130_fd_sc_hd__dfxtp_2
XFILLER_21_142 VGND VGND VPWR VPWR sky130_fd_sc_hd__fill_1
XFILLER_42_38 VGND VGND VPWR VPWR sky130_fd_sc_hd__fill_1
X_5847_ _4473_/C _4340_/B _5847_/A3 _3468_/X VGND VGND VPWR VPWR _5847_/X sky130_fd_sc_hd__a31o_2
XFILLER_21_164 VGND VGND VPWR VPWR sky130_fd_sc_hd__decap_3
XFILLER_21_175 VGND VGND VPWR VPWR sky130_fd_sc_hd__decap_3
X_5778_ _5778_/A1 _5764_/Y _4778_/A _5941_/A3 VGND VGND VPWR VPWR _5778_/X sky130_fd_sc_hd__a211o_2
XFILLER_5_308 VGND VGND VPWR VPWR sky130_fd_sc_hd__decap_3
X_7517_ clkload2/A _7517_/D place2028/X VGND VGND VPWR VPWR _7517_/Q sky130_fd_sc_hd__dfrtp_2
X_7448_ _7509_/CLK _7448_/D place2036/X VGND VGND VPWR VPWR _7448_/Q sky130_fd_sc_hd__dfrtp_2
Xplace1560 _5376_/A1 VGND VGND VPWR VPWR _5681_/A1 sky130_fd_sc_hd__buf_2
Xplace1571 _3753_/A4 VGND VGND VPWR VPWR _4225_/A3 sky130_fd_sc_hd__buf_2
X_7379_ _7514_/CLK _7379_/D place2041/X VGND VGND VPWR VPWR _7379_/Q sky130_fd_sc_hd__dfrtp_2
XFILLER_103_431 VGND VGND VPWR VPWR sky130_fd_sc_hd__fill_1
Xplace1582 _3963_/X VGND VGND VPWR VPWR _4595_/B1 sky130_fd_sc_hd__buf_2
Xplace1593 _3853_/X VGND VGND VPWR VPWR _4663_/B1 sky130_fd_sc_hd__buf_2
XFILLER_67_57 VGND VGND VPWR VPWR sky130_fd_sc_hd__decap_3
XFILLER_29_220 VGND VGND VPWR VPWR sky130_fd_sc_hd__decap_3
XFILLER_29_264 VGND VGND VPWR VPWR sky130_fd_sc_hd__decap_3
XTAP_TAPCELL_ROW_47_719 VGND VPWR sky130_fd_sc_hd__tapvpwrvgnd_1
XFILLER_44_212 VGND VGND VPWR VPWR sky130_fd_sc_hd__decap_3
XFILLER_16_50 VGND VGND VPWR VPWR sky130_fd_sc_hd__decap_3
XTAP_TAPCELL_ROW_55_796 VGND VPWR sky130_fd_sc_hd__tapvpwrvgnd_1
XFILLER_12_197 VGND VGND VPWR VPWR sky130_fd_sc_hd__decap_3
XFILLER_32_71 VGND VGND VPWR VPWR sky130_fd_sc_hd__decap_3
XFILLER_32_82 VGND VGND VPWR VPWR sky130_fd_sc_hd__fill_2
XTAP_TAPCELL_ROW_10_332 VGND VPWR sky130_fd_sc_hd__tapvpwrvgnd_1
XFILLER_4_330 VGND VGND VPWR VPWR sky130_fd_sc_hd__fill_1
XFILLER_4_352 VGND VGND VPWR VPWR sky130_fd_sc_hd__decap_3
XFILLER_67_337 VGND VGND VPWR VPWR sky130_fd_sc_hd__decap_3
XFILLER_48_595 VGND VGND VPWR VPWR sky130_fd_sc_hd__fill_2
XTAP_TAPCELL_ROW_85_1113 VGND VPWR sky130_fd_sc_hd__tapvpwrvgnd_1
XTAP_TAPCELL_ROW_18_410 VGND VPWR sky130_fd_sc_hd__tapvpwrvgnd_1
XFILLER_35_278 VGND VGND VPWR VPWR sky130_fd_sc_hd__fill_2
X_6750_ _6144_/X _6750_/A1 _6765_/S VGND VGND VPWR VPWR _7535_/D sky130_fd_sc_hd__mux2_4
X_5701_ _5701_/A0 _5701_/A1 _5711_/S VGND VGND VPWR VPWR _7277_/D sky130_fd_sc_hd__mux2_2
X_3962_ _4003_/A1 _4003_/A2 _7360_/Q _4312_/B _7552_/Q VGND VGND VPWR VPWR _3962_/X
+ sky130_fd_sc_hd__a32o_2
X_6681_ _6681_/A0 _6128_/X _6687_/S VGND VGND VPWR VPWR _7502_/D sky130_fd_sc_hd__mux2_2
X_3893_ _7526_/Q _3893_/A2 _3865_/B _7494_/Q VGND VGND VPWR VPWR _3894_/C sky130_fd_sc_hd__a22oi_2
XFILLER_31_495 VGND VGND VPWR VPWR sky130_fd_sc_hd__decap_3
X_7302_ clkload5/A _7302_/D place2060/X VGND VGND VPWR VPWR _7302_/Q sky130_fd_sc_hd__dfrtp_2
X_4514_ _7312_/Q _4514_/B VGND VGND VPWR VPWR _4515_/C sky130_fd_sc_hd__nor2_2
XTAP_TAPCELL_ROW_96_1231 VGND VPWR sky130_fd_sc_hd__tapvpwrvgnd_1
X_5494_ _5494_/A0 _5677_/A1 _5513_/S VGND VGND VPWR VPWR _7182_/D sky130_fd_sc_hd__mux2_2
X_7233_ _7289_/CLK _7233_/D VGND VGND VPWR VPWR _7233_/Q sky130_fd_sc_hd__dfxtp_2
X_4445_ _4472_/A _4443_/X _4444_/X VGND VGND VPWR VPWR _4445_/Y sky130_fd_sc_hd__a21oi_2
X_7164_ _7276_/CLK _7164_/D VGND VGND VPWR VPWR _7164_/Q sky130_fd_sc_hd__dfxtp_2
X_4376_ _4416_/A _4375_/C _4375_/A VGND VGND VPWR VPWR _4376_/Y sky130_fd_sc_hd__a21oi_2
XFILLER_58_315 VGND VGND VPWR VPWR sky130_fd_sc_hd__decap_3
X_6115_ _6154_/A1 _7223_/Q _7139_/Q _6154_/B2 VGND VGND VPWR VPWR _6115_/X sky130_fd_sc_hd__o22a_2
X_7095_ _7291_/CLK _7095_/D VGND VGND VPWR VPWR _7095_/Q sky130_fd_sc_hd__dfxtp_2
X_6046_ _6480_/B2 _7048_/Q _6852_/Q _6510_/B2 VGND VGND VPWR VPWR _6046_/X sky130_fd_sc_hd__o22a_2
XFILLER_39_584 VGND VGND VPWR VPWR sky130_fd_sc_hd__decap_3
XFILLER_66_381 VGND VGND VPWR VPWR sky130_fd_sc_hd__fill_1
XFILLER_53_48 VGND VGND VPWR VPWR sky130_fd_sc_hd__decap_3
X_6948_ _7235_/CLK _6948_/D VGND VGND VPWR VPWR _6948_/Q sky130_fd_sc_hd__dfxtp_2
X_6879_ _7273_/CLK _6879_/D VGND VGND VPWR VPWR _6879_/Q sky130_fd_sc_hd__dfxtp_2
XTAP_TAPCELL_ROW_52_766 VGND VPWR sky130_fd_sc_hd__tapvpwrvgnd_1
XFILLER_22_473 VGND VGND VPWR VPWR sky130_fd_sc_hd__decap_3
XFILLER_22_495 VGND VGND VPWR VPWR sky130_fd_sc_hd__decap_3
XTAP_TAPCELL_ROW_24_479 VGND VPWR sky130_fd_sc_hd__tapvpwrvgnd_1
XTAP_TAPCELL_ROW_101_1279 VGND VPWR sky130_fd_sc_hd__tapvpwrvgnd_1
XFILLER_5_116 VGND VGND VPWR VPWR sky130_fd_sc_hd__decap_3
XFILLER_5_138 VGND VGND VPWR VPWR sky130_fd_sc_hd__decap_3
XFILLER_103_250 VGND VGND VPWR VPWR sky130_fd_sc_hd__fill_2
Xplace1390 _4232_/X VGND VGND VPWR VPWR _4233_/B sky130_fd_sc_hd__buf_2
XFILLER_49_337 VGND VGND VPWR VPWR sky130_fd_sc_hd__decap_3
XFILLER_17_212 VGND VGND VPWR VPWR sky130_fd_sc_hd__decap_3
XFILLER_45_521 VGND VGND VPWR VPWR sky130_fd_sc_hd__decap_3
XFILLER_64_318 VGND VGND VPWR VPWR sky130_fd_sc_hd__fill_2
XFILLER_76_178 VGND VGND VPWR VPWR sky130_fd_sc_hd__fill_2
XFILLER_94_66 VGND VGND VPWR VPWR sky130_fd_sc_hd__decap_3
XFILLER_32_204 VGND VGND VPWR VPWR sky130_fd_sc_hd__decap_3
XFILLER_72_373 VGND VGND VPWR VPWR sky130_fd_sc_hd__decap_3
XFILLER_32_259 VGND VGND VPWR VPWR sky130_fd_sc_hd__decap_3
XFILLER_60_579 VGND VGND VPWR VPWR sky130_fd_sc_hd__fill_1
XFILLER_43_92 VGND VGND VPWR VPWR sky130_fd_sc_hd__decap_3
XTAP_TAPCELL_ROW_80_1065 VGND VPWR sky130_fd_sc_hd__tapvpwrvgnd_1
XFILLER_9_499 VGND VGND VPWR VPWR sky130_fd_sc_hd__decap_3
XFILLER_4_193 VGND VGND VPWR VPWR sky130_fd_sc_hd__decap_3
XFILLER_99_259 VGND VGND VPWR VPWR sky130_fd_sc_hd__decap_3
X_4230_ _6180_/A1 _4278_/A2 _4510_/C _6163_/B _6163_/C VGND VGND VPWR VPWR _4230_/X
+ sky130_fd_sc_hd__o311a_2
XFILLER_4_97 VGND VGND VPWR VPWR sky130_fd_sc_hd__decap_3
XTAP_TAPCELL_ROW_91_1183 VGND VPWR sky130_fd_sc_hd__tapvpwrvgnd_1
XFILLER_36_543 VGND VGND VPWR VPWR sky130_fd_sc_hd__fill_2
XFILLER_63_340 VGND VGND VPWR VPWR sky130_fd_sc_hd__decap_3
XFILLER_82_137 VGND VGND VPWR VPWR sky130_fd_sc_hd__decap_3
XFILLER_63_373 VGND VGND VPWR VPWR sky130_fd_sc_hd__decap_3
X_6802_ _6840_/A _6802_/B VGND VGND VPWR VPWR _7559_/D sky130_fd_sc_hd__and2_2
XFILLER_23_237 VGND VGND VPWR VPWR sky130_fd_sc_hd__decap_3
X_4994_ _4994_/A0 _5694_/A1 _4994_/S VGND VGND VPWR VPWR _6966_/D sky130_fd_sc_hd__mux2_2
XFILLER_23_18 VGND VGND VPWR VPWR sky130_fd_sc_hd__decap_3
X_6733_ _6058_/X _6733_/A1 _6775_/S VGND VGND VPWR VPWR _7527_/D sky130_fd_sc_hd__mux2_2
X_3945_ _3945_/A1 _3945_/A2 _3945_/B1 _3945_/C1 _4138_/A1 VGND VGND VPWR VPWR _4017_/D
+ sky130_fd_sc_hd__o2111ai_2
X_6664_ _6664_/A0 _6040_/X _6664_/S VGND VGND VPWR VPWR _7494_/D sky130_fd_sc_hd__mux2_2
XFILLER_31_281 VGND VGND VPWR VPWR sky130_fd_sc_hd__decap_3
X_3876_ _7400_/Q _3914_/A2 _3875_/X VGND VGND VPWR VPWR _3876_/Y sky130_fd_sc_hd__a21oi_2
X_7216_ _7272_/CLK _7216_/D VGND VGND VPWR VPWR _7216_/Q sky130_fd_sc_hd__dfxtp_2
X_4428_ _4473_/A _4428_/B _6302_/B _7302_/Q VGND VGND VPWR VPWR _4428_/X sky130_fd_sc_hd__or4b_2
X_7147_ _7288_/CLK _7147_/D VGND VGND VPWR VPWR _7147_/Q sky130_fd_sc_hd__dfxtp_2
X_4359_ _3561_/B _4357_/X _4358_/X _3992_/X VGND VGND VPWR VPWR _7296_/D sky130_fd_sc_hd__a31o_2
X_7078_ _7274_/CLK _7078_/D VGND VGND VPWR VPWR _7078_/Q sky130_fd_sc_hd__dfxtp_2
XFILLER_58_178 VGND VGND VPWR VPWR sky130_fd_sc_hd__decap_3
XFILLER_58_189 VGND VGND VPWR VPWR sky130_fd_sc_hd__decap_3
X_6029_ _6025_/X _6027_/X _6505_/B1 _6506_/A2 VGND VGND VPWR VPWR _6029_/X sky130_fd_sc_hd__a211o_2
XTAP_TAPCELL_ROW_57_825 VGND VPWR sky130_fd_sc_hd__tapvpwrvgnd_1
XTAP_TAPCELL_ROW_29_527 VGND VPWR sky130_fd_sc_hd__tapvpwrvgnd_1
XFILLER_27_576 VGND VGND VPWR VPWR sky130_fd_sc_hd__fill_2
XFILLER_42_513 VGND VGND VPWR VPWR sky130_fd_sc_hd__decap_3
XTAP_TAPCELL_ROW_103_1308 VGND VPWR sky130_fd_sc_hd__tapvpwrvgnd_1
XTAP_TAPCELL_ROW_103_1319 VGND VPWR sky130_fd_sc_hd__tapvpwrvgnd_1
XFILLER_14_248 VGND VGND VPWR VPWR sky130_fd_sc_hd__decap_3
XFILLER_10_421 VGND VGND VPWR VPWR sky130_fd_sc_hd__fill_2
XFILLER_6_414 VGND VGND VPWR VPWR sky130_fd_sc_hd__decap_3
XFILLER_89_55 VGND VGND VPWR VPWR sky130_fd_sc_hd__fill_1
XFILLER_1_130 VGND VGND VPWR VPWR sky130_fd_sc_hd__decap_3
XFILLER_49_123 VGND VGND VPWR VPWR sky130_fd_sc_hd__fill_2
XFILLER_89_281 VGND VGND VPWR VPWR sky130_fd_sc_hd__decap_3
XFILLER_37_329 VGND VGND VPWR VPWR sky130_fd_sc_hd__decap_3
XFILLER_38_81 VGND VGND VPWR VPWR sky130_fd_sc_hd__decap_3
XFILLER_64_137 VGND VGND VPWR VPWR sky130_fd_sc_hd__decap_3
XFILLER_18_576 VGND VGND VPWR VPWR sky130_fd_sc_hd__fill_2
XFILLER_18_587 VGND VGND VPWR VPWR sky130_fd_sc_hd__fill_1
XFILLER_45_351 VGND VGND VPWR VPWR sky130_fd_sc_hd__decap_3
XFILLER_33_546 VGND VGND VPWR VPWR sky130_fd_sc_hd__decap_3
XFILLER_54_80 VGND VGND VPWR VPWR sky130_fd_sc_hd__decap_3
XFILLER_60_365 VGND VGND VPWR VPWR sky130_fd_sc_hd__fill_1
XFILLER_20_218 VGND VGND VPWR VPWR sky130_fd_sc_hd__decap_3
X_3730_ _3738_/A _3738_/B _3719_/Y _3727_/Y _3729_/Y VGND VGND VPWR VPWR _4283_/C
+ sky130_fd_sc_hd__o41a_2
XFILLER_62_3 VGND VGND VPWR VPWR sky130_fd_sc_hd__decap_3
Xclkload33 _7407_/CLK VGND VGND VPWR VPWR clkload33/Y sky130_fd_sc_hd__bufinv_16
Xclkload22 _7266_/CLK VGND VGND VPWR VPWR clkload22/X sky130_fd_sc_hd__clkbuf_4
Xclkload11 _7493_/CLK VGND VGND VPWR VPWR clkload11/Y sky130_fd_sc_hd__bufinv_16
X_6380_ _6681_/A0 _6411_/A2 _6388_/A3 _6407_/S _6380_/B2 VGND VGND VPWR VPWR _7406_/D
+ sky130_fd_sc_hd__a32o_2
X_5400_ _5400_/A0 _4693_/X _5410_/S VGND VGND VPWR VPWR _7139_/D sky130_fd_sc_hd__mux2_2
X_3592_ _7322_/Q _3957_/B _3592_/B1 _4313_/B _4395_/B1 VGND VGND VPWR VPWR _3592_/Y
+ sky130_fd_sc_hd__a2111oi_2
X_5331_ _5331_/A0 _4670_/X _5331_/S VGND VGND VPWR VPWR _7108_/D sky130_fd_sc_hd__mux2_2
XTAP_TAPCELL_ROW_93_1201 VGND VPWR sky130_fd_sc_hd__tapvpwrvgnd_1
X_7001_ _7279_/CLK _7001_/D VGND VGND VPWR VPWR _7001_/Q sky130_fd_sc_hd__dfxtp_2
X_5262_ _5262_/A0 _5336_/A1 _5293_/S VGND VGND VPWR VPWR _7082_/D sky130_fd_sc_hd__mux2_2
XFILLER_68_421 VGND VGND VPWR VPWR sky130_fd_sc_hd__fill_1
Xhold2806 _7256_/Q VGND VGND VPWR VPWR _5654_/A0 sky130_fd_sc_hd__dlygate4sd3_1
Xhold2817 _7275_/Q VGND VGND VPWR VPWR _5696_/A0 sky130_fd_sc_hd__dlygate4sd3_1
Xhold2828 _7334_/Q VGND VGND VPWR VPWR _6254_/B sky130_fd_sc_hd__dlygate4sd3_1
Xhold2839 _7325_/Q VGND VGND VPWR VPWR _6235_/A sky130_fd_sc_hd__dlygate4sd3_1
X_4213_ _4206_/A _4202_/B _4212_/Y _4201_/B VGND VGND VPWR VPWR _4213_/X sky130_fd_sc_hd__o31a_2
X_4144_ _4144_/A _4144_/B _4144_/C VGND VGND VPWR VPWR _4144_/X sky130_fd_sc_hd__and3_2
XFILLER_18_18 VGND VGND VPWR VPWR sky130_fd_sc_hd__fill_1
XFILLER_18_29 VGND VGND VPWR VPWR sky130_fd_sc_hd__fill_1
XFILLER_28_318 VGND VGND VPWR VPWR sky130_fd_sc_hd__decap_3
XFILLER_55_126 VGND VGND VPWR VPWR sky130_fd_sc_hd__decap_3
X_4075_ _4533_/B _4533_/C VGND VGND VPWR VPWR _7605_/D sky130_fd_sc_hd__nor2_2
XFILLER_36_351 VGND VGND VPWR VPWR sky130_fd_sc_hd__decap_3
XFILLER_36_395 VGND VGND VPWR VPWR sky130_fd_sc_hd__fill_2
XFILLER_51_321 VGND VGND VPWR VPWR sky130_fd_sc_hd__decap_3
XFILLER_24_557 VGND VGND VPWR VPWR sky130_fd_sc_hd__decap_3
XFILLER_24_568 VGND VGND VPWR VPWR sky130_fd_sc_hd__decap_3
X_6716_ _5860_/X _7519_/Q _6769_/S VGND VGND VPWR VPWR _7519_/D sky130_fd_sc_hd__mux2_2
X_4977_ _4977_/A0 _5099_/A1 _4998_/S VGND VGND VPWR VPWR _6958_/D sky130_fd_sc_hd__mux2_2
XTAP_TAPCELL_ROW_62_872 VGND VPWR sky130_fd_sc_hd__tapvpwrvgnd_1
XTAP_TAPCELL_ROW_34_585 VGND VPWR sky130_fd_sc_hd__tapvpwrvgnd_1
Xclkload5 clkload5/A VGND VGND VPWR VPWR clkload5/Y sky130_fd_sc_hd__bufinv_16
X_3928_ _3928_/A _3928_/B VGND VGND VPWR VPWR _3928_/Y sky130_fd_sc_hd__nand2_2
X_6647_ _7486_/Q _5857_/X _6653_/S VGND VGND VPWR VPWR _7486_/D sky130_fd_sc_hd__mux2_2
X_3859_ _3859_/A _3859_/B VGND VGND VPWR VPWR _3859_/Y sky130_fd_sc_hd__nand2_2
XFILLER_19_329 VGND VGND VPWR VPWR sky130_fd_sc_hd__decap_3
XFILLER_74_424 VGND VGND VPWR VPWR sky130_fd_sc_hd__fill_2
XTAP_TAPCELL_ROW_6_288 VGND VPWR sky130_fd_sc_hd__tapvpwrvgnd_1
XFILLER_46_126 VGND VGND VPWR VPWR sky130_fd_sc_hd__decap_3
XFILLER_75_57 VGND VGND VPWR VPWR sky130_fd_sc_hd__decap_3
XFILLER_15_579 VGND VGND VPWR VPWR sky130_fd_sc_hd__fill_1
XFILLER_54_192 VGND VGND VPWR VPWR sky130_fd_sc_hd__decap_3
XFILLER_42_365 VGND VGND VPWR VPWR sky130_fd_sc_hd__decap_3
XFILLER_24_72 VGND VGND VPWR VPWR sky130_fd_sc_hd__decap_3
XFILLER_24_83 VGND VGND VPWR VPWR sky130_fd_sc_hd__fill_1
XFILLER_24_94 VGND VGND VPWR VPWR sky130_fd_sc_hd__decap_3
XFILLER_10_251 VGND VGND VPWR VPWR sky130_fd_sc_hd__fill_1
XFILLER_10_262 VGND VGND VPWR VPWR sky130_fd_sc_hd__decap_3
XFILLER_27_6 VGND VGND VPWR VPWR sky130_fd_sc_hd__fill_2
XFILLER_49_91 VGND VGND VPWR VPWR sky130_fd_sc_hd__decap_3
XFILLER_18_340 VGND VGND VPWR VPWR sky130_fd_sc_hd__fill_1
XFILLER_18_362 VGND VGND VPWR VPWR sky130_fd_sc_hd__fill_2
XFILLER_52_107 VGND VGND VPWR VPWR sky130_fd_sc_hd__decap_3
X_4900_ _4900_/A0 _5728_/A1 _4900_/S VGND VGND VPWR VPWR _6926_/D sky130_fd_sc_hd__mux2_2
XFILLER_21_505 VGND VGND VPWR VPWR sky130_fd_sc_hd__decap_3
XFILLER_21_538 VGND VGND VPWR VPWR sky130_fd_sc_hd__fill_1
XFILLER_33_376 VGND VGND VPWR VPWR sky130_fd_sc_hd__decap_3
XFILLER_21_549 VGND VGND VPWR VPWR sky130_fd_sc_hd__decap_3
X_7550_ _7581_/CLK _7550_/D place2022/X VGND VGND VPWR VPWR _7550_/Q sky130_fd_sc_hd__dfrtp_2
X_4762_ _4763_/A2 _4734_/X _4761_/Y _4773_/B2 _6513_/B1 VGND VGND VPWR VPWR _4762_/X
+ sky130_fd_sc_hd__o221a_2
XTAP_TAPCELL_ROW_31_544 VGND VPWR sky130_fd_sc_hd__tapvpwrvgnd_1
X_7481_ _7507_/CLK _7481_/D place2037/X VGND VGND VPWR VPWR _7481_/Q sky130_fd_sc_hd__dfrtp_2
X_6501_ _6501_/A1 _7046_/Q _6850_/Q _6507_/B2 VGND VGND VPWR VPWR _6501_/X sky130_fd_sc_hd__o22a_2
X_4693_ _6330_/B2 _4707_/A2 _4707_/A3 _4692_/X VGND VGND VPWR VPWR _4693_/X sky130_fd_sc_hd__a31o_2
X_3713_ _3738_/A _3707_/Y _3712_/Y VGND VGND VPWR VPWR _4281_/B sky130_fd_sc_hd__o21a_2
X_6432_ _6477_/A2 _6873_/Q _7265_/Q _6476_/A1 VGND VGND VPWR VPWR _6432_/X sky130_fd_sc_hd__o22a_2
Xplace1912 _3442_/B VGND VGND VPWR VPWR _3459_/A sky130_fd_sc_hd__buf_4
Xplace1901 _3433_/Y VGND VGND VPWR VPWR _3463_/B sky130_fd_sc_hd__buf_6
Xplace1945 _7378_/Q VGND VGND VPWR VPWR _6334_/B2 sky130_fd_sc_hd__buf_2
Xplace1934 _7441_/Q VGND VGND VPWR VPWR _6541_/A0 sky130_fd_sc_hd__buf_2
Xplace1923 _3460_/A VGND VGND VPWR VPWR _6231_/A2 sky130_fd_sc_hd__buf_4
X_6363_ _6363_/A1 _6363_/A2 _6363_/A3 _6363_/B1 _7396_/Q VGND VGND VPWR VPWR _7396_/D
+ sky130_fd_sc_hd__a32o_2
X_3575_ _3575_/A1 _4437_/A2 _3574_/Y VGND VGND VPWR VPWR _3576_/B sky130_fd_sc_hd__a21oi_4
Xplace1978 _3474_/A VGND VGND VPWR VPWR _3843_/B sky130_fd_sc_hd__buf_2
Xplace1967 _7311_/Q VGND VGND VPWR VPWR _4067_/A sky130_fd_sc_hd__buf_2
Xplace1956 _7361_/Q VGND VGND VPWR VPWR _6311_/B2 sky130_fd_sc_hd__buf_2
X_6294_ _6294_/A _6294_/B VGND VGND VPWR VPWR _7353_/D sky130_fd_sc_hd__and2_2
X_5314_ _5314_/A0 _5376_/A1 _5331_/S VGND VGND VPWR VPWR _7100_/D sky130_fd_sc_hd__mux2_2
Xplace1989 _7294_/Q VGND VGND VPWR VPWR _3444_/C sky130_fd_sc_hd__buf_6
Xhold2603 _7209_/Q VGND VGND VPWR VPWR _5553_/A0 sky130_fd_sc_hd__dlygate4sd3_1
Xhold2636 _6913_/Q VGND VGND VPWR VPWR _4873_/A0 sky130_fd_sc_hd__dlygate4sd3_1
Xhold2647 _7087_/Q VGND VGND VPWR VPWR _5277_/A0 sky130_fd_sc_hd__dlygate4sd3_1
Xhold2625 _7218_/Q VGND VGND VPWR VPWR _5572_/A0 sky130_fd_sc_hd__dlygate4sd3_1
Xhold2614 _6982_/Q VGND VGND VPWR VPWR _5028_/A0 sky130_fd_sc_hd__dlygate4sd3_1
XFILLER_68_262 VGND VGND VPWR VPWR sky130_fd_sc_hd__decap_3
Xhold2658 _6950_/Q VGND VGND VPWR VPWR _4954_/A0 sky130_fd_sc_hd__dlygate4sd3_1
Xhold2669 _7167_/Q VGND VGND VPWR VPWR _5461_/A0 sky130_fd_sc_hd__dlygate4sd3_1
XFILLER_56_424 VGND VGND VPWR VPWR sky130_fd_sc_hd__decap_3
XTAP_TAPCELL_ROW_67_931 VGND VPWR sky130_fd_sc_hd__tapvpwrvgnd_1
XTAP_TAPCELL_ROW_3_258 VGND VPWR sky130_fd_sc_hd__tapvpwrvgnd_1
XTAP_TAPCELL_ROW_39_633 VGND VPWR sky130_fd_sc_hd__tapvpwrvgnd_1
XFILLER_43_107 VGND VGND VPWR VPWR sky130_fd_sc_hd__decap_3
X_4058_ _7309_/Q _4059_/C _7310_/Q VGND VGND VPWR VPWR _4499_/B sky130_fd_sc_hd__a21oi_2
XFILLER_83_298 VGND VGND VPWR VPWR sky130_fd_sc_hd__fill_1
XFILLER_36_181 VGND VGND VPWR VPWR sky130_fd_sc_hd__decap_3
XFILLER_20_560 VGND VGND VPWR VPWR sky130_fd_sc_hd__decap_3
XFILLER_3_225 VGND VGND VPWR VPWR sky130_fd_sc_hd__decap_3
XFILLER_79_505 VGND VGND VPWR VPWR sky130_fd_sc_hd__decap_3
XFILLER_10_85 VGND VGND VPWR VPWR sky130_fd_sc_hd__decap_3
XFILLER_19_50 VGND VGND VPWR VPWR sky130_fd_sc_hd__decap_3
XFILLER_47_446 VGND VGND VPWR VPWR sky130_fd_sc_hd__fill_2
XFILLER_59_295 VGND VGND VPWR VPWR sky130_fd_sc_hd__fill_2
XFILLER_15_321 VGND VGND VPWR VPWR sky130_fd_sc_hd__decap_3
XFILLER_30_302 VGND VGND VPWR VPWR sky130_fd_sc_hd__fill_2
XFILLER_35_71 VGND VGND VPWR VPWR sky130_fd_sc_hd__decap_3
XFILLER_96_9 VGND VGND VPWR VPWR sky130_fd_sc_hd__fill_1
XTAP_TAPCELL_ROW_73_989 VGND VPWR sky130_fd_sc_hd__tapvpwrvgnd_1
XFILLER_30_324 VGND VGND VPWR VPWR sky130_fd_sc_hd__decap_3
XFILLER_42_195 VGND VGND VPWR VPWR sky130_fd_sc_hd__fill_1
XFILLER_30_357 VGND VGND VPWR VPWR sky130_fd_sc_hd__decap_3
XFILLER_30_368 VGND VGND VPWR VPWR sky130_fd_sc_hd__decap_3
XFILLER_7_586 VGND VGND VPWR VPWR sky130_fd_sc_hd__decap_3
Xplace1208 _4838_/S VGND VGND VPWR VPWR _4840_/S sky130_fd_sc_hd__buf_2
Xplace1219 _4170_/X VGND VGND VPWR VPWR _4176_/A2 sky130_fd_sc_hd__buf_2
XPHY_EDGE_ROW_29_Left_133 VGND VGND VPWR VPWR sky130_fd_sc_hd__decap_3
X_5030_ _5030_/A0 _5608_/A1 _5030_/S VGND VGND VPWR VPWR _6983_/D sky130_fd_sc_hd__mux2_2
XFILLER_65_221 VGND VGND VPWR VPWR sky130_fd_sc_hd__decap_3
XFILLER_65_232 VGND VGND VPWR VPWR sky130_fd_sc_hd__fill_1
X_6981_ _7287_/CLK _6981_/D VGND VGND VPWR VPWR _6981_/Q sky130_fd_sc_hd__dfxtp_2
XTAP_TAPCELL_ROW_88_1144 VGND VPWR sky130_fd_sc_hd__tapvpwrvgnd_1
XTAP_TAPCELL_ROW_0_217 VGND VPWR sky130_fd_sc_hd__tapvpwrvgnd_1
XFILLER_25_129 VGND VGND VPWR VPWR sky130_fd_sc_hd__decap_3
XFILLER_53_438 VGND VGND VPWR VPWR sky130_fd_sc_hd__fill_1
X_5932_ _7182_/Q _6477_/A2 _7210_/Q _6473_/A1 VGND VGND VPWR VPWR _5932_/X sky130_fd_sc_hd__o22a_2
XTAP_TAPCELL_ROW_36_603 VGND VPWR sky130_fd_sc_hd__tapvpwrvgnd_1
XTAP_TAPCELL_ROW_0_228 VGND VPWR sky130_fd_sc_hd__tapvpwrvgnd_1
XFILLER_53_449 VGND VGND VPWR VPWR sky130_fd_sc_hd__decap_3
Xclkbuf_leaf_45_clk clkbuf_leaf_0_clk/A VGND VGND VPWR VPWR clkload6/A sky130_fd_sc_hd__clkbuf_16
XPHY_EDGE_ROW_38_Left_142 VGND VGND VPWR VPWR sky130_fd_sc_hd__decap_3
X_5863_ _7584_/Q _6565_/B _5862_/X VGND VGND VPWR VPWR _5863_/X sky130_fd_sc_hd__o21a_2
XFILLER_21_335 VGND VGND VPWR VPWR sky130_fd_sc_hd__fill_1
X_7602_ _7606_/CLK _7602_/D place2051/X VGND VGND VPWR VPWR _7602_/Q sky130_fd_sc_hd__dfrtp_2
XTAP_TAPCELL_ROW_44_680 VGND VPWR sky130_fd_sc_hd__tapvpwrvgnd_1
XTAP_TAPCELL_ROW_16_393 VGND VPWR sky130_fd_sc_hd__tapvpwrvgnd_1
XFILLER_21_357 VGND VGND VPWR VPWR sky130_fd_sc_hd__decap_3
X_7533_ clkload3/A _7533_/D place2058/X VGND VGND VPWR VPWR _7533_/Q sky130_fd_sc_hd__dfrtp_2
X_4745_ _4757_/A1 _4745_/A2 _4744_/X VGND VGND VPWR VPWR _4745_/Y sky130_fd_sc_hd__a21oi_2
XTAP_TAPCELL_ROW_99_1262 VGND VPWR sky130_fd_sc_hd__tapvpwrvgnd_1
X_7464_ clkload5/A _7464_/D place2064/X VGND VGND VPWR VPWR _7464_/Q sky130_fd_sc_hd__dfrtp_2
X_4676_ _4676_/A0 _4737_/B1 _5979_/A VGND VGND VPWR VPWR _4676_/X sky130_fd_sc_hd__mux2_2
Xplace1720 _3535_/Y VGND VGND VPWR VPWR place1720/X sky130_fd_sc_hd__buf_6
X_7395_ _7490_/CLK _7395_/D place2024/X VGND VGND VPWR VPWR _7395_/Q sky130_fd_sc_hd__dfrtp_2
Xplace1731 _3860_/A2 VGND VGND VPWR VPWR _4184_/A sky130_fd_sc_hd__buf_2
Xplace1742 _3548_/B1 VGND VGND VPWR VPWR _3936_/B1 sky130_fd_sc_hd__buf_2
Xplace1753 _3863_/A2 VGND VGND VPWR VPWR _6664_/S sky130_fd_sc_hd__buf_2
X_6346_ _7419_/Q _6346_/A2 _6346_/A3 _6304_/X _6346_/B2 VGND VGND VPWR VPWR _6346_/X
+ sky130_fd_sc_hd__a32o_2
X_3558_ _6363_/A2 _3578_/D1 _3555_/Y _7485_/Q _3557_/Y VGND VGND VPWR VPWR _3563_/A
+ sky130_fd_sc_hd__a41oi_2
XTAP_TAPCELL_ROW_8_306 VGND VPWR sky130_fd_sc_hd__tapvpwrvgnd_1
XFILLER_0_228 VGND VGND VPWR VPWR sky130_fd_sc_hd__fill_2
XPHY_EDGE_ROW_47_Left_151 VGND VGND VPWR VPWR sky130_fd_sc_hd__decap_3
Xplace1764 _3855_/A2 VGND VGND VPWR VPWR _6706_/S sky130_fd_sc_hd__buf_6
Xplace1775 _6805_/A VGND VGND VPWR VPWR _6089_/A1 sky130_fd_sc_hd__buf_2
Xplace1797 _3509_/C VGND VGND VPWR VPWR _3581_/B sky130_fd_sc_hd__buf_2
Xplace1786 _3571_/Y VGND VGND VPWR VPWR _3572_/A3 sky130_fd_sc_hd__buf_2
Xhold2422 _7061_/Q VGND VGND VPWR VPWR _5201_/A0 sky130_fd_sc_hd__dlygate4sd3_1
Xhold2411 _7285_/Q VGND VGND VPWR VPWR _5718_/A0 sky130_fd_sc_hd__dlygate4sd3_1
Xhold2400 _7229_/Q VGND VGND VPWR VPWR _5596_/A0 sky130_fd_sc_hd__dlygate4sd3_1
X_6277_ _6298_/A _6277_/B VGND VGND VPWR VPWR _7345_/D sky130_fd_sc_hd__and2_2
X_3489_ _3489_/A1 _3486_/X _3487_/Y _3488_/X VGND VGND VPWR VPWR _3490_/C sky130_fd_sc_hd__a31oi_2
XFILLER_29_402 VGND VGND VPWR VPWR sky130_fd_sc_hd__decap_3
Xhold2455 _7122_/Q VGND VGND VPWR VPWR _5361_/A0 sky130_fd_sc_hd__dlygate4sd3_1
Xhold2444 _7066_/Q VGND VGND VPWR VPWR _5211_/A0 sky130_fd_sc_hd__dlygate4sd3_1
Xhold2433 _7242_/Q VGND VGND VPWR VPWR _5625_/A0 sky130_fd_sc_hd__dlygate4sd3_1
XFILLER_29_424 VGND VGND VPWR VPWR sky130_fd_sc_hd__decap_3
Xhold2488 _7022_/Q VGND VGND VPWR VPWR _5116_/A0 sky130_fd_sc_hd__dlygate4sd3_1
Xhold2477 _7171_/Q VGND VGND VPWR VPWR _5469_/A0 sky130_fd_sc_hd__dlygate4sd3_1
Xhold2466 _6939_/Q VGND VGND VPWR VPWR _4930_/A0 sky130_fd_sc_hd__dlygate4sd3_1
Xhold2499 _7271_/Q VGND VGND VPWR VPWR _5688_/A0 sky130_fd_sc_hd__dlygate4sd3_1
XFILLER_71_246 VGND VGND VPWR VPWR sky130_fd_sc_hd__decap_3
XFILLER_72_25 VGND VGND VPWR VPWR sky130_fd_sc_hd__decap_3
XPHY_EDGE_ROW_56_Left_160 VGND VGND VPWR VPWR sky130_fd_sc_hd__decap_3
Xclkbuf_leaf_36_clk clkbuf_3_2__f_clk/X VGND VGND VPWR VPWR _7542_/CLK sky130_fd_sc_hd__clkbuf_16
XTAP_TAPCELL_ROW_70_959 VGND VPWR sky130_fd_sc_hd__tapvpwrvgnd_1
XFILLER_8_306 VGND VGND VPWR VPWR sky130_fd_sc_hd__fill_2
XFILLER_21_40 VGND VGND VPWR VPWR sky130_fd_sc_hd__fill_2
XFILLER_4_556 VGND VGND VPWR VPWR sky130_fd_sc_hd__fill_2
XFILLER_4_567 VGND VGND VPWR VPWR sky130_fd_sc_hd__fill_1
XFILLER_4_589 VGND VGND VPWR VPWR sky130_fd_sc_hd__decap_3
XFILLER_79_335 VGND VGND VPWR VPWR sky130_fd_sc_hd__fill_1
XFILLER_67_519 VGND VGND VPWR VPWR sky130_fd_sc_hd__fill_1
XFILLER_62_213 VGND VGND VPWR VPWR sky130_fd_sc_hd__decap_3
XFILLER_35_449 VGND VGND VPWR VPWR sky130_fd_sc_hd__decap_3
Xclkbuf_leaf_27_clk clkload1/A VGND VGND VPWR VPWR _7279_/CLK sky130_fd_sc_hd__clkbuf_16
XFILLER_43_471 VGND VGND VPWR VPWR sky130_fd_sc_hd__decap_3
XFILLER_15_184 VGND VGND VPWR VPWR sky130_fd_sc_hd__decap_3
XFILLER_30_121 VGND VGND VPWR VPWR sky130_fd_sc_hd__decap_3
XTAP_TAPCELL_ROW_83_1096 VGND VPWR sky130_fd_sc_hd__tapvpwrvgnd_1
XTAP_TAPCELL_ROW_41_650 VGND VPWR sky130_fd_sc_hd__tapvpwrvgnd_1
XFILLER_30_187 VGND VGND VPWR VPWR sky130_fd_sc_hd__fill_1
XTAP_TAPCELL_ROW_13_363 VGND VPWR sky130_fd_sc_hd__tapvpwrvgnd_1
XFILLER_7_361 VGND VGND VPWR VPWR sky130_fd_sc_hd__fill_1
X_4461_ _4461_/A _4464_/B _4564_/B VGND VGND VPWR VPWR _4461_/X sky130_fd_sc_hd__or3b_2
X_7180_ _7264_/CLK _7180_/D VGND VGND VPWR VPWR _7180_/Q sky130_fd_sc_hd__dfxtp_2
X_6200_ _6200_/A1 _5824_/Y _6200_/A3 _6179_/B VGND VGND VPWR VPWR _6200_/Y sky130_fd_sc_hd__o31ai_2
X_3412_ _3412_/A1 _3409_/A _3443_/C VGND VGND VPWR VPWR _3412_/Y sky130_fd_sc_hd__a21oi_4
X_6131_ _6139_/A1 _7196_/Q _7140_/Q _6138_/B2 VGND VGND VPWR VPWR _6131_/X sky130_fd_sc_hd__o22a_2
X_4392_ _7582_/D _3421_/C _3485_/C _4392_/B1 _4341_/X VGND VGND VPWR VPWR _4392_/X
+ sky130_fd_sc_hd__o311a_2
X_6062_ _6449_/A2 _7189_/Q _7161_/Q _6448_/A1 VGND VGND VPWR VPWR _6062_/X sky130_fd_sc_hd__o22a_2
XFILLER_66_530 VGND VGND VPWR VPWR sky130_fd_sc_hd__fill_2
X_5013_ _5013_/A0 _5591_/A1 _5030_/S VGND VGND VPWR VPWR _6975_/D sky130_fd_sc_hd__mux2_2
XFILLER_38_243 VGND VGND VPWR VPWR sky130_fd_sc_hd__decap_3
XFILLER_66_541 VGND VGND VPWR VPWR sky130_fd_sc_hd__fill_1
XFILLER_26_29 VGND VGND VPWR VPWR sky130_fd_sc_hd__decap_3
XFILLER_38_265 VGND VGND VPWR VPWR sky130_fd_sc_hd__decap_3
XFILLER_53_202 VGND VGND VPWR VPWR sky130_fd_sc_hd__decap_3
XPHY_EDGE_ROW_5_Right_5 VGND VGND VPWR VPWR sky130_fd_sc_hd__decap_3
Xclkbuf_leaf_18_clk clkbuf_leaf_3_clk/A VGND VGND VPWR VPWR _7565_/CLK sky130_fd_sc_hd__clkbuf_16
X_6964_ _7275_/CLK _6964_/D VGND VGND VPWR VPWR _6964_/Q sky130_fd_sc_hd__dfxtp_2
XFILLER_53_268 VGND VGND VPWR VPWR sky130_fd_sc_hd__decap_3
X_6895_ _7287_/CLK _6895_/D VGND VGND VPWR VPWR _6895_/Q sky130_fd_sc_hd__dfxtp_2
X_5915_ _6510_/A1 _6910_/Q _7246_/Q _6510_/B2 VGND VGND VPWR VPWR _5915_/X sky130_fd_sc_hd__o22a_2
X_5846_ _5841_/B _6804_/A1 _5745_/X _5845_/Y VGND VGND VPWR VPWR _5846_/X sky130_fd_sc_hd__o22a_2
X_5777_ _7005_/Q _6204_/A2 _7033_/Q _6455_/A1 VGND VGND VPWR VPWR _5777_/X sky130_fd_sc_hd__o22a_2
X_7516_ clkload2/A _7516_/D place2028/X VGND VGND VPWR VPWR _7516_/Q sky130_fd_sc_hd__dfrtp_2
X_4728_ _4727_/X _4726_/Y _4725_/X _4757_/A1 _6335_/B2 VGND VGND VPWR VPWR _4728_/X
+ sky130_fd_sc_hd__a32o_2
X_7447_ _7507_/CLK _7447_/D place2039/X VGND VGND VPWR VPWR _7447_/Q sky130_fd_sc_hd__dfrtp_2
XFILLER_89_611 VGND VGND VPWR VPWR sky130_fd_sc_hd__fill_1
Xplace1550 _4094_/B VGND VGND VPWR VPWR _3982_/B sky130_fd_sc_hd__buf_2
Xplace1561 _4727_/C VGND VGND VPWR VPWR _5376_/A1 sky130_fd_sc_hd__buf_2
X_7378_ _7514_/CLK _7378_/D place2041/X VGND VGND VPWR VPWR _7378_/Q sky130_fd_sc_hd__dfrtp_2
XFILLER_103_421 VGND VGND VPWR VPWR sky130_fd_sc_hd__fill_1
XFILLER_1_559 VGND VGND VPWR VPWR sky130_fd_sc_hd__fill_1
XFILLER_88_110 VGND VGND VPWR VPWR sky130_fd_sc_hd__fill_1
Xplace1572 _3751_/A VGND VGND VPWR VPWR _3753_/A4 sky130_fd_sc_hd__buf_2
Xplace1583 _3779_/Y VGND VGND VPWR VPWR _3784_/B1 sky130_fd_sc_hd__buf_2
Xplace1594 _3842_/X VGND VGND VPWR VPWR _4188_/A1 sky130_fd_sc_hd__buf_2
X_6329_ _6376_/B2 _6346_/A2 _6346_/A3 _6304_/X _6329_/B2 VGND VGND VPWR VPWR _7373_/D
+ sky130_fd_sc_hd__a32o_2
XFILLER_29_243 VGND VGND VPWR VPWR sky130_fd_sc_hd__decap_3
XFILLER_29_276 VGND VGND VPWR VPWR sky130_fd_sc_hd__decap_3
XFILLER_29_287 VGND VGND VPWR VPWR sky130_fd_sc_hd__decap_3
XFILLER_44_246 VGND VGND VPWR VPWR sky130_fd_sc_hd__decap_3
XFILLER_72_533 VGND VGND VPWR VPWR sky130_fd_sc_hd__fill_2
XFILLER_83_57 VGND VGND VPWR VPWR sky130_fd_sc_hd__fill_2
XFILLER_83_68 VGND VGND VPWR VPWR sky130_fd_sc_hd__decap_3
XFILLER_16_62 VGND VGND VPWR VPWR sky130_fd_sc_hd__decap_3
XFILLER_25_460 VGND VGND VPWR VPWR sky130_fd_sc_hd__decap_3
XFILLER_32_408 VGND VGND VPWR VPWR sky130_fd_sc_hd__decap_3
XFILLER_13_611 VGND VGND VPWR VPWR sky130_fd_sc_hd__fill_1
XTAP_TAPCELL_ROW_55_797 VGND VPWR sky130_fd_sc_hd__tapvpwrvgnd_1
XFILLER_12_121 VGND VGND VPWR VPWR sky130_fd_sc_hd__fill_1
XFILLER_12_132 VGND VGND VPWR VPWR sky130_fd_sc_hd__decap_3
XFILLER_40_430 VGND VGND VPWR VPWR sky130_fd_sc_hd__fill_2
XFILLER_8_103 VGND VGND VPWR VPWR sky130_fd_sc_hd__decap_3
XFILLER_12_187 VGND VGND VPWR VPWR sky130_fd_sc_hd__decap_3
XFILLER_8_136 VGND VGND VPWR VPWR sky130_fd_sc_hd__decap_3
XTAP_TAPCELL_ROW_10_333 VGND VPWR sky130_fd_sc_hd__tapvpwrvgnd_1
XFILLER_32_94 VGND VGND VPWR VPWR sky130_fd_sc_hd__decap_3
XFILLER_0_570 VGND VGND VPWR VPWR sky130_fd_sc_hd__decap_3
XFILLER_35_213 VGND VGND VPWR VPWR sky130_fd_sc_hd__decap_3
XTAP_TAPCELL_ROW_85_1114 VGND VPWR sky130_fd_sc_hd__tapvpwrvgnd_1
XTAP_TAPCELL_ROW_18_411 VGND VPWR sky130_fd_sc_hd__tapvpwrvgnd_1
XFILLER_35_257 VGND VGND VPWR VPWR sky130_fd_sc_hd__decap_3
X_3961_ _3961_/A _4373_/B _3961_/C _4473_/A VGND VGND VPWR VPWR _3961_/X sky130_fd_sc_hd__or4_2
XFILLER_16_471 VGND VGND VPWR VPWR sky130_fd_sc_hd__decap_3
XFILLER_50_216 VGND VGND VPWR VPWR sky130_fd_sc_hd__decap_3
XFILLER_31_441 VGND VGND VPWR VPWR sky130_fd_sc_hd__decap_3
XFILLER_31_452 VGND VGND VPWR VPWR sky130_fd_sc_hd__decap_3
XFILLER_92_3 VGND VGND VPWR VPWR sky130_fd_sc_hd__fill_1
X_3892_ _6319_/B2 _3904_/A2 _3986_/B2 _7462_/Q VGND VGND VPWR VPWR _3894_/B sky130_fd_sc_hd__a22oi_2
XFILLER_31_474 VGND VGND VPWR VPWR sky130_fd_sc_hd__decap_3
X_5631_ _5631_/A0 _5692_/A1 _5637_/S VGND VGND VPWR VPWR _7245_/D sky130_fd_sc_hd__mux2_2
X_5562_ _5562_/A0 _5684_/A1 _5608_/S VGND VGND VPWR VPWR _7213_/D sky130_fd_sc_hd__mux2_2
X_7301_ clkload5/A _7301_/D place2060/X VGND VGND VPWR VPWR _7301_/Q sky130_fd_sc_hd__dfrtp_2
X_4513_ _7310_/Q _4067_/A _4478_/B _4495_/X _4482_/B VGND VGND VPWR VPWR _4514_/B
+ sky130_fd_sc_hd__a41o_2
XTAP_TAPCELL_ROW_96_1232 VGND VPWR sky130_fd_sc_hd__tapvpwrvgnd_1
X_7232_ _7288_/CLK _7232_/D VGND VGND VPWR VPWR _7232_/Q sky130_fd_sc_hd__dfxtp_2
Xclkbuf_leaf_7_clk clkbuf_leaf_8_clk/A VGND VGND VPWR VPWR _7266_/CLK sky130_fd_sc_hd__clkbuf_16
X_4444_ _7302_/Q _4561_/A1 _4470_/A3 _4433_/C VGND VGND VPWR VPWR _4444_/X sky130_fd_sc_hd__a31o_2
X_7163_ _7247_/CLK _7163_/D VGND VGND VPWR VPWR _7163_/Q sky130_fd_sc_hd__dfxtp_2
X_4375_ _4375_/A _4416_/A _4375_/C VGND VGND VPWR VPWR _4411_/A sky130_fd_sc_hd__and3_2
XFILLER_58_305 VGND VGND VPWR VPWR sky130_fd_sc_hd__decap_3
X_7094_ _7290_/CLK _7094_/D VGND VGND VPWR VPWR _7094_/Q sky130_fd_sc_hd__dfxtp_2
X_6114_ _6559_/B1 _4970_/B _4970_/C _7195_/Q _6186_/C1 VGND VGND VPWR VPWR _6114_/X
+ sky130_fd_sc_hd__a311o_2
XFILLER_100_424 VGND VGND VPWR VPWR sky130_fd_sc_hd__decap_3
XFILLER_58_349 VGND VGND VPWR VPWR sky130_fd_sc_hd__decap_3
X_6045_ _6043_/X _6044_/X _5778_/X VGND VGND VPWR VPWR _6055_/A sky130_fd_sc_hd__a21oi_2
XFILLER_26_213 VGND VGND VPWR VPWR sky130_fd_sc_hd__decap_3
XFILLER_54_533 VGND VGND VPWR VPWR sky130_fd_sc_hd__fill_1
XFILLER_26_279 VGND VGND VPWR VPWR sky130_fd_sc_hd__decap_3
XFILLER_54_566 VGND VGND VPWR VPWR sky130_fd_sc_hd__fill_1
X_6947_ _7565_/CLK _6947_/D VGND VGND VPWR VPWR _6947_/Q sky130_fd_sc_hd__dfxtp_2
XFILLER_22_430 VGND VGND VPWR VPWR sky130_fd_sc_hd__decap_3
X_6878_ _7274_/CLK _6878_/D VGND VGND VPWR VPWR _6878_/Q sky130_fd_sc_hd__dfxtp_2
XTAP_TAPCELL_ROW_52_767 VGND VPWR sky130_fd_sc_hd__tapvpwrvgnd_1
X_5829_ _5827_/X _5828_/X _5304_/B VGND VGND VPWR VPWR _5829_/Y sky130_fd_sc_hd__o21ai_2
XFILLER_1_323 VGND VGND VPWR VPWR sky130_fd_sc_hd__decap_3
Xplace1380 _3741_/A VGND VGND VPWR VPWR _4295_/B1 sky130_fd_sc_hd__buf_2
Xplace1391 _4227_/X VGND VGND VPWR VPWR _4228_/C sky130_fd_sc_hd__buf_2
XFILLER_76_135 VGND VGND VPWR VPWR sky130_fd_sc_hd__decap_3
XFILLER_45_500 VGND VGND VPWR VPWR sky130_fd_sc_hd__decap_3
XFILLER_45_544 VGND VGND VPWR VPWR sky130_fd_sc_hd__decap_3
XFILLER_72_352 VGND VGND VPWR VPWR sky130_fd_sc_hd__decap_3
XFILLER_32_227 VGND VGND VPWR VPWR sky130_fd_sc_hd__decap_3
Xmax_cap2102 _5755_/Y VGND VGND VPWR VPWR _5987_/A1 sky130_fd_sc_hd__buf_6
XTAP_TAPCELL_ROW_80_1066 VGND VPWR sky130_fd_sc_hd__tapvpwrvgnd_1
XFILLER_4_150 VGND VGND VPWR VPWR sky130_fd_sc_hd__decap_3
XFILLER_67_113 VGND VGND VPWR VPWR sky130_fd_sc_hd__fill_1
XFILLER_68_90 VGND VGND VPWR VPWR sky130_fd_sc_hd__fill_1
XFILLER_95_466 VGND VGND VPWR VPWR sky130_fd_sc_hd__fill_1
X_4091_ _4091_/A _4091_/B VGND VGND VPWR VPWR _7611_/D sky130_fd_sc_hd__xnor2_2
XFILLER_36_500 VGND VGND VPWR VPWR sky130_fd_sc_hd__decap_3
XFILLER_55_319 VGND VGND VPWR VPWR sky130_fd_sc_hd__decap_3
XFILLER_36_533 VGND VGND VPWR VPWR sky130_fd_sc_hd__fill_1
XFILLER_48_393 VGND VGND VPWR VPWR sky130_fd_sc_hd__fill_1
XFILLER_36_555 VGND VGND VPWR VPWR sky130_fd_sc_hd__decap_3
XFILLER_63_352 VGND VGND VPWR VPWR sky130_fd_sc_hd__decap_3
XFILLER_23_216 VGND VGND VPWR VPWR sky130_fd_sc_hd__decap_3
XFILLER_23_249 VGND VGND VPWR VPWR sky130_fd_sc_hd__decap_3
XFILLER_51_569 VGND VGND VPWR VPWR sky130_fd_sc_hd__fill_2
X_3944_ _3944_/A _3944_/B VGND VGND VPWR VPWR _3944_/Y sky130_fd_sc_hd__nand2_2
X_3875_ _7432_/Q _4576_/B1 _3923_/B1 _7336_/Q _3874_/X VGND VGND VPWR VPWR _3875_/X
+ sky130_fd_sc_hd__a221o_2
X_5614_ _5614_/A0 _5614_/A1 _5635_/S VGND VGND VPWR VPWR _7237_/D sky130_fd_sc_hd__mux2_2
XTAP_TAPCELL_ROW_21_439 VGND VPWR sky130_fd_sc_hd__tapvpwrvgnd_1
X_6594_ _6594_/A0 _6515_/X _6607_/S VGND VGND VPWR VPWR _7461_/D sky130_fd_sc_hd__mux2_2
X_5545_ _5545_/A0 _5606_/A1 _5545_/S VGND VGND VPWR VPWR _7206_/D sky130_fd_sc_hd__mux2_2
X_5476_ _5476_/A0 _5720_/A1 _5486_/S VGND VGND VPWR VPWR _7174_/D sky130_fd_sc_hd__mux2_2
X_7215_ _7217_/CLK _7215_/D VGND VGND VPWR VPWR _7215_/Q sky130_fd_sc_hd__dfxtp_2
X_4427_ _6231_/A1 _4470_/A3 _6231_/A2 _7302_/Q VGND VGND VPWR VPWR _4427_/X sky130_fd_sc_hd__a31o_2
X_7146_ _7288_/CLK _7146_/D VGND VGND VPWR VPWR _7146_/Q sky130_fd_sc_hd__dfxtp_2
X_4358_ _4306_/A _4306_/B _4306_/C _7586_/D _4325_/B VGND VGND VPWR VPWR _4358_/X
+ sky130_fd_sc_hd__a311o_2
XFILLER_58_157 VGND VGND VPWR VPWR sky130_fd_sc_hd__decap_3
XFILLER_98_293 VGND VGND VPWR VPWR sky130_fd_sc_hd__decap_3
X_7077_ _7273_/CLK _7077_/D VGND VGND VPWR VPWR _7077_/Q sky130_fd_sc_hd__dfxtp_2
X_4289_ _4289_/A _4289_/B _4289_/C VGND VGND VPWR VPWR _4289_/Y sky130_fd_sc_hd__nand3_2
XTAP_TAPCELL_ROW_57_826 VGND VPWR sky130_fd_sc_hd__tapvpwrvgnd_1
XTAP_TAPCELL_ROW_29_528 VGND VPWR sky130_fd_sc_hd__tapvpwrvgnd_1
XFILLER_66_190 VGND VGND VPWR VPWR sky130_fd_sc_hd__decap_3
XFILLER_14_227 VGND VGND VPWR VPWR sky130_fd_sc_hd__decap_3
XFILLER_42_525 VGND VGND VPWR VPWR sky130_fd_sc_hd__decap_3
XTAP_TAPCELL_ROW_103_1309 VGND VPWR sky130_fd_sc_hd__tapvpwrvgnd_1
XFILLER_10_411 VGND VGND VPWR VPWR sky130_fd_sc_hd__fill_2
XFILLER_10_444 VGND VGND VPWR VPWR sky130_fd_sc_hd__decap_3
XFILLER_13_41 VGND VGND VPWR VPWR sky130_fd_sc_hd__decap_3
XFILLER_10_466 VGND VGND VPWR VPWR sky130_fd_sc_hd__fill_2
XFILLER_6_404 VGND VGND VPWR VPWR sky130_fd_sc_hd__fill_2
XFILLER_13_85 VGND VGND VPWR VPWR sky130_fd_sc_hd__fill_1
XFILLER_13_96 VGND VGND VPWR VPWR sky130_fd_sc_hd__fill_1
XFILLER_1_153 VGND VGND VPWR VPWR sky130_fd_sc_hd__fill_2
XFILLER_89_260 VGND VGND VPWR VPWR sky130_fd_sc_hd__fill_1
XFILLER_37_308 VGND VGND VPWR VPWR sky130_fd_sc_hd__decap_3
XFILLER_49_179 VGND VGND VPWR VPWR sky130_fd_sc_hd__decap_3
XFILLER_18_533 VGND VGND VPWR VPWR sky130_fd_sc_hd__decap_3
XFILLER_57_190 VGND VGND VPWR VPWR sky130_fd_sc_hd__decap_3
XFILLER_33_514 VGND VGND VPWR VPWR sky130_fd_sc_hd__decap_3
XFILLER_41_591 VGND VGND VPWR VPWR sky130_fd_sc_hd__decap_3
X_3660_ _3660_/A _3660_/B VGND VGND VPWR VPWR _3660_/Y sky130_fd_sc_hd__nand2_2
XFILLER_70_91 VGND VGND VPWR VPWR sky130_fd_sc_hd__fill_1
Xclkload34 _7509_/CLK VGND VGND VPWR VPWR clkload34/Y sky130_fd_sc_hd__inv_6
Xclkload23 _7275_/CLK VGND VGND VPWR VPWR clkload23/X sky130_fd_sc_hd__clkbuf_4
Xclkload12 _7579_/CLK VGND VGND VPWR VPWR clkload12/X sky130_fd_sc_hd__clkbuf_8
XFILLER_55_3 VGND VGND VPWR VPWR sky130_fd_sc_hd__fill_1
XTAP_TAPCELL_ROW_93_1202 VGND VPWR sky130_fd_sc_hd__tapvpwrvgnd_1
XPHY_EDGE_ROW_10_Left_114 VGND VGND VPWR VPWR sky130_fd_sc_hd__decap_3
X_7000_ _7280_/CLK _7000_/D VGND VGND VPWR VPWR _7000_/Q sky130_fd_sc_hd__dfxtp_2
X_4212_ _4212_/A _4212_/B VGND VGND VPWR VPWR _4212_/Y sky130_fd_sc_hd__nor2_2
Xhold2807 _7144_/Q VGND VGND VPWR VPWR _5410_/A0 sky130_fd_sc_hd__dlygate4sd3_1
Xhold2818 _6974_/Q VGND VGND VPWR VPWR _5011_/A0 sky130_fd_sc_hd__dlygate4sd3_1
Xhold2829 _7559_/Q VGND VGND VPWR VPWR _6802_/B sky130_fd_sc_hd__dlygate4sd3_1
X_5192_ _5192_/A0 _5342_/A1 _5207_/S VGND VGND VPWR VPWR _7057_/D sky130_fd_sc_hd__mux2_2
X_4143_ _4143_/A VGND VGND VPWR VPWR _4144_/C sky130_fd_sc_hd__inv_2
XFILLER_68_466 VGND VGND VPWR VPWR sky130_fd_sc_hd__fill_1
X_4074_ _4532_/B _7315_/Q _4077_/D VGND VGND VPWR VPWR _4533_/C sky130_fd_sc_hd__and3_2
XFILLER_83_447 VGND VGND VPWR VPWR sky130_fd_sc_hd__fill_1
XFILLER_24_514 VGND VGND VPWR VPWR sky130_fd_sc_hd__fill_2
Xplace171 _4200_/Y VGND VGND VPWR VPWR place171/X sky130_fd_sc_hd__buf_4
XTAP_TAPCELL_ROW_62_873 VGND VPWR sky130_fd_sc_hd__tapvpwrvgnd_1
XTAP_TAPCELL_ROW_34_575 VGND VPWR sky130_fd_sc_hd__tapvpwrvgnd_1
X_3927_ _7524_/Q _5734_/A _3968_/B _7492_/Q _3926_/X VGND VGND VPWR VPWR _3928_/B
+ sky130_fd_sc_hd__a221oi_2
Xclkload6 clkload6/A VGND VGND VPWR VPWR clkload6/Y sky130_fd_sc_hd__inv_6
X_3858_ _7498_/Q _3614_/X _3858_/B1 _7434_/Q VGND VGND VPWR VPWR _3859_/B sky130_fd_sc_hd__a22oi_2
X_6577_ _6577_/A0 _5855_/X _6590_/S VGND VGND VPWR VPWR _7453_/D sky130_fd_sc_hd__mux2_2
X_3789_ _7535_/Q _3812_/A2 _3789_/B1 _7407_/Q VGND VGND VPWR VPWR _3790_/C sky130_fd_sc_hd__a22oi_2
X_5528_ _5528_/A0 _5711_/A1 _5532_/S VGND VGND VPWR VPWR _7198_/D sky130_fd_sc_hd__mux2_2
X_5459_ _5459_/A0 _5703_/A1 _5471_/S VGND VGND VPWR VPWR _7166_/D sky130_fd_sc_hd__mux2_2
XFILLER_101_541 VGND VGND VPWR VPWR sky130_fd_sc_hd__fill_2
X_7129_ _7241_/CLK _7129_/D VGND VGND VPWR VPWR _7129_/Q sky130_fd_sc_hd__dfxtp_2
XFILLER_19_308 VGND VGND VPWR VPWR sky130_fd_sc_hd__decap_3
XFILLER_59_488 VGND VGND VPWR VPWR sky130_fd_sc_hd__fill_1
XTAP_TAPCELL_ROW_6_289 VGND VPWR sky130_fd_sc_hd__tapvpwrvgnd_1
XFILLER_15_514 VGND VGND VPWR VPWR sky130_fd_sc_hd__fill_1
XFILLER_27_363 VGND VGND VPWR VPWR sky130_fd_sc_hd__decap_3
XFILLER_15_569 VGND VGND VPWR VPWR sky130_fd_sc_hd__fill_2
XFILLER_91_57 VGND VGND VPWR VPWR sky130_fd_sc_hd__decap_3
XFILLER_24_51 VGND VGND VPWR VPWR sky130_fd_sc_hd__decap_3
XFILLER_30_506 VGND VGND VPWR VPWR sky130_fd_sc_hd__decap_3
XFILLER_30_539 VGND VGND VPWR VPWR sky130_fd_sc_hd__fill_1
XFILLER_10_230 VGND VGND VPWR VPWR sky130_fd_sc_hd__decap_3
XFILLER_10_274 VGND VGND VPWR VPWR sky130_fd_sc_hd__fill_1
XFILLER_10_285 VGND VGND VPWR VPWR sky130_fd_sc_hd__decap_3
XFILLER_6_212 VGND VGND VPWR VPWR sky130_fd_sc_hd__fill_2
XFILLER_6_245 VGND VGND VPWR VPWR sky130_fd_sc_hd__decap_3
XFILLER_6_256 VGND VGND VPWR VPWR sky130_fd_sc_hd__decap_3
XFILLER_6_289 VGND VGND VPWR VPWR sky130_fd_sc_hd__decap_3
XFILLER_97_517 VGND VGND VPWR VPWR sky130_fd_sc_hd__fill_1
XFILLER_2_451 VGND VGND VPWR VPWR sky130_fd_sc_hd__decap_3
XFILLER_77_241 VGND VGND VPWR VPWR sky130_fd_sc_hd__decap_3
XFILLER_33_300 VGND VGND VPWR VPWR sky130_fd_sc_hd__decap_3
XFILLER_52_119 VGND VGND VPWR VPWR sky130_fd_sc_hd__decap_3
XFILLER_33_333 VGND VGND VPWR VPWR sky130_fd_sc_hd__decap_3
X_4830_ _4830_/A0 _5353_/A1 _4838_/S VGND VGND VPWR VPWR _6894_/D sky130_fd_sc_hd__mux2_2
XFILLER_21_517 VGND VGND VPWR VPWR sky130_fd_sc_hd__decap_3
XFILLER_60_141 VGND VGND VPWR VPWR sky130_fd_sc_hd__decap_3
X_4761_ _4761_/A VGND VGND VPWR VPWR _4761_/Y sky130_fd_sc_hd__inv_2
X_7480_ _7608_/CLK _7480_/D place2067/X VGND VGND VPWR VPWR _7480_/Q sky130_fd_sc_hd__dfrtp_2
X_4692_ _4733_/B1 _4750_/A1 _6436_/C _4690_/X _4691_/X VGND VGND VPWR VPWR _4692_/X
+ sky130_fd_sc_hd__o311a_2
X_3712_ _4261_/A _3712_/B VGND VGND VPWR VPWR _3712_/Y sky130_fd_sc_hd__nor2_2
XTAP_TAPCELL_ROW_31_545 VGND VPWR sky130_fd_sc_hd__tapvpwrvgnd_1
X_6431_ _6429_/X _6430_/X _6478_/B1 VGND VGND VPWR VPWR _6435_/C sky130_fd_sc_hd__a21oi_2
X_3643_ _7380_/Q _6698_/S _3769_/B1 _7476_/Q VGND VGND VPWR VPWR _3647_/B sky130_fd_sc_hd__a22oi_2
Xplace1902 _3433_/Y VGND VGND VPWR VPWR _4321_/C sky130_fd_sc_hd__buf_2
X_6362_ _6658_/A0 _6362_/A2 _6362_/A3 _6363_/B1 _7395_/Q VGND VGND VPWR VPWR _6362_/X
+ sky130_fd_sc_hd__a32o_2
Xplace1946 _7375_/Q VGND VGND VPWR VPWR _6331_/B2 sky130_fd_sc_hd__buf_2
Xplace1935 _7433_/Q VGND VGND VPWR VPWR _6524_/A0 sky130_fd_sc_hd__buf_2
Xplace1924 _3460_/A VGND VGND VPWR VPWR _3471_/C sky130_fd_sc_hd__buf_2
Xplace1913 _3421_/B VGND VGND VPWR VPWR _4337_/D sky130_fd_sc_hd__buf_4
X_3574_ _3574_/A1 _4023_/B _3481_/A _3573_/X VGND VGND VPWR VPWR _3574_/Y sky130_fd_sc_hd__o211ai_2
Xplace1979 _7295_/Q VGND VGND VPWR VPWR _3474_/A sky130_fd_sc_hd__buf_2
Xplace1968 _7307_/Q VGND VGND VPWR VPWR _4495_/A sky130_fd_sc_hd__buf_2
Xplace1957 _7360_/Q VGND VGND VPWR VPWR _6310_/B2 sky130_fd_sc_hd__buf_2
XFILLER_88_528 VGND VGND VPWR VPWR sky130_fd_sc_hd__decap_3
Xhold2604 _6888_/Q VGND VGND VPWR VPWR _4817_/A0 sky130_fd_sc_hd__dlygate4sd3_1
Xhold2637 _7073_/Q VGND VGND VPWR VPWR _5234_/A0 sky130_fd_sc_hd__dlygate4sd3_1
Xhold2626 _6856_/Q VGND VGND VPWR VPWR _4672_/A0 sky130_fd_sc_hd__dlygate4sd3_1
Xhold2615 _7150_/Q VGND VGND VPWR VPWR _5423_/A0 sky130_fd_sc_hd__dlygate4sd3_1
X_5175_ _5175_/A0 _5692_/A1 _5179_/S VGND VGND VPWR VPWR _7049_/D sky130_fd_sc_hd__mux2_2
XFILLER_68_241 VGND VGND VPWR VPWR sky130_fd_sc_hd__decap_3
XFILLER_68_274 VGND VGND VPWR VPWR sky130_fd_sc_hd__decap_3
Xhold2648 _7226_/Q VGND VGND VPWR VPWR _5589_/A0 sky130_fd_sc_hd__dlygate4sd3_1
Xhold2659 _7045_/Q VGND VGND VPWR VPWR _5167_/A0 sky130_fd_sc_hd__dlygate4sd3_1
XFILLER_68_296 VGND VGND VPWR VPWR sky130_fd_sc_hd__decap_3
XFILLER_96_594 VGND VGND VPWR VPWR sky130_fd_sc_hd__fill_1
XTAP_TAPCELL_ROW_3_259 VGND VPWR sky130_fd_sc_hd__tapvpwrvgnd_1
XTAP_TAPCELL_ROW_39_634 VGND VPWR sky130_fd_sc_hd__tapvpwrvgnd_1
XFILLER_28_149 VGND VGND VPWR VPWR sky130_fd_sc_hd__decap_3
X_4057_ _7309_/Q _4059_/C VGND VGND VPWR VPWR _7599_/D sky130_fd_sc_hd__xor2_2
XFILLER_36_193 VGND VGND VPWR VPWR sky130_fd_sc_hd__decap_3
XFILLER_20_583 VGND VGND VPWR VPWR sky130_fd_sc_hd__decap_3
XFILLER_10_42 VGND VGND VPWR VPWR sky130_fd_sc_hd__decap_3
XFILLER_10_97 VGND VGND VPWR VPWR sky130_fd_sc_hd__decap_3
XFILLER_47_414 VGND VGND VPWR VPWR sky130_fd_sc_hd__decap_3
XFILLER_87_561 VGND VGND VPWR VPWR sky130_fd_sc_hd__decap_3
XFILLER_19_62 VGND VGND VPWR VPWR sky130_fd_sc_hd__decap_3
XFILLER_35_609 VGND VGND VPWR VPWR sky130_fd_sc_hd__decap_3
XFILLER_34_108 VGND VGND VPWR VPWR sky130_fd_sc_hd__decap_3
XFILLER_27_193 VGND VGND VPWR VPWR sky130_fd_sc_hd__decap_3
XFILLER_35_83 VGND VGND VPWR VPWR sky130_fd_sc_hd__decap_3
XFILLER_42_141 VGND VGND VPWR VPWR sky130_fd_sc_hd__decap_3
XFILLER_30_336 VGND VGND VPWR VPWR sky130_fd_sc_hd__decap_3
XFILLER_11_561 VGND VGND VPWR VPWR sky130_fd_sc_hd__fill_1
XTAP_TAPCELL_ROW_77_1027 VGND VPWR sky130_fd_sc_hd__tapvpwrvgnd_1
Xplace1209 _4808_/S VGND VGND VPWR VPWR _4806_/S sky130_fd_sc_hd__buf_2
XFILLER_18_3 VGND VGND VPWR VPWR sky130_fd_sc_hd__decap_3
XFILLER_38_425 VGND VGND VPWR VPWR sky130_fd_sc_hd__fill_2
XFILLER_93_564 VGND VGND VPWR VPWR sky130_fd_sc_hd__decap_3
X_6980_ _7291_/CLK _6980_/D VGND VGND VPWR VPWR _6980_/Q sky130_fd_sc_hd__dfxtp_2
XTAP_TAPCELL_ROW_88_1145 VGND VPWR sky130_fd_sc_hd__tapvpwrvgnd_1
XTAP_TAPCELL_ROW_0_218 VGND VPWR sky130_fd_sc_hd__tapvpwrvgnd_1
XFILLER_53_417 VGND VGND VPWR VPWR sky130_fd_sc_hd__decap_3
X_5931_ _6476_/A1 _7154_/Q _7126_/Q _6476_/B2 VGND VGND VPWR VPWR _5931_/X sky130_fd_sc_hd__o22a_2
XTAP_TAPCELL_ROW_36_604 VGND VPWR sky130_fd_sc_hd__tapvpwrvgnd_1
XFILLER_18_182 VGND VGND VPWR VPWR sky130_fd_sc_hd__decap_3
X_5862_ _6489_/A1 _5862_/A2 _5862_/A3 _6495_/A2 _6440_/B1 VGND VGND VPWR VPWR _5862_/X
+ sky130_fd_sc_hd__a41o_2
XFILLER_33_185 VGND VGND VPWR VPWR sky130_fd_sc_hd__decap_3
X_7601_ _7606_/CLK _7601_/D place2052/X VGND VGND VPWR VPWR _7601_/Q sky130_fd_sc_hd__dfrtp_2
X_4813_ _4813_/A0 _5703_/A1 _4840_/S VGND VGND VPWR VPWR _6886_/D sky130_fd_sc_hd__mux2_2
XTAP_TAPCELL_ROW_44_681 VGND VPWR sky130_fd_sc_hd__tapvpwrvgnd_1
X_7532_ _7610_/CLK _7532_/D place2058/X VGND VGND VPWR VPWR _7532_/Q sky130_fd_sc_hd__dfrtp_2
X_4744_ _4734_/X _4745_/A2 _4743_/Y _4773_/B2 _6547_/A1 VGND VGND VPWR VPWR _4744_/X
+ sky130_fd_sc_hd__o221a_2
XTAP_TAPCELL_ROW_16_394 VGND VPWR sky130_fd_sc_hd__tapvpwrvgnd_1
X_7463_ clkload4/A _7463_/D place2064/X VGND VGND VPWR VPWR _7463_/Q sky130_fd_sc_hd__dfrtp_2
X_4675_ _4675_/A _4675_/B _4675_/C VGND VGND VPWR VPWR _5979_/A sky130_fd_sc_hd__and3_4
XTAP_TAPCELL_ROW_99_1263 VGND VPWR sky130_fd_sc_hd__tapvpwrvgnd_1
Xplace1710 _4550_/S VGND VGND VPWR VPWR _4539_/S sky130_fd_sc_hd__buf_2
X_7394_ _7490_/CLK _7394_/D place2024/X VGND VGND VPWR VPWR _7394_/Q sky130_fd_sc_hd__dfrtp_2
X_6414_ _6302_/A _6302_/B _6302_/C _6347_/A _6347_/B VGND VGND VPWR VPWR _6518_/S
+ sky130_fd_sc_hd__o311a_2
Xplace1721 _3529_/Y VGND VGND VPWR VPWR _3557_/B sky130_fd_sc_hd__buf_2
Xplace1732 _4237_/A VGND VGND VPWR VPWR _3738_/A sky130_fd_sc_hd__buf_2
Xplace1743 _3548_/B1 VGND VGND VPWR VPWR _3854_/A2 sky130_fd_sc_hd__buf_4
Xplace1754 _3978_/B VGND VGND VPWR VPWR _6658_/S sky130_fd_sc_hd__buf_2
X_6345_ _7418_/Q _6346_/A2 _6346_/A3 _6345_/B1 _6345_/B2 VGND VGND VPWR VPWR _6345_/X
+ sky130_fd_sc_hd__a32o_2
X_3557_ _3557_/A _3557_/B _3557_/C VGND VGND VPWR VPWR _3557_/Y sky130_fd_sc_hd__nor3_2
XTAP_TAPCELL_ROW_8_307 VGND VPWR sky130_fd_sc_hd__tapvpwrvgnd_1
XFILLER_0_207 VGND VGND VPWR VPWR sky130_fd_sc_hd__decap_3
Xplace1765 _3863_/A2 VGND VGND VPWR VPWR _3855_/A2 sky130_fd_sc_hd__buf_6
Xplace1776 _3975_/C VGND VGND VPWR VPWR _6805_/A sky130_fd_sc_hd__buf_2
Xplace1787 _3554_/X VGND VGND VPWR VPWR _3578_/D1 sky130_fd_sc_hd__buf_2
Xplace1798 _3500_/C VGND VGND VPWR VPWR place1798/X sky130_fd_sc_hd__buf_2
Xhold2412 _7026_/Q VGND VGND VPWR VPWR _5125_/A0 sky130_fd_sc_hd__dlygate4sd3_1
Xhold2401 _7063_/Q VGND VGND VPWR VPWR _5205_/A0 sky130_fd_sc_hd__dlygate4sd3_1
X_5227_ _5227_/A0 _5312_/A1 _5255_/S VGND VGND VPWR VPWR _7071_/D sky130_fd_sc_hd__mux2_2
X_3488_ _4319_/A1 _3522_/A2 _3481_/B VGND VGND VPWR VPWR _3488_/X sky130_fd_sc_hd__o21a_2
XFILLER_69_561 VGND VGND VPWR VPWR sky130_fd_sc_hd__decap_3
Xhold2445 _6904_/Q VGND VGND VPWR VPWR _4853_/A0 sky130_fd_sc_hd__dlygate4sd3_1
Xhold2434 _7261_/Q VGND VGND VPWR VPWR _5665_/A0 sky130_fd_sc_hd__dlygate4sd3_1
Xhold2423 _7072_/Q VGND VGND VPWR VPWR _5230_/A0 sky130_fd_sc_hd__dlygate4sd3_1
XFILLER_29_436 VGND VGND VPWR VPWR sky130_fd_sc_hd__decap_3
XFILLER_56_200 VGND VGND VPWR VPWR sky130_fd_sc_hd__fill_1
XFILLER_56_222 VGND VGND VPWR VPWR sky130_fd_sc_hd__decap_3
XFILLER_56_38 VGND VGND VPWR VPWR sky130_fd_sc_hd__fill_2
XFILLER_84_531 VGND VGND VPWR VPWR sky130_fd_sc_hd__fill_1
Xhold2489 _6897_/Q VGND VGND VPWR VPWR _4836_/A0 sky130_fd_sc_hd__dlygate4sd3_1
Xhold2478 _7107_/Q VGND VGND VPWR VPWR _5329_/A0 sky130_fd_sc_hd__dlygate4sd3_1
Xhold2467 _6998_/Q VGND VGND VPWR VPWR _5064_/A0 sky130_fd_sc_hd__dlygate4sd3_1
Xhold2456 _7227_/Q VGND VGND VPWR VPWR _5591_/A0 sky130_fd_sc_hd__dlygate4sd3_1
X_5158_ _5158_/A0 _5221_/A1 _5181_/S VGND VGND VPWR VPWR _7041_/D sky130_fd_sc_hd__mux2_2
XFILLER_29_458 VGND VGND VPWR VPWR sky130_fd_sc_hd__decap_3
X_5089_ _5089_/A0 _5728_/A1 _5089_/S VGND VGND VPWR VPWR _7010_/D sky130_fd_sc_hd__mux2_2
X_4109_ _4111_/A1 _4584_/B1 _5862_/A3 VGND VGND VPWR VPWR _4109_/Y sky130_fd_sc_hd__o21ai_2
XFILLER_37_480 VGND VGND VPWR VPWR sky130_fd_sc_hd__decap_3
XFILLER_24_141 VGND VGND VPWR VPWR sky130_fd_sc_hd__decap_3
XFILLER_24_174 VGND VGND VPWR VPWR sky130_fd_sc_hd__decap_3
XFILLER_12_347 VGND VGND VPWR VPWR sky130_fd_sc_hd__fill_1
XFILLER_8_318 VGND VGND VPWR VPWR sky130_fd_sc_hd__decap_3
XFILLER_21_52 VGND VGND VPWR VPWR sky130_fd_sc_hd__decap_3
XFILLER_21_74 VGND VGND VPWR VPWR sky130_fd_sc_hd__decap_3
Xhold2990 _6357_/X VGND VGND VPWR VPWR _7390_/D sky130_fd_sc_hd__dlygate4sd3_1
XFILLER_35_417 VGND VGND VPWR VPWR sky130_fd_sc_hd__decap_3
XFILLER_47_277 VGND VGND VPWR VPWR sky130_fd_sc_hd__decap_3
XFILLER_90_512 VGND VGND VPWR VPWR sky130_fd_sc_hd__decap_3
XFILLER_28_480 VGND VGND VPWR VPWR sky130_fd_sc_hd__decap_3
XFILLER_46_71 VGND VGND VPWR VPWR sky130_fd_sc_hd__decap_3
XFILLER_50_409 VGND VGND VPWR VPWR sky130_fd_sc_hd__fill_2
XFILLER_90_589 VGND VGND VPWR VPWR sky130_fd_sc_hd__decap_3
XFILLER_15_196 VGND VGND VPWR VPWR sky130_fd_sc_hd__decap_3
XTAP_TAPCELL_ROW_83_1097 VGND VPWR sky130_fd_sc_hd__tapvpwrvgnd_1
XTAP_TAPCELL_ROW_41_651 VGND VPWR sky130_fd_sc_hd__tapvpwrvgnd_1
XTAP_TAPCELL_ROW_13_364 VGND VPWR sky130_fd_sc_hd__tapvpwrvgnd_1
XFILLER_7_54 VGND VGND VPWR VPWR sky130_fd_sc_hd__fill_2
XFILLER_7_87 VGND VGND VPWR VPWR sky130_fd_sc_hd__fill_1
X_4460_ _4460_/A _4460_/B _4460_/C VGND VGND VPWR VPWR _4564_/B sky130_fd_sc_hd__or3_2
X_3411_ _3480_/B _3409_/Y _3445_/A VGND VGND VPWR VPWR _3411_/Y sky130_fd_sc_hd__o21ai_4
X_6130_ _7084_/Q _6139_/A1 _6138_/A1 _7112_/Q _6129_/X VGND VGND VPWR VPWR _6130_/X
+ sky130_fd_sc_hd__o221a_2
X_6061_ _6449_/B1 _7217_/Q _7133_/Q _6450_/B2 VGND VGND VPWR VPWR _6061_/X sky130_fd_sc_hd__o22a_2
XFILLER_38_200 VGND VGND VPWR VPWR sky130_fd_sc_hd__decap_3
XTAP_TAPCELL_ROW_49_740 VGND VPWR sky130_fd_sc_hd__tapvpwrvgnd_1
XFILLER_26_19 VGND VGND VPWR VPWR sky130_fd_sc_hd__fill_1
XFILLER_26_417 VGND VGND VPWR VPWR sky130_fd_sc_hd__decap_3
XFILLER_19_480 VGND VGND VPWR VPWR sky130_fd_sc_hd__decap_3
XFILLER_53_225 VGND VGND VPWR VPWR sky130_fd_sc_hd__decap_3
X_6963_ _7273_/CLK _6963_/D VGND VGND VPWR VPWR _6963_/Q sky130_fd_sc_hd__dfxtp_2
X_6894_ _7288_/CLK _6894_/D VGND VGND VPWR VPWR _6894_/Q sky130_fd_sc_hd__dfxtp_2
X_5914_ _6966_/Q _6511_/B2 _5912_/X _5913_/X VGND VGND VPWR VPWR _5914_/X sky130_fd_sc_hd__o211a_2
XFILLER_34_483 VGND VGND VPWR VPWR sky130_fd_sc_hd__decap_3
X_5845_ _5826_/X _5840_/X _5844_/X VGND VGND VPWR VPWR _5845_/Y sky130_fd_sc_hd__a21oi_2
XFILLER_21_133 VGND VGND VPWR VPWR sky130_fd_sc_hd__decap_3
XFILLER_61_291 VGND VGND VPWR VPWR sky130_fd_sc_hd__decap_3
XFILLER_21_199 VGND VGND VPWR VPWR sky130_fd_sc_hd__decap_3
X_7515_ clkload4/A _7515_/D place2064/X VGND VGND VPWR VPWR _7515_/Q sky130_fd_sc_hd__dfrtp_2
X_4727_ _6436_/A _6436_/B _4727_/C _4727_/D VGND VGND VPWR VPWR _4727_/X sky130_fd_sc_hd__or4_4
XPHY_EDGE_ROW_2_Left_106 VGND VGND VPWR VPWR sky130_fd_sc_hd__decap_3
X_7446_ _7542_/CLK _7446_/D place2048/X VGND VGND VPWR VPWR _7446_/Q sky130_fd_sc_hd__dfrtp_2
X_4658_ _4658_/A0 _5572_/A1 _4665_/S VGND VGND VPWR VPWR _6854_/D sky130_fd_sc_hd__mux2_2
Xplace1540 _6560_/B VGND VGND VPWR VPWR _6566_/A2 sky130_fd_sc_hd__buf_2
Xplace1551 _3969_/B VGND VGND VPWR VPWR _4398_/B sky130_fd_sc_hd__buf_2
Xplace1562 _3938_/X VGND VGND VPWR VPWR _4727_/C sky130_fd_sc_hd__buf_2
X_7377_ _7514_/CLK _7377_/D place2043/X VGND VGND VPWR VPWR _7377_/Q sky130_fd_sc_hd__dfrtp_2
Xplace1573 _3738_/C VGND VGND VPWR VPWR _4297_/B sky130_fd_sc_hd__buf_2
Xplace1584 _3862_/A2 VGND VGND VPWR VPWR _3946_/B sky130_fd_sc_hd__buf_2
Xplace1595 _3993_/B1 VGND VGND VPWR VPWR _4007_/B1 sky130_fd_sc_hd__buf_4
X_6328_ _6328_/A1 _6346_/A2 _6335_/A3 _6345_/B1 _6328_/B2 VGND VGND VPWR VPWR _7372_/D
+ sky130_fd_sc_hd__a32o_2
XFILLER_103_444 VGND VGND VPWR VPWR sky130_fd_sc_hd__decap_3
XFILLER_29_211 VGND VGND VPWR VPWR sky130_fd_sc_hd__fill_2
XFILLER_69_391 VGND VGND VPWR VPWR sky130_fd_sc_hd__fill_1
XFILLER_29_255 VGND VGND VPWR VPWR sky130_fd_sc_hd__decap_3
XFILLER_72_501 VGND VGND VPWR VPWR sky130_fd_sc_hd__fill_2
XFILLER_29_299 VGND VGND VPWR VPWR sky130_fd_sc_hd__decap_3
XFILLER_72_589 VGND VGND VPWR VPWR sky130_fd_sc_hd__decap_3
XFILLER_12_100 VGND VGND VPWR VPWR sky130_fd_sc_hd__decap_3
XFILLER_16_85 VGND VGND VPWR VPWR sky130_fd_sc_hd__decap_3
XFILLER_25_472 VGND VGND VPWR VPWR sky130_fd_sc_hd__decap_3
XPHY_EDGE_ROW_11_Right_11 VGND VGND VPWR VPWR sky130_fd_sc_hd__decap_3
XTAP_TAPCELL_ROW_55_798 VGND VPWR sky130_fd_sc_hd__tapvpwrvgnd_1
XFILLER_40_453 VGND VGND VPWR VPWR sky130_fd_sc_hd__decap_3
XFILLER_8_115 VGND VGND VPWR VPWR sky130_fd_sc_hd__fill_2
XFILLER_32_51 VGND VGND VPWR VPWR sky130_fd_sc_hd__decap_3
XTAP_TAPCELL_ROW_10_323 VGND VPWR sky130_fd_sc_hd__tapvpwrvgnd_1
XFILLER_4_365 VGND VGND VPWR VPWR sky130_fd_sc_hd__decap_3
XPHY_EDGE_ROW_20_Right_20 VGND VGND VPWR VPWR sky130_fd_sc_hd__decap_3
XFILLER_79_144 VGND VGND VPWR VPWR sky130_fd_sc_hd__fill_1
XFILLER_94_103 VGND VGND VPWR VPWR sky130_fd_sc_hd__decap_3
XFILLER_0_593 VGND VGND VPWR VPWR sky130_fd_sc_hd__decap_3
XFILLER_82_309 VGND VGND VPWR VPWR sky130_fd_sc_hd__fill_2
XFILLER_48_586 VGND VGND VPWR VPWR sky130_fd_sc_hd__fill_2
XTAP_TAPCELL_ROW_46_710 VGND VPWR sky130_fd_sc_hd__tapvpwrvgnd_1
XFILLER_35_225 VGND VGND VPWR VPWR sky130_fd_sc_hd__decap_3
XTAP_TAPCELL_ROW_85_1115 VGND VPWR sky130_fd_sc_hd__tapvpwrvgnd_1
XTAP_TAPCELL_ROW_18_412 VGND VPWR sky130_fd_sc_hd__tapvpwrvgnd_1
XFILLER_35_269 VGND VGND VPWR VPWR sky130_fd_sc_hd__decap_3
XFILLER_50_239 VGND VGND VPWR VPWR sky130_fd_sc_hd__decap_3
X_3891_ _7430_/Q _3934_/B1 _4007_/B1 _7398_/Q VGND VGND VPWR VPWR _3894_/A sky130_fd_sc_hd__a22oi_2
XFILLER_31_486 VGND VGND VPWR VPWR sky130_fd_sc_hd__decap_3
XPHY_EDGE_ROW_75_Left_179 VGND VGND VPWR VPWR sky130_fd_sc_hd__decap_3
X_7300_ clkload5/A _7300_/D place2062/X VGND VGND VPWR VPWR _7300_/Q sky130_fd_sc_hd__dfrtp_2
X_5492_ _5492_/A0 _5614_/A1 _5513_/S VGND VGND VPWR VPWR _7181_/D sky130_fd_sc_hd__mux2_2
X_4512_ _7311_/Q _4482_/B _7312_/Q _4506_/B VGND VGND VPWR VPWR _4532_/D sky130_fd_sc_hd__o211a_2
XTAP_TAPCELL_ROW_96_1233 VGND VPWR sky130_fd_sc_hd__tapvpwrvgnd_1
XFILLER_7_181 VGND VGND VPWR VPWR sky130_fd_sc_hd__decap_3
X_7231_ _7289_/CLK _7231_/D VGND VGND VPWR VPWR _7231_/Q sky130_fd_sc_hd__dfxtp_2
X_4443_ _4503_/A _4503_/B _4503_/C _7303_/Q VGND VGND VPWR VPWR _4443_/X sky130_fd_sc_hd__or4b_2
X_7162_ _7274_/CLK _7162_/D VGND VGND VPWR VPWR _7162_/Q sky130_fd_sc_hd__dfxtp_2
X_4374_ _4437_/A3 _4379_/B _4448_/B _4036_/A VGND VGND VPWR VPWR _4375_/C sky130_fd_sc_hd__a31o_2
X_7093_ _7289_/CLK _7093_/D VGND VGND VPWR VPWR _7093_/Q sky130_fd_sc_hd__dfxtp_2
X_6113_ _6219_/A1 _6220_/A2 _6185_/B1 _7597_/Q _6112_/X VGND VGND VPWR VPWR _6113_/X
+ sky130_fd_sc_hd__o221a_4
XPHY_EDGE_ROW_84_Left_188 VGND VGND VPWR VPWR sky130_fd_sc_hd__decap_3
X_6044_ _6484_/A2 _6992_/Q _6964_/Q _6480_/B2 VGND VGND VPWR VPWR _6044_/X sky130_fd_sc_hd__o22a_2
XFILLER_100_436 VGND VGND VPWR VPWR sky130_fd_sc_hd__decap_3
XFILLER_39_531 VGND VGND VPWR VPWR sky130_fd_sc_hd__decap_3
XFILLER_85_147 VGND VGND VPWR VPWR sky130_fd_sc_hd__fill_2
XFILLER_54_501 VGND VGND VPWR VPWR sky130_fd_sc_hd__decap_3
XFILLER_26_225 VGND VGND VPWR VPWR sky130_fd_sc_hd__decap_3
X_6946_ _7279_/CLK _6946_/D VGND VGND VPWR VPWR _6946_/Q sky130_fd_sc_hd__dfxtp_2
XFILLER_41_228 VGND VGND VPWR VPWR sky130_fd_sc_hd__decap_3
XFILLER_22_442 VGND VGND VPWR VPWR sky130_fd_sc_hd__fill_2
XFILLER_34_291 VGND VGND VPWR VPWR sky130_fd_sc_hd__decap_3
X_6877_ _7217_/CLK _6877_/D VGND VGND VPWR VPWR _6877_/Q sky130_fd_sc_hd__dfxtp_2
XTAP_TAPCELL_ROW_52_768 VGND VPWR sky130_fd_sc_hd__tapvpwrvgnd_1
XPHY_EDGE_ROW_93_Left_197 VGND VGND VPWR VPWR sky130_fd_sc_hd__decap_3
XFILLER_22_464 VGND VGND VPWR VPWR sky130_fd_sc_hd__decap_3
XFILLER_22_486 VGND VGND VPWR VPWR sky130_fd_sc_hd__decap_3
X_5828_ _6844_/Q _5610_/B _5549_/B _7096_/Q VGND VGND VPWR VPWR _5828_/X sky130_fd_sc_hd__a22o_2
X_5759_ _6088_/A _3802_/C _5759_/B1 _4842_/C _5759_/D1 VGND VGND VPWR VPWR _5759_/Y
+ sky130_fd_sc_hd__o2111ai_4
Xplace2060 place2062/X VGND VGND VPWR VPWR place2060/X sky130_fd_sc_hd__buf_2
X_7429_ clkload9/A _7429_/D place2034/X VGND VGND VPWR VPWR _7429_/Q sky130_fd_sc_hd__dfrtp_2
Xplace1370 _4148_/A VGND VGND VPWR VPWR _3917_/B1 sky130_fd_sc_hd__buf_2
XFILLER_1_335 VGND VGND VPWR VPWR sky130_fd_sc_hd__fill_1
Xplace1381 _4274_/B VGND VGND VPWR VPWR _4260_/B sky130_fd_sc_hd__buf_2
Xplace1392 _4184_/Y VGND VGND VPWR VPWR _4185_/B sky130_fd_sc_hd__buf_2
XFILLER_76_158 VGND VGND VPWR VPWR sky130_fd_sc_hd__decap_3
XFILLER_17_203 VGND VGND VPWR VPWR sky130_fd_sc_hd__decap_3
XFILLER_17_225 VGND VGND VPWR VPWR sky130_fd_sc_hd__decap_3
XFILLER_27_40 VGND VGND VPWR VPWR sky130_fd_sc_hd__decap_3
XFILLER_45_534 VGND VGND VPWR VPWR sky130_fd_sc_hd__fill_2
XFILLER_72_320 VGND VGND VPWR VPWR sky130_fd_sc_hd__decap_3
XFILLER_27_73 VGND VGND VPWR VPWR sky130_fd_sc_hd__decap_3
XFILLER_32_217 VGND VGND VPWR VPWR sky130_fd_sc_hd__decap_3
XFILLER_43_83 VGND VGND VPWR VPWR sky130_fd_sc_hd__decap_3
Xmax_cap2103 _3945_/A2 VGND VGND VPWR VPWR place1531/A sky130_fd_sc_hd__clkbuf_1
XTAP_TAPCELL_ROW_80_1067 VGND VPWR sky130_fd_sc_hd__tapvpwrvgnd_1
XFILLER_40_283 VGND VGND VPWR VPWR sky130_fd_sc_hd__decap_3
XFILLER_4_88 VGND VGND VPWR VPWR sky130_fd_sc_hd__decap_3
XTAP_TAPCELL_ROW_91_1174 VGND VPWR sky130_fd_sc_hd__tapvpwrvgnd_1
XFILLER_0_390 VGND VGND VPWR VPWR sky130_fd_sc_hd__fill_2
XFILLER_36_567 VGND VGND VPWR VPWR sky130_fd_sc_hd__fill_1
X_6800_ _6805_/A _6800_/B VGND VGND VPWR VPWR _7558_/D sky130_fd_sc_hd__and2_2
XFILLER_23_228 VGND VGND VPWR VPWR sky130_fd_sc_hd__decap_3
XFILLER_36_589 VGND VGND VPWR VPWR sky130_fd_sc_hd__fill_1
X_4992_ _4992_/A0 _4650_/X _4994_/S VGND VGND VPWR VPWR _6965_/D sky130_fd_sc_hd__mux2_2
XFILLER_51_559 VGND VGND VPWR VPWR sky130_fd_sc_hd__fill_1
X_6731_ _6040_/X _6731_/A1 _6775_/S VGND VGND VPWR VPWR _7526_/D sky130_fd_sc_hd__mux2_2
X_3943_ _7297_/Q _5850_/B _3935_/Y _3941_/X VGND VGND VPWR VPWR _3944_/B sky130_fd_sc_hd__a211o_2
XFILLER_31_261 VGND VGND VPWR VPWR sky130_fd_sc_hd__decap_3
X_6662_ _6662_/A0 _6515_/X _6662_/S VGND VGND VPWR VPWR _7493_/D sky130_fd_sc_hd__mux2_2
X_3874_ _3842_/C _3842_/B _7368_/Q _3936_/B1 _7560_/Q VGND VGND VPWR VPWR _3874_/X
+ sky130_fd_sc_hd__a32o_2
XFILLER_31_294 VGND VGND VPWR VPWR sky130_fd_sc_hd__decap_3
Xclkbuf_3_2__f_clk clkbuf_0_clk/X VGND VGND VPWR VPWR clkbuf_3_2__f_clk/X sky130_fd_sc_hd__clkbuf_8
XTAP_TAPCELL_ROW_100_1270 VGND VPWR sky130_fd_sc_hd__tapvpwrvgnd_1
X_7214_ _7273_/CLK _7214_/D VGND VGND VPWR VPWR _7214_/Q sky130_fd_sc_hd__dfxtp_2
XFILLER_98_250 VGND VGND VPWR VPWR sky130_fd_sc_hd__fill_2
X_7145_ _7217_/CLK _7145_/D VGND VGND VPWR VPWR _7145_/Q sky130_fd_sc_hd__dfxtp_2
XFILLER_100_200 VGND VGND VPWR VPWR sky130_fd_sc_hd__decap_3
X_4357_ _4362_/B _4356_/X _4346_/A _4388_/S VGND VGND VPWR VPWR _4357_/X sky130_fd_sc_hd__a211o_2
XFILLER_58_147 VGND VGND VPWR VPWR sky130_fd_sc_hd__decap_3
X_7076_ _7274_/CLK _7076_/D VGND VGND VPWR VPWR _7076_/Q sky130_fd_sc_hd__dfxtp_2
X_4288_ _4294_/A2 _3738_/B _4287_/X _4763_/A2 _4283_/X VGND VGND VPWR VPWR _4288_/X
+ sky130_fd_sc_hd__o41a_2
XFILLER_100_266 VGND VGND VPWR VPWR sky130_fd_sc_hd__fill_2
XFILLER_46_309 VGND VGND VPWR VPWR sky130_fd_sc_hd__decap_3
X_6027_ _6449_/A2 _7187_/Q _7159_/Q _6448_/A1 VGND VGND VPWR VPWR _6027_/X sky130_fd_sc_hd__o22a_2
XFILLER_27_512 VGND VGND VPWR VPWR sky130_fd_sc_hd__decap_3
XTAP_TAPCELL_ROW_29_529 VGND VPWR sky130_fd_sc_hd__tapvpwrvgnd_1
XFILLER_27_567 VGND VGND VPWR VPWR sky130_fd_sc_hd__decap_3
X_6929_ _7266_/CLK _6929_/D VGND VGND VPWR VPWR _6929_/Q sky130_fd_sc_hd__dfxtp_2
XFILLER_10_401 VGND VGND VPWR VPWR sky130_fd_sc_hd__fill_1
XFILLER_22_250 VGND VGND VPWR VPWR sky130_fd_sc_hd__fill_2
XFILLER_22_283 VGND VGND VPWR VPWR sky130_fd_sc_hd__decap_3
XFILLER_13_53 VGND VGND VPWR VPWR sky130_fd_sc_hd__decap_3
XFILLER_13_64 VGND VGND VPWR VPWR sky130_fd_sc_hd__decap_3
XFILLER_89_57 VGND VGND VPWR VPWR sky130_fd_sc_hd__fill_2
XFILLER_49_103 VGND VGND VPWR VPWR sky130_fd_sc_hd__decap_3
Xrebuffer2190 place1674/X VGND VGND VPWR VPWR _6363_/A3 sky130_fd_sc_hd__buf_2
XFILLER_77_445 VGND VGND VPWR VPWR sky130_fd_sc_hd__decap_3
XFILLER_18_545 VGND VGND VPWR VPWR sky130_fd_sc_hd__decap_3
XFILLER_33_526 VGND VGND VPWR VPWR sky130_fd_sc_hd__decap_3
XFILLER_60_312 VGND VGND VPWR VPWR sky130_fd_sc_hd__fill_2
XFILLER_60_323 VGND VGND VPWR VPWR sky130_fd_sc_hd__decap_3
XFILLER_72_150 VGND VGND VPWR VPWR sky130_fd_sc_hd__fill_1
XFILLER_60_345 VGND VGND VPWR VPWR sky130_fd_sc_hd__decap_3
XFILLER_20_209 VGND VGND VPWR VPWR sky130_fd_sc_hd__decap_3
XFILLER_60_378 VGND VGND VPWR VPWR sky130_fd_sc_hd__fill_2
XFILLER_9_232 VGND VGND VPWR VPWR sky130_fd_sc_hd__decap_3
XFILLER_9_287 VGND VGND VPWR VPWR sky130_fd_sc_hd__fill_2
Xclkload35 _7217_/CLK VGND VGND VPWR VPWR clkload35/X sky130_fd_sc_hd__clkbuf_4
Xclkload24 _7243_/CLK VGND VGND VPWR VPWR clkload24/X sky130_fd_sc_hd__clkbuf_4
Xclkload13 _7507_/CLK VGND VGND VPWR VPWR clkload13/X sky130_fd_sc_hd__clkbuf_8
XTAP_TAPCELL_ROW_93_1203 VGND VPWR sky130_fd_sc_hd__tapvpwrvgnd_1
X_4211_ _4211_/A _4237_/C _4211_/C VGND VGND VPWR VPWR _4211_/X sky130_fd_sc_hd__or3_2
Xhold2808 _7060_/Q VGND VGND VPWR VPWR _5198_/A0 sky130_fd_sc_hd__dlygate4sd3_1
Xhold2819 _7068_/Q VGND VGND VPWR VPWR _5218_/A0 sky130_fd_sc_hd__dlygate4sd3_1
X_4142_ _4352_/C _4352_/A _3567_/A _4142_/B2 VGND VGND VPWR VPWR _4142_/X sky130_fd_sc_hd__o2bb2a_2
XFILLER_28_309 VGND VGND VPWR VPWR sky130_fd_sc_hd__decap_3
X_4073_ _4532_/B _4077_/D _7315_/Q VGND VGND VPWR VPWR _4533_/B sky130_fd_sc_hd__a21oi_2
XFILLER_24_526 VGND VGND VPWR VPWR sky130_fd_sc_hd__decap_3
XFILLER_24_537 VGND VGND VPWR VPWR sky130_fd_sc_hd__decap_3
XFILLER_36_386 VGND VGND VPWR VPWR sky130_fd_sc_hd__fill_1
XFILLER_70_109 VGND VGND VPWR VPWR sky130_fd_sc_hd__fill_2
XFILLER_24_548 VGND VGND VPWR VPWR sky130_fd_sc_hd__decap_3
XFILLER_51_334 VGND VGND VPWR VPWR sky130_fd_sc_hd__fill_2
X_4975_ _4975_/A0 _5221_/A1 _4998_/S VGND VGND VPWR VPWR _6957_/D sky130_fd_sc_hd__mux2_2
XFILLER_11_209 VGND VGND VPWR VPWR sky130_fd_sc_hd__decap_3
XFILLER_51_367 VGND VGND VPWR VPWR sky130_fd_sc_hd__decap_3
X_6714_ _5857_/X _6714_/A1 _6720_/S VGND VGND VPWR VPWR _7518_/D sky130_fd_sc_hd__mux2_2
X_3926_ _3990_/A1 _3901_/C _7364_/Q _3986_/B2 _7460_/Q VGND VGND VPWR VPWR _3926_/X
+ sky130_fd_sc_hd__a32o_2
XTAP_TAPCELL_ROW_62_874 VGND VPWR sky130_fd_sc_hd__tapvpwrvgnd_1
XTAP_TAPCELL_ROW_34_576 VGND VPWR sky130_fd_sc_hd__tapvpwrvgnd_1
XFILLER_32_581 VGND VGND VPWR VPWR sky130_fd_sc_hd__decap_3
Xclkload7 clkload7/A VGND VGND VPWR VPWR clkload7/X sky130_fd_sc_hd__clkbuf_4
X_6645_ _7485_/Q _5855_/X _6653_/S VGND VGND VPWR VPWR _7485_/D sky130_fd_sc_hd__mux2_2
X_3857_ _7466_/Q _3857_/A2 _3857_/B1 _7402_/Q _3856_/X VGND VGND VPWR VPWR _3859_/A
+ sky130_fd_sc_hd__a221oi_2
X_3788_ _6331_/B2 _3811_/A2 _3788_/B1 _7503_/Q VGND VGND VPWR VPWR _3790_/B sky130_fd_sc_hd__a22oi_2
XFILLER_3_419 VGND VGND VPWR VPWR sky130_fd_sc_hd__decap_3
XFILLER_1_9 VGND VGND VPWR VPWR sky130_fd_sc_hd__decap_3
XFILLER_99_581 VGND VGND VPWR VPWR sky130_fd_sc_hd__decap_3
X_5389_ _5389_/A0 _5694_/A1 _5391_/S VGND VGND VPWR VPWR _7134_/D sky130_fd_sc_hd__mux2_2
X_4409_ _4437_/B1 _4420_/B _4408_/X VGND VGND VPWR VPWR _4409_/Y sky130_fd_sc_hd__o21ai_2
X_7128_ _7490_/CLK _7128_/D VGND VGND VPWR VPWR _7128_/Q sky130_fd_sc_hd__dfxtp_2
XFILLER_59_478 VGND VGND VPWR VPWR sky130_fd_sc_hd__fill_2
X_7059_ _7575_/CLK _7059_/D VGND VGND VPWR VPWR _7059_/Q sky130_fd_sc_hd__dfxtp_2
XFILLER_27_320 VGND VGND VPWR VPWR sky130_fd_sc_hd__fill_1
XFILLER_42_323 VGND VGND VPWR VPWR sky130_fd_sc_hd__decap_3
XFILLER_54_183 VGND VGND VPWR VPWR sky130_fd_sc_hd__decap_3
XFILLER_30_529 VGND VGND VPWR VPWR sky130_fd_sc_hd__decap_3
XFILLER_42_356 VGND VGND VPWR VPWR sky130_fd_sc_hd__decap_3
XFILLER_24_63 VGND VGND VPWR VPWR sky130_fd_sc_hd__decap_3
XFILLER_24_85 VGND VGND VPWR VPWR sky130_fd_sc_hd__decap_3
XFILLER_10_253 VGND VGND VPWR VPWR sky130_fd_sc_hd__decap_3
XFILLER_10_297 VGND VGND VPWR VPWR sky130_fd_sc_hd__decap_3
XFILLER_40_95 VGND VGND VPWR VPWR sky130_fd_sc_hd__fill_1
XFILLER_6_279 VGND VGND VPWR VPWR sky130_fd_sc_hd__decap_3
XFILLER_69_209 VGND VGND VPWR VPWR sky130_fd_sc_hd__decap_3
XFILLER_1_12 VGND VGND VPWR VPWR sky130_fd_sc_hd__fill_2
XFILLER_77_264 VGND VGND VPWR VPWR sky130_fd_sc_hd__fill_1
XFILLER_37_139 VGND VGND VPWR VPWR sky130_fd_sc_hd__decap_3
XFILLER_18_331 VGND VGND VPWR VPWR sky130_fd_sc_hd__decap_3
XFILLER_92_245 VGND VGND VPWR VPWR sky130_fd_sc_hd__decap_3
XFILLER_21_529 VGND VGND VPWR VPWR sky130_fd_sc_hd__decap_3
XFILLER_60_197 VGND VGND VPWR VPWR sky130_fd_sc_hd__fill_2
X_4691_ _4691_/A1 _4613_/X _4667_/Y VGND VGND VPWR VPWR _4691_/X sky130_fd_sc_hd__a21o_2
X_3711_ _7416_/Q _3811_/A2 _3710_/X VGND VGND VPWR VPWR _3712_/B sky130_fd_sc_hd__a21oi_2
XTAP_TAPCELL_ROW_31_546 VGND VPWR sky130_fd_sc_hd__tapvpwrvgnd_1
X_6430_ _7181_/Q _6477_/A2 _7209_/Q _6473_/A1 VGND VGND VPWR VPWR _6430_/X sky130_fd_sc_hd__o22a_2
Xplace1903 _3429_/Y VGND VGND VPWR VPWR _4321_/B sky130_fd_sc_hd__buf_2
X_6361_ _6655_/A0 _6362_/A2 _6362_/A3 _6363_/B1 _7394_/Q VGND VGND VPWR VPWR _6361_/X
+ sky130_fd_sc_hd__a32o_2
XPHY_EDGE_ROW_49_Right_49 VGND VGND VPWR VPWR sky130_fd_sc_hd__decap_3
Xplace1936 _7425_/Q VGND VGND VPWR VPWR _6446_/A0 sky130_fd_sc_hd__buf_2
Xplace1925 _3445_/A VGND VGND VPWR VPWR _3460_/A sky130_fd_sc_hd__buf_4
Xplace1914 _3416_/Y VGND VGND VPWR VPWR _3476_/C1 sky130_fd_sc_hd__buf_2
X_5312_ _5312_/A0 _5312_/A1 _5331_/S VGND VGND VPWR VPWR _7099_/D sky130_fd_sc_hd__mux2_2
X_3573_ _3511_/Y _3573_/A2 _3481_/B VGND VGND VPWR VPWR _3573_/X sky130_fd_sc_hd__a21o_2
Xplace1969 _7298_/Q VGND VGND VPWR VPWR _4036_/A sky130_fd_sc_hd__buf_2
Xplace1958 _7358_/Q VGND VGND VPWR VPWR _6308_/B2 sky130_fd_sc_hd__buf_2
Xplace1947 _7374_/Q VGND VGND VPWR VPWR _6330_/B2 sky130_fd_sc_hd__buf_2
X_6292_ _6292_/A _6292_/B VGND VGND VPWR VPWR _7352_/D sky130_fd_sc_hd__and2_2
X_5243_ _5243_/A0 _4644_/X _5255_/S VGND VGND VPWR VPWR _7076_/D sky130_fd_sc_hd__mux2_2
XFILLER_68_220 VGND VGND VPWR VPWR sky130_fd_sc_hd__decap_3
Xhold2638 _7183_/Q VGND VGND VPWR VPWR _5496_/A0 sky130_fd_sc_hd__dlygate4sd3_1
Xhold2627 _7250_/Q VGND VGND VPWR VPWR _5642_/A0 sky130_fd_sc_hd__dlygate4sd3_1
Xhold2616 _7162_/Q VGND VGND VPWR VPWR _5450_/A0 sky130_fd_sc_hd__dlygate4sd3_1
Xhold2605 _7007_/Q VGND VGND VPWR VPWR _5083_/A0 sky130_fd_sc_hd__dlygate4sd3_1
XFILLER_68_253 VGND VGND VPWR VPWR sky130_fd_sc_hd__decap_3
Xhold2649 _7070_/Q VGND VGND VPWR VPWR _5224_/A0 sky130_fd_sc_hd__dlygate4sd3_1
X_4125_ _4125_/A VGND VGND VPWR VPWR _4125_/Y sky130_fd_sc_hd__inv_2
XFILLER_56_415 VGND VGND VPWR VPWR sky130_fd_sc_hd__decap_3
XFILLER_56_437 VGND VGND VPWR VPWR sky130_fd_sc_hd__decap_3
XTAP_TAPCELL_ROW_67_922 VGND VPWR sky130_fd_sc_hd__tapvpwrvgnd_1
XTAP_TAPCELL_ROW_39_635 VGND VPWR sky130_fd_sc_hd__tapvpwrvgnd_1
XPHY_EDGE_ROW_58_Right_58 VGND VGND VPWR VPWR sky130_fd_sc_hd__decap_3
X_4056_ _4056_/A _4059_/C VGND VGND VPWR VPWR _7598_/D sky130_fd_sc_hd__nor2_2
XFILLER_24_301 VGND VGND VPWR VPWR sky130_fd_sc_hd__decap_3
XFILLER_36_161 VGND VGND VPWR VPWR sky130_fd_sc_hd__decap_3
XFILLER_52_610 VGND VGND VPWR VPWR sky130_fd_sc_hd__fill_2
XFILLER_83_278 VGND VGND VPWR VPWR sky130_fd_sc_hd__fill_2
XFILLER_24_312 VGND VGND VPWR VPWR sky130_fd_sc_hd__decap_3
XFILLER_36_172 VGND VGND VPWR VPWR sky130_fd_sc_hd__fill_1
XFILLER_101_57 VGND VGND VPWR VPWR sky130_fd_sc_hd__fill_1
XFILLER_51_153 VGND VGND VPWR VPWR sky130_fd_sc_hd__decap_3
XFILLER_12_529 VGND VGND VPWR VPWR sky130_fd_sc_hd__decap_3
X_4958_ _4958_/A0 _4757_/Y _4958_/S VGND VGND VPWR VPWR _6952_/D sky130_fd_sc_hd__mux2_2
XFILLER_20_551 VGND VGND VPWR VPWR sky130_fd_sc_hd__decap_3
X_3909_ _7527_/Q _3909_/A2 _3865_/B _7495_/Q _3908_/X VGND VGND VPWR VPWR _3910_/B
+ sky130_fd_sc_hd__a221oi_2
X_6628_ _6628_/A0 _6201_/X _6638_/S VGND VGND VPWR VPWR _7477_/D sky130_fd_sc_hd__mux2_2
XPHY_EDGE_ROW_67_Right_67 VGND VGND VPWR VPWR sky130_fd_sc_hd__decap_3
X_6559_ _6559_/A1 _6347_/D _6559_/B1 _6559_/C1 _6559_/D1 VGND VGND VPWR VPWR _6559_/Y
+ sky130_fd_sc_hd__o2111ai_2
XFILLER_19_74 VGND VGND VPWR VPWR sky130_fd_sc_hd__decap_3
XFILLER_47_437 VGND VGND VPWR VPWR sky130_fd_sc_hd__decap_3
XFILLER_59_275 VGND VGND VPWR VPWR sky130_fd_sc_hd__decap_3
XFILLER_74_201 VGND VGND VPWR VPWR sky130_fd_sc_hd__fill_1
XPHY_EDGE_ROW_76_Right_76 VGND VGND VPWR VPWR sky130_fd_sc_hd__decap_3
XFILLER_19_139 VGND VGND VPWR VPWR sky130_fd_sc_hd__decap_3
XFILLER_27_161 VGND VGND VPWR VPWR sky130_fd_sc_hd__decap_3
XFILLER_27_172 VGND VGND VPWR VPWR sky130_fd_sc_hd__decap_3
XFILLER_15_367 VGND VGND VPWR VPWR sky130_fd_sc_hd__decap_3
XFILLER_42_186 VGND VGND VPWR VPWR sky130_fd_sc_hd__decap_3
XFILLER_42_197 VGND VGND VPWR VPWR sky130_fd_sc_hd__decap_3
XFILLER_7_533 VGND VGND VPWR VPWR sky130_fd_sc_hd__decap_3
XPHY_EDGE_ROW_85_Right_85 VGND VGND VPWR VPWR sky130_fd_sc_hd__decap_3
XTAP_TAPCELL_ROW_77_1028 VGND VPWR sky130_fd_sc_hd__tapvpwrvgnd_1
XFILLER_32_6 VGND VGND VPWR VPWR sky130_fd_sc_hd__fill_1
XFILLER_97_337 VGND VGND VPWR VPWR sky130_fd_sc_hd__decap_3
XPHY_EDGE_ROW_94_Right_94 VGND VGND VPWR VPWR sky130_fd_sc_hd__decap_3
XFILLER_76_80 VGND VGND VPWR VPWR sky130_fd_sc_hd__decap_3
XTAP_TAPCELL_ROW_88_1146 VGND VPWR sky130_fd_sc_hd__tapvpwrvgnd_1
XTAP_TAPCELL_ROW_0_208 VGND VPWR sky130_fd_sc_hd__tapvpwrvgnd_1
X_5930_ _5928_/X _5929_/X _6048_/A VGND VGND VPWR VPWR _5930_/Y sky130_fd_sc_hd__a21oi_2
XTAP_TAPCELL_ROW_36_605 VGND VPWR sky130_fd_sc_hd__tapvpwrvgnd_1
XTAP_TAPCELL_ROW_0_219 VGND VPWR sky130_fd_sc_hd__tapvpwrvgnd_1
XFILLER_18_194 VGND VGND VPWR VPWR sky130_fd_sc_hd__fill_2
X_7600_ _7606_/CLK _7600_/D place2050/X VGND VGND VPWR VPWR _7600_/Q sky130_fd_sc_hd__dfrtp_2
XFILLER_21_304 VGND VGND VPWR VPWR sky130_fd_sc_hd__decap_3
XFILLER_21_337 VGND VGND VPWR VPWR sky130_fd_sc_hd__decap_3
XFILLER_33_197 VGND VGND VPWR VPWR sky130_fd_sc_hd__decap_3
X_5792_ _6504_/B2 _6905_/Q _7241_/Q _5991_/B2 VGND VGND VPWR VPWR _5792_/X sky130_fd_sc_hd__o22a_2
XTAP_TAPCELL_ROW_72_980 VGND VPWR sky130_fd_sc_hd__tapvpwrvgnd_1
XTAP_TAPCELL_ROW_44_682 VGND VPWR sky130_fd_sc_hd__tapvpwrvgnd_1
X_7531_ _7611_/CLK _7531_/D place2059/X VGND VGND VPWR VPWR _7531_/Q sky130_fd_sc_hd__dfrtp_2
X_4743_ _4743_/A VGND VGND VPWR VPWR _4743_/Y sky130_fd_sc_hd__inv_2
XTAP_TAPCELL_ROW_16_395 VGND VPWR sky130_fd_sc_hd__tapvpwrvgnd_1
X_7462_ clkload4/A _7462_/D place2017/X VGND VGND VPWR VPWR _7462_/Q sky130_fd_sc_hd__dfrtp_2
X_4674_ _4676_/A0 _4726_/A2 _4726_/B1 VGND VGND VPWR VPWR _4674_/X sky130_fd_sc_hd__o21a_2
XTAP_TAPCELL_ROW_99_1264 VGND VPWR sky130_fd_sc_hd__tapvpwrvgnd_1
Xplace1700 _4905_/A VGND VGND VPWR VPWR _5427_/A sky130_fd_sc_hd__buf_2
Xplace1711 _5843_/A VGND VGND VPWR VPWR _4550_/S sky130_fd_sc_hd__buf_2
X_7393_ _7393_/CLK _7393_/D place2019/X VGND VGND VPWR VPWR _7393_/Q sky130_fd_sc_hd__dfrtp_2
X_3625_ _7541_/Q _3812_/A2 _3811_/A2 _7381_/Q VGND VGND VPWR VPWR _3631_/B sky130_fd_sc_hd__a22oi_2
Xplace1722 _3536_/B VGND VGND VPWR VPWR _3555_/B sky130_fd_sc_hd__buf_2
Xplace1733 _4237_/A VGND VGND VPWR VPWR _4294_/A2 sky130_fd_sc_hd__buf_2
Xplace1744 _3490_/X VGND VGND VPWR VPWR _4004_/A2 sky130_fd_sc_hd__buf_2
X_6344_ _7417_/Q _6344_/A2 _6344_/A3 _6344_/B1 _6344_/B2 VGND VGND VPWR VPWR _6344_/X
+ sky130_fd_sc_hd__a32o_2
X_3556_ _7421_/Q VGND VGND VPWR VPWR _3557_/A sky130_fd_sc_hd__inv_2
XTAP_TAPCELL_ROW_8_308 VGND VPWR sky130_fd_sc_hd__tapvpwrvgnd_1
XFILLER_0_219 VGND VGND VPWR VPWR sky130_fd_sc_hd__decap_3
Xplace1755 _3978_/B VGND VGND VPWR VPWR _6653_/S sky130_fd_sc_hd__buf_2
Xplace1766 _3863_/A2 VGND VGND VPWR VPWR _3904_/A2 sky130_fd_sc_hd__buf_2
Xplace1777 _3541_/A VGND VGND VPWR VPWR _4144_/A sky130_fd_sc_hd__buf_2
X_6275_ _6294_/A _6275_/B VGND VGND VPWR VPWR _7344_/D sky130_fd_sc_hd__and2_2
Xplace1799 _3842_/B VGND VGND VPWR VPWR _5839_/B1 sky130_fd_sc_hd__buf_2
Xplace1788 _6180_/A1 VGND VGND VPWR VPWR _6183_/A sky130_fd_sc_hd__buf_2
Xhold2413 _7145_/Q VGND VGND VPWR VPWR _5413_/A0 sky130_fd_sc_hd__dlygate4sd3_1
Xhold2402 _7184_/Q VGND VGND VPWR VPWR _5498_/A0 sky130_fd_sc_hd__dlygate4sd3_1
X_3487_ _3462_/B _3487_/B _3487_/C VGND VGND VPWR VPWR _3487_/Y sky130_fd_sc_hd__nand3b_2
Xhold2446 _7161_/Q VGND VGND VPWR VPWR _5448_/A0 sky130_fd_sc_hd__dlygate4sd3_1
Xhold2435 _7019_/Q VGND VGND VPWR VPWR _5110_/A0 sky130_fd_sc_hd__dlygate4sd3_1
Xhold2424 _7185_/Q VGND VGND VPWR VPWR _5501_/A0 sky130_fd_sc_hd__dlygate4sd3_1
Xhold2479 _6891_/Q VGND VGND VPWR VPWR _4823_/A0 sky130_fd_sc_hd__dlygate4sd3_1
Xhold2468 _7188_/Q VGND VGND VPWR VPWR _5507_/A0 sky130_fd_sc_hd__dlygate4sd3_1
Xhold2457 _6844_/Q VGND VGND VPWR VPWR _4590_/A0 sky130_fd_sc_hd__dlygate4sd3_1
X_4108_ _4108_/A VGND VGND VPWR VPWR _4108_/Y sky130_fd_sc_hd__inv_2
XFILLER_56_278 VGND VGND VPWR VPWR sky130_fd_sc_hd__decap_3
XFILLER_84_587 VGND VGND VPWR VPWR sky130_fd_sc_hd__fill_1
X_4039_ _7301_/Q _4043_/D VGND VGND VPWR VPWR _7591_/D sky130_fd_sc_hd__xor2_2
XFILLER_71_237 VGND VGND VPWR VPWR sky130_fd_sc_hd__decap_3
XFILLER_71_259 VGND VGND VPWR VPWR sky130_fd_sc_hd__decap_3
XFILLER_52_495 VGND VGND VPWR VPWR sky130_fd_sc_hd__fill_1
XFILLER_24_197 VGND VGND VPWR VPWR sky130_fd_sc_hd__decap_3
XFILLER_4_503 VGND VGND VPWR VPWR sky130_fd_sc_hd__decap_3
XFILLER_4_525 VGND VGND VPWR VPWR sky130_fd_sc_hd__decap_3
XFILLER_79_337 VGND VGND VPWR VPWR sky130_fd_sc_hd__decap_3
XFILLER_97_57 VGND VGND VPWR VPWR sky130_fd_sc_hd__fill_1
Xhold2980 _7470_/Q VGND VGND VPWR VPWR _6613_/A0 sky130_fd_sc_hd__dlygate4sd3_1
Xhold2991 _7524_/Q VGND VGND VPWR VPWR _6727_/A1 sky130_fd_sc_hd__dlygate4sd3_1
XFILLER_35_429 VGND VGND VPWR VPWR sky130_fd_sc_hd__decap_3
XFILLER_46_61 VGND VGND VPWR VPWR sky130_fd_sc_hd__fill_1
XFILLER_62_204 VGND VGND VPWR VPWR sky130_fd_sc_hd__fill_2
XFILLER_28_492 VGND VGND VPWR VPWR sky130_fd_sc_hd__decap_3
XFILLER_62_248 VGND VGND VPWR VPWR sky130_fd_sc_hd__decap_3
XFILLER_90_568 VGND VGND VPWR VPWR sky130_fd_sc_hd__decap_3
XFILLER_15_175 VGND VGND VPWR VPWR sky130_fd_sc_hd__fill_2
XFILLER_30_145 VGND VGND VPWR VPWR sky130_fd_sc_hd__decap_3
XTAP_TAPCELL_ROW_83_1098 VGND VPWR sky130_fd_sc_hd__tapvpwrvgnd_1
XFILLER_30_178 VGND VGND VPWR VPWR sky130_fd_sc_hd__decap_3
XTAP_TAPCELL_ROW_41_652 VGND VPWR sky130_fd_sc_hd__tapvpwrvgnd_1
XFILLER_7_330 VGND VGND VPWR VPWR sky130_fd_sc_hd__decap_3
X_3410_ _7296_/Q VGND VGND VPWR VPWR _3445_/A sky130_fd_sc_hd__inv_4
X_6060_ _7077_/Q _6449_/A2 _6449_/B1 _7105_/Q _6059_/X VGND VGND VPWR VPWR _6060_/X
+ sky130_fd_sc_hd__o221a_2
X_5011_ _5011_/A0 _5344_/A1 _5024_/S VGND VGND VPWR VPWR _6974_/D sky130_fd_sc_hd__mux2_2
XFILLER_38_223 VGND VGND VPWR VPWR sky130_fd_sc_hd__decap_3
XFILLER_38_234 VGND VGND VPWR VPWR sky130_fd_sc_hd__decap_3
XTAP_TAPCELL_ROW_49_741 VGND VPWR sky130_fd_sc_hd__tapvpwrvgnd_1
XFILLER_26_407 VGND VGND VPWR VPWR sky130_fd_sc_hd__decap_3
XFILLER_38_256 VGND VGND VPWR VPWR sky130_fd_sc_hd__fill_2
XFILLER_66_587 VGND VGND VPWR VPWR sky130_fd_sc_hd__fill_1
XFILLER_19_492 VGND VGND VPWR VPWR sky130_fd_sc_hd__fill_2
X_6962_ _7274_/CLK _6962_/D VGND VGND VPWR VPWR _6962_/Q sky130_fd_sc_hd__dfxtp_2
XFILLER_34_440 VGND VGND VPWR VPWR sky130_fd_sc_hd__fill_2
X_6893_ _7290_/CLK _6893_/D VGND VGND VPWR VPWR _6893_/Q sky130_fd_sc_hd__dfxtp_2
X_5913_ _6510_/A1 _7022_/Q _6938_/Q _6510_/B2 VGND VGND VPWR VPWR _5913_/X sky130_fd_sc_hd__o22a_2
XFILLER_34_473 VGND VGND VPWR VPWR sky130_fd_sc_hd__decap_3
X_5844_ _4675_/C _4675_/A _6404_/B1 _6440_/B1 VGND VGND VPWR VPWR _5844_/X sky130_fd_sc_hd__a31o_2
XFILLER_21_167 VGND VGND VPWR VPWR sky130_fd_sc_hd__fill_1
XFILLER_21_178 VGND VGND VPWR VPWR sky130_fd_sc_hd__decap_3
X_7514_ _7514_/CLK _7514_/D place2041/X VGND VGND VPWR VPWR _7514_/Q sky130_fd_sc_hd__dfrtp_2
X_5775_ _6453_/B1 _6977_/Q _6949_/Q _6450_/B2 VGND VGND VPWR VPWR _5775_/X sky130_fd_sc_hd__o22a_2
X_4726_ _3767_/Y _4726_/A2 _4726_/B1 VGND VGND VPWR VPWR _4726_/Y sky130_fd_sc_hd__o21ai_2
X_7445_ _7509_/CLK _7445_/D place2069/X VGND VGND VPWR VPWR _7445_/Q sky130_fd_sc_hd__dfrtp_2
X_7376_ _7514_/CLK _7376_/D place2040/X VGND VGND VPWR VPWR _7376_/Q sky130_fd_sc_hd__dfrtp_2
X_3608_ _7413_/Q _6662_/S _3607_/X VGND VGND VPWR VPWR _3670_/C sky130_fd_sc_hd__a21oi_2
Xplace1530 _4253_/C VGND VGND VPWR VPWR _4247_/B sky130_fd_sc_hd__buf_2
Xplace1541 _6560_/B VGND VGND VPWR VPWR _6179_/B sky130_fd_sc_hd__buf_2
Xplace1552 _3969_/A VGND VGND VPWR VPWR _4398_/A sky130_fd_sc_hd__buf_2
X_4588_ _5671_/A _5610_/B _5304_/B VGND VGND VPWR VPWR _4776_/S sky130_fd_sc_hd__and3_2
Xplace1563 _3938_/X VGND VGND VPWR VPWR _4143_/A sky130_fd_sc_hd__buf_4
Xplace1574 _4279_/C VGND VGND VPWR VPWR _3707_/C sky130_fd_sc_hd__buf_2
Xplace1585 _4237_/C VGND VGND VPWR VPWR _3738_/B sky130_fd_sc_hd__clkbuf_4
Xplace1596 _3628_/X VGND VGND VPWR VPWR _3983_/B sky130_fd_sc_hd__buf_8
X_3539_ _3441_/X _3539_/A2 _3568_/B _3539_/B2 VGND VGND VPWR VPWR _3539_/Y sky130_fd_sc_hd__o22ai_4
X_6258_ _6292_/A _6258_/B VGND VGND VPWR VPWR _7336_/D sky130_fd_sc_hd__and2_2
X_6189_ _6401_/B2 _7062_/Q _6866_/Q _6393_/B2 VGND VGND VPWR VPWR _6189_/X sky130_fd_sc_hd__o22a_2
X_5209_ _5209_/A0 _5726_/A1 _5211_/S VGND VGND VPWR VPWR _7065_/D sky130_fd_sc_hd__mux2_2
XFILLER_29_223 VGND VGND VPWR VPWR sky130_fd_sc_hd__fill_1
XFILLER_29_267 VGND VGND VPWR VPWR sky130_fd_sc_hd__decap_3
XPHY_EDGE_ROW_103_Left_207 VGND VGND VPWR VPWR sky130_fd_sc_hd__decap_3
XFILLER_16_53 VGND VGND VPWR VPWR sky130_fd_sc_hd__fill_1
XFILLER_25_440 VGND VGND VPWR VPWR sky130_fd_sc_hd__decap_3
XTAP_TAPCELL_ROW_55_799 VGND VPWR sky130_fd_sc_hd__tapvpwrvgnd_1
XFILLER_12_112 VGND VGND VPWR VPWR sky130_fd_sc_hd__decap_3
XFILLER_32_74 VGND VGND VPWR VPWR sky130_fd_sc_hd__fill_1
XTAP_TAPCELL_ROW_10_324 VGND VPWR sky130_fd_sc_hd__tapvpwrvgnd_1
XFILLER_32_85 VGND VGND VPWR VPWR sky130_fd_sc_hd__decap_3
XFILLER_95_605 VGND VGND VPWR VPWR sky130_fd_sc_hd__decap_3
XFILLER_0_550 VGND VGND VPWR VPWR sky130_fd_sc_hd__decap_3
XFILLER_0_561 VGND VGND VPWR VPWR sky130_fd_sc_hd__decap_3
XFILLER_75_340 VGND VGND VPWR VPWR sky130_fd_sc_hd__fill_1
XTAP_TAPCELL_ROW_85_1116 VGND VPWR sky130_fd_sc_hd__tapvpwrvgnd_1
XTAP_TAPCELL_ROW_46_711 VGND VPWR sky130_fd_sc_hd__tapvpwrvgnd_1
XTAP_TAPCELL_ROW_18_413 VGND VPWR sky130_fd_sc_hd__tapvpwrvgnd_1
XFILLER_35_248 VGND VGND VPWR VPWR sky130_fd_sc_hd__decap_3
XFILLER_63_579 VGND VGND VPWR VPWR sky130_fd_sc_hd__fill_1
XFILLER_50_207 VGND VGND VPWR VPWR sky130_fd_sc_hd__decap_3
XFILLER_31_421 VGND VGND VPWR VPWR sky130_fd_sc_hd__decap_3
X_3890_ _7398_/Q _4150_/A2 _3923_/B1 _7334_/Q _3889_/X VGND VGND VPWR VPWR _3896_/C
+ sky130_fd_sc_hd__a221o_2
XFILLER_31_498 VGND VGND VPWR VPWR sky130_fd_sc_hd__decap_3
X_4511_ _4550_/S _4509_/X _4510_/X VGND VGND VPWR VPWR _7311_/D sky130_fd_sc_hd__o21ai_2
XTAP_TAPCELL_ROW_96_1234 VGND VPWR sky130_fd_sc_hd__tapvpwrvgnd_1
X_7230_ _7288_/CLK _7230_/D VGND VGND VPWR VPWR _7230_/Q sky130_fd_sc_hd__dfxtp_2
X_4442_ _4561_/A1 _4379_/B _4448_/B _7303_/Q VGND VGND VPWR VPWR _4472_/A sky130_fd_sc_hd__a31o_2
X_7161_ _7217_/CLK _7161_/D VGND VGND VPWR VPWR _7161_/Q sky130_fd_sc_hd__dfxtp_2
X_4373_ _4448_/C _4373_/B _4373_/C VGND VGND VPWR VPWR _4379_/B sky130_fd_sc_hd__and3_2
X_7092_ _7280_/CLK _7092_/D VGND VGND VPWR VPWR _7092_/Q sky130_fd_sc_hd__dfxtp_2
X_6112_ _4200_/Y _6161_/A2 _6184_/B1 _6111_/X _6184_/C1 VGND VGND VPWR VPWR _6112_/X
+ sky130_fd_sc_hd__a221o_2
XFILLER_58_318 VGND VGND VPWR VPWR sky130_fd_sc_hd__decap_3
X_6043_ _6484_/B2 _7020_/Q _6936_/Q _6483_/B2 VGND VGND VPWR VPWR _6043_/X sky130_fd_sc_hd__o22a_2
XFILLER_39_587 VGND VGND VPWR VPWR sky130_fd_sc_hd__decap_3
XFILLER_26_237 VGND VGND VPWR VPWR sky130_fd_sc_hd__fill_1
XFILLER_54_524 VGND VGND VPWR VPWR sky130_fd_sc_hd__decap_3
XFILLER_81_343 VGND VGND VPWR VPWR sky130_fd_sc_hd__fill_1
X_6945_ _7279_/CLK _6945_/D VGND VGND VPWR VPWR _6945_/Q sky130_fd_sc_hd__dfxtp_2
XFILLER_22_410 VGND VGND VPWR VPWR sky130_fd_sc_hd__fill_1
XFILLER_34_270 VGND VGND VPWR VPWR sky130_fd_sc_hd__fill_2
XFILLER_22_421 VGND VGND VPWR VPWR sky130_fd_sc_hd__decap_3
X_6876_ _7264_/CLK _6876_/D VGND VGND VPWR VPWR _6876_/Q sky130_fd_sc_hd__dfxtp_2
XTAP_TAPCELL_ROW_52_769 VGND VPWR sky130_fd_sc_hd__tapvpwrvgnd_1
X_5827_ _7068_/Q _5488_/B _5671_/C _7040_/Q VGND VGND VPWR VPWR _5827_/X sky130_fd_sc_hd__a22o_2
XFILLER_22_498 VGND VGND VPWR VPWR sky130_fd_sc_hd__decap_3
X_4709_ _4709_/A0 _5342_/A1 _4759_/S VGND VGND VPWR VPWR _6861_/D sky130_fd_sc_hd__mux2_2
X_7428_ clkload8/A _7428_/D place2017/X VGND VGND VPWR VPWR _7428_/Q sky130_fd_sc_hd__dfrtp_2
Xplace2061 place2062/X VGND VGND VPWR VPWR place2061/X sky130_fd_sc_hd__buf_2
Xplace2050 place2052/X VGND VGND VPWR VPWR place2050/X sky130_fd_sc_hd__buf_2
XFILLER_78_37 VGND VGND VPWR VPWR sky130_fd_sc_hd__fill_1
Xplace1360 _4245_/Y VGND VGND VPWR VPWR _4249_/C sky130_fd_sc_hd__buf_2
Xplace1371 _4192_/B VGND VGND VPWR VPWR _3887_/D sky130_fd_sc_hd__buf_2
X_7359_ clkload8/A _7359_/D place2026/X VGND VGND VPWR VPWR _7359_/Q sky130_fd_sc_hd__dfrtp_2
XFILLER_103_231 VGND VGND VPWR VPWR sky130_fd_sc_hd__fill_1
XFILLER_1_347 VGND VGND VPWR VPWR sky130_fd_sc_hd__fill_2
XFILLER_1_358 VGND VGND VPWR VPWR sky130_fd_sc_hd__fill_2
Xplace1393 _4582_/B VGND VGND VPWR VPWR _4970_/C sky130_fd_sc_hd__buf_2
XFILLER_103_253 VGND VGND VPWR VPWR sky130_fd_sc_hd__fill_2
XFILLER_57_362 VGND VGND VPWR VPWR sky130_fd_sc_hd__decap_3
XFILLER_17_215 VGND VGND VPWR VPWR sky130_fd_sc_hd__decap_3
XFILLER_45_524 VGND VGND VPWR VPWR sky130_fd_sc_hd__fill_2
XFILLER_27_85 VGND VGND VPWR VPWR sky130_fd_sc_hd__decap_3
XFILLER_72_376 VGND VGND VPWR VPWR sky130_fd_sc_hd__decap_3
XFILLER_25_281 VGND VGND VPWR VPWR sky130_fd_sc_hd__decap_3
XFILLER_43_73 VGND VGND VPWR VPWR sky130_fd_sc_hd__decap_3
XTAP_TAPCELL_ROW_80_1068 VGND VPWR sky130_fd_sc_hd__tapvpwrvgnd_1
XFILLER_40_295 VGND VGND VPWR VPWR sky130_fd_sc_hd__decap_3
XFILLER_43_95 VGND VGND VPWR VPWR sky130_fd_sc_hd__decap_3
XTAP_TAPCELL_ROW_23_460 VGND VPWR sky130_fd_sc_hd__tapvpwrvgnd_1
XFILLER_4_141 VGND VGND VPWR VPWR sky130_fd_sc_hd__decap_3
XFILLER_95_413 VGND VGND VPWR VPWR sky130_fd_sc_hd__decap_3
XTAP_TAPCELL_ROW_91_1175 VGND VPWR sky130_fd_sc_hd__tapvpwrvgnd_1
XFILLER_48_362 VGND VGND VPWR VPWR sky130_fd_sc_hd__fill_2
XFILLER_83_608 VGND VGND VPWR VPWR sky130_fd_sc_hd__decap_3
XFILLER_36_579 VGND VGND VPWR VPWR sky130_fd_sc_hd__decap_3
XFILLER_63_343 VGND VGND VPWR VPWR sky130_fd_sc_hd__decap_3
XFILLER_63_365 VGND VGND VPWR VPWR sky130_fd_sc_hd__fill_1
XFILLER_16_281 VGND VGND VPWR VPWR sky130_fd_sc_hd__fill_2
X_3942_ _3931_/X _3935_/Y _3941_/X VGND VGND VPWR VPWR _3944_/A sky130_fd_sc_hd__o21ai_2
XFILLER_31_240 VGND VGND VPWR VPWR sky130_fd_sc_hd__decap_3
X_3873_ _5850_/B _3946_/B _3867_/Y _3870_/Y _3872_/Y VGND VGND VPWR VPWR _4192_/A
+ sky130_fd_sc_hd__o41a_2
XFILLER_31_284 VGND VGND VPWR VPWR sky130_fd_sc_hd__decap_3
X_6592_ _6592_/A0 _6017_/X _6600_/S VGND VGND VPWR VPWR _7460_/D sky130_fd_sc_hd__mux2_2
X_5612_ _5612_/A0 _5612_/A1 _5637_/S VGND VGND VPWR VPWR _7236_/D sky130_fd_sc_hd__mux2_2
X_5543_ _5543_/A0 _4763_/Y _5545_/S VGND VGND VPWR VPWR _7205_/D sky130_fd_sc_hd__mux2_2
XTAP_TAPCELL_ROW_100_1271 VGND VPWR sky130_fd_sc_hd__tapvpwrvgnd_1
X_5474_ _5474_/A0 _5718_/A1 _5486_/S VGND VGND VPWR VPWR _7173_/D sky130_fd_sc_hd__mux2_2
X_7213_ _7241_/CLK _7213_/D VGND VGND VPWR VPWR _7213_/Q sky130_fd_sc_hd__dfxtp_2
X_4425_ _4424_/Y _6733_/A1 _4452_/S VGND VGND VPWR VPWR _7301_/D sky130_fd_sc_hd__mux2_2
X_7144_ _7575_/CLK _7144_/D VGND VGND VPWR VPWR _7144_/Q sky130_fd_sc_hd__dfxtp_2
X_4356_ _4448_/A _4437_/A2 _4437_/A3 _4356_/B1 _6302_/B VGND VGND VPWR VPWR _4356_/X
+ sky130_fd_sc_hd__a32o_2
X_7075_ _7273_/CLK _7075_/D VGND VGND VPWR VPWR _7075_/Q sky130_fd_sc_hd__dfxtp_2
X_4287_ _4287_/A _4287_/B _4287_/C VGND VGND VPWR VPWR _4287_/X sky130_fd_sc_hd__and3_2
XFILLER_73_107 VGND VGND VPWR VPWR sky130_fd_sc_hd__fill_1
XTAP_TAPCELL_ROW_57_817 VGND VPWR sky130_fd_sc_hd__tapvpwrvgnd_1
XFILLER_100_289 VGND VGND VPWR VPWR sky130_fd_sc_hd__fill_2
XFILLER_27_524 VGND VGND VPWR VPWR sky130_fd_sc_hd__decap_3
XFILLER_42_516 VGND VGND VPWR VPWR sky130_fd_sc_hd__decap_3
X_6928_ _7264_/CLK _6928_/D VGND VGND VPWR VPWR _6928_/Q sky130_fd_sc_hd__dfxtp_2
X_6859_ _7114_/CLK _6859_/D VGND VGND VPWR VPWR _6859_/Q sky130_fd_sc_hd__dfxtp_2
XFILLER_13_32 VGND VGND VPWR VPWR sky130_fd_sc_hd__decap_3
XFILLER_50_593 VGND VGND VPWR VPWR sky130_fd_sc_hd__fill_1
XFILLER_6_417 VGND VGND VPWR VPWR sky130_fd_sc_hd__decap_3
XTAP_TAPCELL_ROW_20_430 VGND VPWR sky130_fd_sc_hd__tapvpwrvgnd_1
XFILLER_1_111 VGND VGND VPWR VPWR sky130_fd_sc_hd__fill_1
XFILLER_1_133 VGND VGND VPWR VPWR sky130_fd_sc_hd__decap_3
XFILLER_8_3 VGND VGND VPWR VPWR sky130_fd_sc_hd__decap_3
Xplace1190 _5302_/S VGND VGND VPWR VPWR _5293_/S sky130_fd_sc_hd__buf_2
Xrebuffer2180 _4638_/Y VGND VGND VPWR VPWR _4639_/A1 sky130_fd_sc_hd__buf_4
Xrebuffer2191 _3536_/C VGND VGND VPWR VPWR _3628_/B1 sky130_fd_sc_hd__buf_2
XFILLER_49_137 VGND VGND VPWR VPWR sky130_fd_sc_hd__fill_1
XFILLER_77_457 VGND VGND VPWR VPWR sky130_fd_sc_hd__fill_2
XFILLER_18_502 VGND VGND VPWR VPWR sky130_fd_sc_hd__decap_3
XFILLER_45_321 VGND VGND VPWR VPWR sky130_fd_sc_hd__decap_3
XFILLER_45_354 VGND VGND VPWR VPWR sky130_fd_sc_hd__decap_3
XFILLER_57_181 VGND VGND VPWR VPWR sky130_fd_sc_hd__decap_3
XFILLER_33_505 VGND VGND VPWR VPWR sky130_fd_sc_hd__decap_3
XFILLER_54_50 VGND VGND VPWR VPWR sky130_fd_sc_hd__decap_3
XFILLER_33_549 VGND VGND VPWR VPWR sky130_fd_sc_hd__fill_2
XFILLER_54_83 VGND VGND VPWR VPWR sky130_fd_sc_hd__fill_1
XFILLER_13_240 VGND VGND VPWR VPWR sky130_fd_sc_hd__decap_3
XFILLER_41_582 VGND VGND VPWR VPWR sky130_fd_sc_hd__decap_3
XFILLER_9_211 VGND VGND VPWR VPWR sky130_fd_sc_hd__decap_3
XFILLER_62_6 VGND VGND VPWR VPWR sky130_fd_sc_hd__fill_1
Xclkload25 _7272_/CLK VGND VGND VPWR VPWR clkload25/X sky130_fd_sc_hd__clkbuf_4
Xclkload14 _7542_/CLK VGND VGND VPWR VPWR clkload14/Y sky130_fd_sc_hd__inv_6
Xclkload36 _7279_/CLK VGND VGND VPWR VPWR clkload36/X sky130_fd_sc_hd__clkbuf_4
XTAP_TAPCELL_ROW_93_1204 VGND VPWR sky130_fd_sc_hd__tapvpwrvgnd_1
XFILLER_5_461 VGND VGND VPWR VPWR sky130_fd_sc_hd__fill_1
Xhold2809 _7284_/Q VGND VGND VPWR VPWR _5715_/A0 sky130_fd_sc_hd__dlygate4sd3_1
X_5190_ _5190_/A0 _5190_/A1 _5207_/S VGND VGND VPWR VPWR _7056_/D sky130_fd_sc_hd__mux2_2
X_4141_ _7297_/Q _5850_/B _3935_/Y VGND VGND VPWR VPWR _4141_/Y sky130_fd_sc_hd__a21oi_2
XFILLER_83_449 VGND VGND VPWR VPWR sky130_fd_sc_hd__fill_2
XFILLER_95_298 VGND VGND VPWR VPWR sky130_fd_sc_hd__fill_2
XFILLER_36_321 VGND VGND VPWR VPWR sky130_fd_sc_hd__decap_3
XFILLER_36_354 VGND VGND VPWR VPWR sky130_fd_sc_hd__decap_3
XFILLER_48_181 VGND VGND VPWR VPWR sky130_fd_sc_hd__decap_3
XFILLER_76_490 VGND VGND VPWR VPWR sky130_fd_sc_hd__decap_3
XFILLER_63_151 VGND VGND VPWR VPWR sky130_fd_sc_hd__fill_1
XFILLER_63_162 VGND VGND VPWR VPWR sky130_fd_sc_hd__decap_3
XFILLER_51_324 VGND VGND VPWR VPWR sky130_fd_sc_hd__fill_2
X_3925_ _7428_/Q _3934_/B1 _4007_/B1 _7396_/Q VGND VGND VPWR VPWR _3928_/A sky130_fd_sc_hd__a22oi_2
XTAP_TAPCELL_ROW_62_875 VGND VPWR sky130_fd_sc_hd__tapvpwrvgnd_1
XTAP_TAPCELL_ROW_34_577 VGND VPWR sky130_fd_sc_hd__tapvpwrvgnd_1
Xclkload8 clkload8/A VGND VGND VPWR VPWR clkload8/Y sky130_fd_sc_hd__inv_6
X_3856_ _7370_/Q _3544_/B _3544_/C _3984_/B1 _7530_/Q VGND VGND VPWR VPWR _3856_/X
+ sky130_fd_sc_hd__a32o_2
X_6575_ _6575_/A0 _5846_/X _6590_/S VGND VGND VPWR VPWR _7452_/D sky130_fd_sc_hd__mux2_2
X_3787_ _7439_/Q _3810_/B1 _3812_/B1 _7471_/Q VGND VGND VPWR VPWR _3787_/X sky130_fd_sc_hd__a22o_2
X_5526_ _5526_/A0 _4707_/X _5532_/S VGND VGND VPWR VPWR _7197_/D sky130_fd_sc_hd__mux2_2
X_5457_ _5457_/A0 _4677_/X _5471_/S VGND VGND VPWR VPWR _7165_/D sky130_fd_sc_hd__mux2_2
X_4408_ _4402_/Y _4439_/D _4408_/C _4408_/D VGND VGND VPWR VPWR _4408_/X sky130_fd_sc_hd__and4b_2
XFILLER_86_232 VGND VGND VPWR VPWR sky130_fd_sc_hd__decap_3
X_7127_ _7266_/CLK _7127_/D VGND VGND VPWR VPWR _7127_/Q sky130_fd_sc_hd__dfxtp_2
X_4339_ _3429_/B _4337_/X _4338_/X _4315_/X VGND VGND VPWR VPWR _4345_/A sky130_fd_sc_hd__o22ai_2
X_7058_ _7114_/CLK _7058_/D VGND VGND VPWR VPWR _7058_/Q sky130_fd_sc_hd__dfxtp_2
XFILLER_46_129 VGND VGND VPWR VPWR sky130_fd_sc_hd__decap_3
X_6009_ _5304_/B _6005_/Y _6008_/Y VGND VGND VPWR VPWR _6010_/A sky130_fd_sc_hd__a21oi_2
XFILLER_15_505 VGND VGND VPWR VPWR sky130_fd_sc_hd__decap_3
XFILLER_54_162 VGND VGND VPWR VPWR sky130_fd_sc_hd__fill_1
XFILLER_54_195 VGND VGND VPWR VPWR sky130_fd_sc_hd__fill_1
XFILLER_91_26 VGND VGND VPWR VPWR sky130_fd_sc_hd__fill_2
XFILLER_42_368 VGND VGND VPWR VPWR sky130_fd_sc_hd__decap_3
XFILLER_23_593 VGND VGND VPWR VPWR sky130_fd_sc_hd__fill_2
XFILLER_24_97 VGND VGND VPWR VPWR sky130_fd_sc_hd__decap_3
XFILLER_10_265 VGND VGND VPWR VPWR sky130_fd_sc_hd__decap_3
XFILLER_40_85 VGND VGND VPWR VPWR sky130_fd_sc_hd__decap_3
XFILLER_49_94 VGND VGND VPWR VPWR sky130_fd_sc_hd__decap_3
XFILLER_77_254 VGND VGND VPWR VPWR sky130_fd_sc_hd__fill_2
XTAP_TAPCELL_ROW_5_280 VGND VPWR sky130_fd_sc_hd__tapvpwrvgnd_1
XFILLER_18_321 VGND VGND VPWR VPWR sky130_fd_sc_hd__decap_3
XFILLER_1_57 VGND VGND VPWR VPWR sky130_fd_sc_hd__decap_3
XFILLER_18_365 VGND VGND VPWR VPWR sky130_fd_sc_hd__decap_3
XFILLER_80_419 VGND VGND VPWR VPWR sky130_fd_sc_hd__fill_1
XFILLER_33_313 VGND VGND VPWR VPWR sky130_fd_sc_hd__decap_3
XFILLER_21_508 VGND VGND VPWR VPWR sky130_fd_sc_hd__decap_3
XFILLER_33_379 VGND VGND VPWR VPWR sky130_fd_sc_hd__decap_3
X_3710_ _7448_/Q _3793_/A2 _3781_/B1 _7352_/Q _3709_/X VGND VGND VPWR VPWR _3710_/X
+ sky130_fd_sc_hd__a221o_2
X_4690_ _4675_/A _4675_/B _4675_/C _4691_/A1 VGND VGND VPWR VPWR _4690_/X sky130_fd_sc_hd__a31o_2
XTAP_TAPCELL_ROW_31_547 VGND VPWR sky130_fd_sc_hd__tapvpwrvgnd_1
X_3641_ _7508_/Q _3725_/A2 _3757_/B1 _7444_/Q VGND VGND VPWR VPWR _3647_/A sky130_fd_sc_hd__a22oi_2
XFILLER_60_3 VGND VGND VPWR VPWR sky130_fd_sc_hd__fill_2
X_6360_ _6653_/A0 _6362_/A2 _6362_/A3 _6363_/B1 _7393_/Q VGND VGND VPWR VPWR _6360_/X
+ sky130_fd_sc_hd__a32o_2
X_3572_ _4146_/A1 _3653_/A1 _3572_/A3 _3557_/B _3557_/A VGND VGND VPWR VPWR _3572_/X
+ sky130_fd_sc_hd__a311o_2
Xplace1926 _3409_/Y VGND VGND VPWR VPWR _4473_/C sky130_fd_sc_hd__buf_2
Xplace1915 _3416_/Y VGND VGND VPWR VPWR _3522_/A1 sky130_fd_sc_hd__buf_2
Xplace1904 _3459_/B VGND VGND VPWR VPWR _3525_/A2 sky130_fd_sc_hd__buf_2
Xplace1959 _7357_/Q VGND VGND VPWR VPWR _6307_/B2 sky130_fd_sc_hd__buf_2
Xplace1948 _7373_/Q VGND VGND VPWR VPWR _6329_/B2 sky130_fd_sc_hd__buf_2
Xplace1937 _7423_/Q VGND VGND VPWR VPWR _6442_/A0 sky130_fd_sc_hd__buf_2
Xhold2628 _7212_/Q VGND VGND VPWR VPWR _5559_/A0 sky130_fd_sc_hd__dlygate4sd3_1
Xhold2617 _7186_/Q VGND VGND VPWR VPWR _5503_/A0 sky130_fd_sc_hd__dlygate4sd3_1
Xhold2606 _7268_/Q VGND VGND VPWR VPWR _5681_/A0 sky130_fd_sc_hd__dlygate4sd3_1
X_5173_ _5173_/A0 _4644_/X _5179_/S VGND VGND VPWR VPWR _7048_/D sky130_fd_sc_hd__mux2_2
XFILLER_29_608 VGND VGND VPWR VPWR sky130_fd_sc_hd__decap_3
XFILLER_68_265 VGND VGND VPWR VPWR sky130_fd_sc_hd__decap_3
Xhold2639 _6991_/Q VGND VGND VPWR VPWR _5049_/A0 sky130_fd_sc_hd__dlygate4sd3_1
XFILLER_56_427 VGND VGND VPWR VPWR sky130_fd_sc_hd__fill_2
XFILLER_83_202 VGND VGND VPWR VPWR sky130_fd_sc_hd__fill_1
XTAP_TAPCELL_ROW_67_923 VGND VPWR sky130_fd_sc_hd__tapvpwrvgnd_1
X_4055_ _4495_/A _7308_/Q _4055_/C VGND VGND VPWR VPWR _4059_/C sky130_fd_sc_hd__and3_2
XTAP_TAPCELL_ROW_39_636 VGND VPWR sky130_fd_sc_hd__tapvpwrvgnd_1
XFILLER_36_184 VGND VGND VPWR VPWR sky130_fd_sc_hd__decap_3
XFILLER_91_290 VGND VGND VPWR VPWR sky130_fd_sc_hd__fill_2
XFILLER_20_530 VGND VGND VPWR VPWR sky130_fd_sc_hd__fill_2
XFILLER_32_390 VGND VGND VPWR VPWR sky130_fd_sc_hd__decap_3
X_3908_ _3990_/A1 _3901_/C _7367_/Q _3908_/B1 _7463_/Q VGND VGND VPWR VPWR _3908_/X
+ sky130_fd_sc_hd__a32o_2
XFILLER_20_563 VGND VGND VPWR VPWR sky130_fd_sc_hd__decap_3
X_3839_ _7305_/Q _3860_/A2 _3836_/X _3838_/X VGND VGND VPWR VPWR _3850_/A sky130_fd_sc_hd__a211o_4
XFILLER_3_228 VGND VGND VPWR VPWR sky130_fd_sc_hd__decap_3
X_6489_ _6489_/A1 _4132_/X _4134_/Y _6489_/A4 _6488_/Y VGND VGND VPWR VPWR _6489_/X
+ sky130_fd_sc_hd__a41o_2
X_5509_ _5509_/A0 _5570_/A1 _5545_/S VGND VGND VPWR VPWR _7189_/D sky130_fd_sc_hd__mux2_2
XFILLER_59_254 VGND VGND VPWR VPWR sky130_fd_sc_hd__decap_3
XFILLER_19_53 VGND VGND VPWR VPWR sky130_fd_sc_hd__decap_3
Xclkbuf_leaf_39_clk clkbuf_3_2__f_clk/X VGND VGND VPWR VPWR _7610_/CLK sky130_fd_sc_hd__clkbuf_16
XFILLER_43_600 VGND VGND VPWR VPWR sky130_fd_sc_hd__fill_1
XFILLER_15_324 VGND VGND VPWR VPWR sky130_fd_sc_hd__decap_3
XFILLER_27_184 VGND VGND VPWR VPWR sky130_fd_sc_hd__decap_3
XFILLER_35_74 VGND VGND VPWR VPWR sky130_fd_sc_hd__decap_3
XFILLER_30_327 VGND VGND VPWR VPWR sky130_fd_sc_hd__decap_3
XFILLER_7_589 VGND VGND VPWR VPWR sky130_fd_sc_hd__decap_3
XTAP_TAPCELL_ROW_77_1029 VGND VPWR sky130_fd_sc_hd__tapvpwrvgnd_1
XFILLER_78_541 VGND VGND VPWR VPWR sky130_fd_sc_hd__fill_2
XFILLER_65_213 VGND VGND VPWR VPWR sky130_fd_sc_hd__fill_1
XTAP_TAPCELL_ROW_88_1147 VGND VPWR sky130_fd_sc_hd__tapvpwrvgnd_1
XTAP_TAPCELL_ROW_0_209 VGND VPWR sky130_fd_sc_hd__tapvpwrvgnd_1
XTAP_TAPCELL_ROW_36_606 VGND VPWR sky130_fd_sc_hd__tapvpwrvgnd_1
X_5860_ _6229_/A1 _6229_/A2 _6229_/B1 _7583_/Q VGND VGND VPWR VPWR _5860_/X sky130_fd_sc_hd__o22a_2
X_4811_ _4811_/A0 _5701_/A1 _4834_/S VGND VGND VPWR VPWR _6885_/D sky130_fd_sc_hd__mux2_2
XTAP_TAPCELL_ROW_72_981 VGND VPWR sky130_fd_sc_hd__tapvpwrvgnd_1
XTAP_TAPCELL_ROW_44_683 VGND VPWR sky130_fd_sc_hd__tapvpwrvgnd_1
X_7530_ _7611_/CLK _7530_/D place2059/X VGND VGND VPWR VPWR _7530_/Q sky130_fd_sc_hd__dfrtp_2
XTAP_TAPCELL_ROW_16_396 VGND VPWR sky130_fd_sc_hd__tapvpwrvgnd_1
X_7461_ clkload8/A _7461_/D place2017/X VGND VGND VPWR VPWR _7461_/Q sky130_fd_sc_hd__dfrtp_2
X_6412_ _7515_/Q _6412_/A2 _6412_/A3 _6412_/B1 _6412_/B2 VGND VGND VPWR VPWR _6412_/X
+ sky130_fd_sc_hd__a32o_2
XTAP_TAPCELL_ROW_99_1265 VGND VPWR sky130_fd_sc_hd__tapvpwrvgnd_1
Xplace1701 _6404_/A2 VGND VGND VPWR VPWR _4757_/A1 sky130_fd_sc_hd__buf_2
X_7392_ _7581_/CLK _7392_/D place2019/X VGND VGND VPWR VPWR _7392_/Q sky130_fd_sc_hd__dfrtp_2
Xplace1712 _5843_/A VGND VGND VPWR VPWR _5732_/S sky130_fd_sc_hd__buf_2
Xplace1723 _3536_/B VGND VGND VPWR VPWR _3575_/A1 sky130_fd_sc_hd__buf_6
Xplace1734 _3698_/B VGND VGND VPWR VPWR _4237_/A sky130_fd_sc_hd__clkbuf_4
Xplace1745 _4576_/B1 VGND VGND VPWR VPWR _3923_/A2 sky130_fd_sc_hd__buf_2
X_6343_ _7416_/Q _6344_/A2 _6344_/A3 _6344_/B1 _6343_/B2 VGND VGND VPWR VPWR _6343_/X
+ sky130_fd_sc_hd__a32o_2
X_3555_ _3561_/B _3555_/B VGND VGND VPWR VPWR _3555_/Y sky130_fd_sc_hd__nand2_2
XTAP_TAPCELL_ROW_8_309 VGND VPWR sky130_fd_sc_hd__tapvpwrvgnd_1
Xplace1756 _3478_/Y VGND VGND VPWR VPWR _3978_/B sky130_fd_sc_hd__buf_4
Xplace1767 _6513_/B1 VGND VGND VPWR VPWR _6226_/B1 sky130_fd_sc_hd__buf_2
Xplace1778 _6220_/A1 VGND VGND VPWR VPWR _6219_/A1 sky130_fd_sc_hd__buf_2
X_3486_ _7292_/Q _3487_/B _3487_/C VGND VGND VPWR VPWR _3486_/X sky130_fd_sc_hd__a21o_2
Xplace1789 _4146_/A1 VGND VGND VPWR VPWR _6180_/A1 sky130_fd_sc_hd__buf_2
Xhold2403 _7153_/Q VGND VGND VPWR VPWR _5431_/A0 sky130_fd_sc_hd__dlygate4sd3_1
Xhold2436 _7235_/Q VGND VGND VPWR VPWR _5608_/A0 sky130_fd_sc_hd__dlygate4sd3_1
Xhold2425 _6943_/Q VGND VGND VPWR VPWR _4939_/A0 sky130_fd_sc_hd__dlygate4sd3_1
Xhold2414 _7062_/Q VGND VGND VPWR VPWR _5203_/A0 sky130_fd_sc_hd__dlygate4sd3_1
XFILLER_29_405 VGND VGND VPWR VPWR sky130_fd_sc_hd__decap_3
XFILLER_29_427 VGND VGND VPWR VPWR sky130_fd_sc_hd__decap_3
XFILLER_56_18 VGND VGND VPWR VPWR sky130_fd_sc_hd__fill_1
XFILLER_96_371 VGND VGND VPWR VPWR sky130_fd_sc_hd__fill_1
XPHY_EDGE_ROW_16_Left_120 VGND VGND VPWR VPWR sky130_fd_sc_hd__decap_3
Xhold2469 _7187_/Q VGND VGND VPWR VPWR _5505_/A0 sky130_fd_sc_hd__dlygate4sd3_1
Xhold2458 _7086_/Q VGND VGND VPWR VPWR _5274_/A0 sky130_fd_sc_hd__dlygate4sd3_1
Xhold2447 _7205_/Q VGND VGND VPWR VPWR _5543_/A0 sky130_fd_sc_hd__dlygate4sd3_1
X_5156_ _5156_/A0 _5673_/A1 _5181_/S VGND VGND VPWR VPWR _7040_/D sky130_fd_sc_hd__mux2_2
XFILLER_29_449 VGND VGND VPWR VPWR sky130_fd_sc_hd__decap_3
X_5087_ _5087_/A0 _5296_/A1 _5089_/S VGND VGND VPWR VPWR _7009_/D sky130_fd_sc_hd__mux2_2
X_4038_ _4043_/D _4038_/B VGND VGND VPWR VPWR _7590_/D sky130_fd_sc_hd__nor2_2
XFILLER_71_249 VGND VGND VPWR VPWR sky130_fd_sc_hd__fill_2
XFILLER_24_132 VGND VGND VPWR VPWR sky130_fd_sc_hd__decap_3
XFILLER_12_316 VGND VGND VPWR VPWR sky130_fd_sc_hd__fill_1
XFILLER_52_474 VGND VGND VPWR VPWR sky130_fd_sc_hd__fill_2
X_5989_ _5989_/A _5989_/B VGND VGND VPWR VPWR _5989_/Y sky130_fd_sc_hd__nand2_2
XFILLER_8_309 VGND VGND VPWR VPWR sky130_fd_sc_hd__decap_3
XANTENNA_50 _7056_/Q VGND VGND VPWR VPWR sky130_fd_sc_hd__diode_2
XFILLER_47_202 VGND VGND VPWR VPWR sky130_fd_sc_hd__fill_1
Xhold2970 _7449_/Q VGND VGND VPWR VPWR _6567_/A0 sky130_fd_sc_hd__dlygate4sd3_1
Xhold2981 _7500_/Q VGND VGND VPWR VPWR _6677_/A0 sky130_fd_sc_hd__dlygate4sd3_1
Xhold2992 _7527_/Q VGND VGND VPWR VPWR _6733_/A1 sky130_fd_sc_hd__dlygate4sd3_1
XFILLER_28_460 VGND VGND VPWR VPWR sky130_fd_sc_hd__decap_3
XFILLER_47_268 VGND VGND VPWR VPWR sky130_fd_sc_hd__fill_1
XFILLER_15_110 VGND VGND VPWR VPWR sky130_fd_sc_hd__fill_2
XFILLER_62_216 VGND VGND VPWR VPWR sky130_fd_sc_hd__decap_3
XFILLER_15_143 VGND VGND VPWR VPWR sky130_fd_sc_hd__decap_3
XFILLER_55_290 VGND VGND VPWR VPWR sky130_fd_sc_hd__fill_2
XFILLER_15_187 VGND VGND VPWR VPWR sky130_fd_sc_hd__decap_3
XFILLER_30_102 VGND VGND VPWR VPWR sky130_fd_sc_hd__decap_3
XFILLER_43_474 VGND VGND VPWR VPWR sky130_fd_sc_hd__decap_3
XFILLER_70_282 VGND VGND VPWR VPWR sky130_fd_sc_hd__decap_3
XTAP_TAPCELL_ROW_83_1099 VGND VPWR sky130_fd_sc_hd__tapvpwrvgnd_1
XTAP_TAPCELL_ROW_41_653 VGND VPWR sky130_fd_sc_hd__tapvpwrvgnd_1
XTAP_TAPCELL_ROW_13_355 VGND VPWR sky130_fd_sc_hd__tapvpwrvgnd_1
XFILLER_11_393 VGND VGND VPWR VPWR sky130_fd_sc_hd__fill_2
XFILLER_7_78 VGND VGND VPWR VPWR sky130_fd_sc_hd__decap_3
XFILLER_7_397 VGND VGND VPWR VPWR sky130_fd_sc_hd__fill_2
XFILLER_97_113 VGND VGND VPWR VPWR sky130_fd_sc_hd__fill_1
XFILLER_100_608 VGND VGND VPWR VPWR sky130_fd_sc_hd__decap_3
XFILLER_23_3 VGND VGND VPWR VPWR sky130_fd_sc_hd__decap_3
XTAP_TAPCELL_ROW_49_742 VGND VPWR sky130_fd_sc_hd__tapvpwrvgnd_1
XFILLER_38_268 VGND VGND VPWR VPWR sky130_fd_sc_hd__decap_3
XFILLER_38_279 VGND VGND VPWR VPWR sky130_fd_sc_hd__fill_1
XFILLER_53_205 VGND VGND VPWR VPWR sky130_fd_sc_hd__decap_3
XFILLER_81_503 VGND VGND VPWR VPWR sky130_fd_sc_hd__fill_1
XFILLER_19_471 VGND VGND VPWR VPWR sky130_fd_sc_hd__decap_3
X_6961_ _7243_/CLK _6961_/D VGND VGND VPWR VPWR _6961_/Q sky130_fd_sc_hd__dfxtp_2
XFILLER_81_569 VGND VGND VPWR VPWR sky130_fd_sc_hd__fill_1
X_6892_ _7575_/CLK _6892_/D VGND VGND VPWR VPWR _6892_/Q sky130_fd_sc_hd__dfxtp_2
X_5912_ _6064_/A1 _4582_/A _4582_/B _6994_/Q _6064_/C1 VGND VGND VPWR VPWR _5912_/X
+ sky130_fd_sc_hd__a311o_2
X_5843_ _5843_/A _5843_/B VGND VGND VPWR VPWR _5843_/X sky130_fd_sc_hd__or2_2
XFILLER_21_113 VGND VGND VPWR VPWR sky130_fd_sc_hd__decap_3
X_7513_ _7577_/CLK _7513_/D place2039/X VGND VGND VPWR VPWR _7513_/Q sky130_fd_sc_hd__dfrtp_2
X_5774_ _5769_/X _5770_/X _5772_/Y VGND VGND VPWR VPWR _5789_/B sky130_fd_sc_hd__a21oi_2
X_4725_ _7411_/Q _4725_/A2 _4725_/B1 _5979_/A VGND VGND VPWR VPWR _4725_/X sky130_fd_sc_hd__a211o_2
X_7444_ _7542_/CLK _7444_/D place2048/X VGND VGND VPWR VPWR _7444_/Q sky130_fd_sc_hd__dfrtp_2
X_4656_ _7369_/Q _6178_/A1 _6178_/A3 _4654_/Y _4655_/X VGND VGND VPWR VPWR _4656_/X
+ sky130_fd_sc_hd__a32o_2
Xplace1520 _3736_/X VGND VGND VPWR VPWR _4569_/B1 sky130_fd_sc_hd__buf_2
X_7375_ _7514_/CLK _7375_/D place2041/X VGND VGND VPWR VPWR _7375_/Q sky130_fd_sc_hd__dfrtp_2
X_4587_ _4904_/B _4904_/C _4904_/A VGND VGND VPWR VPWR _5304_/B sky130_fd_sc_hd__a21oi_2
X_3607_ _7445_/Q _3793_/A2 _3781_/B1 _7349_/Q _3606_/X VGND VGND VPWR VPWR _3607_/X
+ sky130_fd_sc_hd__a221o_2
Xplace1531 place1531/A VGND VGND VPWR VPWR _4609_/C sky130_fd_sc_hd__buf_2
Xplace1542 _6406_/A3 VGND VGND VPWR VPWR _6560_/B sky130_fd_sc_hd__buf_2
Xplace1553 _4755_/A VGND VGND VPWR VPWR _5614_/A1 sky130_fd_sc_hd__buf_2
X_3538_ _3538_/A _3538_/B _3538_/C VGND VGND VPWR VPWR _3538_/Y sky130_fd_sc_hd__nand3_2
Xplace1564 _3922_/X VGND VGND VPWR VPWR _3924_/B1 sky130_fd_sc_hd__buf_2
Xplace1575 _4279_/B VGND VGND VPWR VPWR _3707_/B sky130_fd_sc_hd__buf_2
Xplace1586 _4184_/B VGND VGND VPWR VPWR _4237_/C sky130_fd_sc_hd__buf_2
Xplace1597 _3789_/B1 VGND VGND VPWR VPWR _3907_/B1 sky130_fd_sc_hd__buf_4
X_3469_ _4473_/C _3463_/A _5847_/A3 _3468_/X VGND VGND VPWR VPWR _3543_/B sky130_fd_sc_hd__a31oi_4
XFILLER_29_202 VGND VGND VPWR VPWR sky130_fd_sc_hd__decap_3
X_6188_ _6950_/Q _6455_/B2 _6186_/X _6187_/X VGND VGND VPWR VPWR _6188_/X sky130_fd_sc_hd__o211a_2
XFILLER_29_246 VGND VGND VPWR VPWR sky130_fd_sc_hd__decap_3
XFILLER_29_279 VGND VGND VPWR VPWR sky130_fd_sc_hd__fill_1
XFILLER_84_374 VGND VGND VPWR VPWR sky130_fd_sc_hd__decap_3
XFILLER_44_249 VGND VGND VPWR VPWR sky130_fd_sc_hd__decap_3
XFILLER_16_65 VGND VGND VPWR VPWR sky130_fd_sc_hd__fill_2
XFILLER_25_463 VGND VGND VPWR VPWR sky130_fd_sc_hd__decap_3
XFILLER_25_485 VGND VGND VPWR VPWR sky130_fd_sc_hd__fill_2
XFILLER_12_135 VGND VGND VPWR VPWR sky130_fd_sc_hd__decap_3
XFILLER_52_282 VGND VGND VPWR VPWR sky130_fd_sc_hd__decap_3
XFILLER_12_157 VGND VGND VPWR VPWR sky130_fd_sc_hd__decap_3
XFILLER_8_106 VGND VGND VPWR VPWR sky130_fd_sc_hd__decap_3
XFILLER_8_139 VGND VGND VPWR VPWR sky130_fd_sc_hd__fill_1
XTAP_TAPCELL_ROW_10_325 VGND VPWR sky130_fd_sc_hd__tapvpwrvgnd_1
XFILLER_79_113 VGND VGND VPWR VPWR sky130_fd_sc_hd__fill_2
XFILLER_0_573 VGND VGND VPWR VPWR sky130_fd_sc_hd__decap_3
XFILLER_48_533 VGND VGND VPWR VPWR sky130_fd_sc_hd__fill_1
XFILLER_48_544 VGND VGND VPWR VPWR sky130_fd_sc_hd__decap_3
XFILLER_75_352 VGND VGND VPWR VPWR sky130_fd_sc_hd__decap_3
XTAP_TAPCELL_ROW_46_701 VGND VPWR sky130_fd_sc_hd__tapvpwrvgnd_1
XFILLER_35_216 VGND VGND VPWR VPWR sky130_fd_sc_hd__decap_3
XFILLER_63_525 VGND VGND VPWR VPWR sky130_fd_sc_hd__decap_3
XTAP_TAPCELL_ROW_85_1117 VGND VPWR sky130_fd_sc_hd__tapvpwrvgnd_1
XTAP_TAPCELL_ROW_18_414 VGND VPWR sky130_fd_sc_hd__tapvpwrvgnd_1
XFILLER_63_569 VGND VGND VPWR VPWR sky130_fd_sc_hd__fill_2
XFILLER_16_474 VGND VGND VPWR VPWR sky130_fd_sc_hd__fill_2
XFILLER_31_400 VGND VGND VPWR VPWR sky130_fd_sc_hd__decap_3
XFILLER_50_219 VGND VGND VPWR VPWR sky130_fd_sc_hd__decap_3
XFILLER_31_444 VGND VGND VPWR VPWR sky130_fd_sc_hd__decap_3
XTAP_TAPCELL_ROW_26_491 VGND VPWR sky130_fd_sc_hd__tapvpwrvgnd_1
XFILLER_31_455 VGND VGND VPWR VPWR sky130_fd_sc_hd__fill_2
XFILLER_31_477 VGND VGND VPWR VPWR sky130_fd_sc_hd__decap_3
X_5490_ _5490_/A0 _4576_/X _5547_/S VGND VGND VPWR VPWR _7180_/D sky130_fd_sc_hd__mux2_2
X_4510_ _4510_/A _4510_/B _4510_/C _7537_/Q VGND VGND VPWR VPWR _4510_/X sky130_fd_sc_hd__or4b_2
XFILLER_7_172 VGND VGND VPWR VPWR sky130_fd_sc_hd__decap_3
X_4441_ _4433_/X _4434_/X _4468_/C1 _4440_/Y VGND VGND VPWR VPWR _7302_/D sky130_fd_sc_hd__o2bb2a_2
XTAP_TAPCELL_ROW_96_1235 VGND VPWR sky130_fd_sc_hd__tapvpwrvgnd_1
X_7160_ _7272_/CLK _7160_/D VGND VGND VPWR VPWR _7160_/Q sky130_fd_sc_hd__dfxtp_2
XPHY_EDGE_ROW_9_Right_9 VGND VGND VPWR VPWR sky130_fd_sc_hd__decap_3
X_6111_ _6100_/X _6106_/X _6110_/X _6547_/A1 VGND VGND VPWR VPWR _6111_/X sky130_fd_sc_hd__a31o_2
X_4372_ _4473_/A _4503_/B _4503_/C _4036_/A VGND VGND VPWR VPWR _4416_/A sky130_fd_sc_hd__or4b_4
XFILLER_98_466 VGND VGND VPWR VPWR sky130_fd_sc_hd__fill_1
X_7091_ _7289_/CLK _7091_/D VGND VGND VPWR VPWR _7091_/Q sky130_fd_sc_hd__dfxtp_2
XFILLER_26_216 VGND VGND VPWR VPWR sky130_fd_sc_hd__decap_3
XFILLER_19_290 VGND VGND VPWR VPWR sky130_fd_sc_hd__decap_3
XFILLER_26_249 VGND VGND VPWR VPWR sky130_fd_sc_hd__decap_3
X_6944_ _7114_/CLK _6944_/D VGND VGND VPWR VPWR _6944_/Q sky130_fd_sc_hd__dfxtp_2
XFILLER_22_433 VGND VGND VPWR VPWR sky130_fd_sc_hd__decap_3
XFILLER_34_282 VGND VGND VPWR VPWR sky130_fd_sc_hd__decap_3
X_6875_ _7272_/CLK _6875_/D VGND VGND VPWR VPWR _6875_/Q sky130_fd_sc_hd__dfxtp_2
XFILLER_22_455 VGND VGND VPWR VPWR sky130_fd_sc_hd__decap_3
XFILLER_22_477 VGND VGND VPWR VPWR sky130_fd_sc_hd__decap_3
X_5826_ _4735_/X _5789_/X _5822_/X _4639_/Y _6515_/A3 VGND VGND VPWR VPWR _5826_/X
+ sky130_fd_sc_hd__o221a_2
X_7427_ _7581_/CLK _7427_/D place2032/X VGND VGND VPWR VPWR _7427_/Q sky130_fd_sc_hd__dfrtp_2
X_5688_ _5688_/A0 _5688_/A1 _5698_/S VGND VGND VPWR VPWR _7271_/D sky130_fd_sc_hd__mux2_2
Xplace2062 place2065/X VGND VGND VPWR VPWR place2062/X sky130_fd_sc_hd__buf_2
Xplace2051 place2052/X VGND VGND VPWR VPWR place2051/X sky130_fd_sc_hd__buf_2
Xplace2040 place2041/X VGND VGND VPWR VPWR place2040/X sky130_fd_sc_hd__buf_2
X_4639_ _4639_/A1 _4613_/X _5850_/C VGND VGND VPWR VPWR _4639_/Y sky130_fd_sc_hd__a21oi_4
Xplace1350 _4209_/B VGND VGND VPWR VPWR _4198_/B1 sky130_fd_sc_hd__buf_2
Xplace1361 _4154_/B VGND VGND VPWR VPWR _4153_/A1 sky130_fd_sc_hd__buf_2
X_7358_ clkload8/A _7358_/D place2019/X VGND VGND VPWR VPWR _7358_/Q sky130_fd_sc_hd__dfrtp_2
Xplace1372 _4192_/A VGND VGND VPWR VPWR _3887_/C sky130_fd_sc_hd__buf_4
Xplace1383 _3742_/D VGND VGND VPWR VPWR _4248_/A1 sky130_fd_sc_hd__buf_2
Xplace1394 _4117_/X VGND VGND VPWR VPWR _4582_/B sky130_fd_sc_hd__buf_2
Xrebuffer2362 _3628_/X VGND VGND VPWR VPWR rebuffer2362/X sky130_fd_sc_hd__buf_2
X_7289_ _7289_/CLK _7289_/D VGND VGND VPWR VPWR _7289_/Q sky130_fd_sc_hd__dfxtp_2
X_6309_ _7391_/Q _6313_/A2 _6313_/A3 _6313_/B1 _6309_/B2 VGND VGND VPWR VPWR _6309_/X
+ sky130_fd_sc_hd__a32o_2
XFILLER_76_138 VGND VGND VPWR VPWR sky130_fd_sc_hd__fill_2
XFILLER_45_503 VGND VGND VPWR VPWR sky130_fd_sc_hd__fill_1
XFILLER_57_374 VGND VGND VPWR VPWR sky130_fd_sc_hd__fill_1
XFILLER_17_238 VGND VGND VPWR VPWR sky130_fd_sc_hd__decap_3
XFILLER_17_249 VGND VGND VPWR VPWR sky130_fd_sc_hd__decap_3
XFILLER_27_64 VGND VGND VPWR VPWR sky130_fd_sc_hd__decap_3
XFILLER_45_558 VGND VGND VPWR VPWR sky130_fd_sc_hd__fill_2
XFILLER_13_433 VGND VGND VPWR VPWR sky130_fd_sc_hd__decap_3
XFILLER_25_271 VGND VGND VPWR VPWR sky130_fd_sc_hd__decap_3
Xmax_cap2105 _5824_/Y VGND VGND VPWR VPWR _6089_/B1 sky130_fd_sc_hd__clkbuf_2
XTAP_TAPCELL_ROW_80_1058 VGND VPWR sky130_fd_sc_hd__tapvpwrvgnd_1
XFILLER_40_274 VGND VGND VPWR VPWR sky130_fd_sc_hd__decap_3
XTAP_TAPCELL_ROW_23_461 VGND VPWR sky130_fd_sc_hd__tapvpwrvgnd_1
XFILLER_4_153 VGND VGND VPWR VPWR sky130_fd_sc_hd__fill_1
XTAP_TAPCELL_ROW_91_1176 VGND VPWR sky130_fd_sc_hd__tapvpwrvgnd_1
XFILLER_95_425 VGND VGND VPWR VPWR sky130_fd_sc_hd__decap_3
XFILLER_36_503 VGND VGND VPWR VPWR sky130_fd_sc_hd__fill_2
XFILLER_48_330 VGND VGND VPWR VPWR sky130_fd_sc_hd__decap_3
XFILLER_48_352 VGND VGND VPWR VPWR sky130_fd_sc_hd__decap_3
XFILLER_36_514 VGND VGND VPWR VPWR sky130_fd_sc_hd__decap_3
XFILLER_63_355 VGND VGND VPWR VPWR sky130_fd_sc_hd__decap_3
XFILLER_23_219 VGND VGND VPWR VPWR sky130_fd_sc_hd__decap_3
X_4990_ _4990_/A0 _5446_/A1 _4998_/S VGND VGND VPWR VPWR _6964_/D sky130_fd_sc_hd__mux2_2
X_3941_ _5850_/B _3946_/B _3938_/X _3940_/X VGND VGND VPWR VPWR _3941_/X sky130_fd_sc_hd__o31a_2
X_6660_ _6660_/A0 _6017_/X _6664_/S VGND VGND VPWR VPWR _7492_/D sky130_fd_sc_hd__mux2_2
X_3872_ _3832_/A _3870_/Y _3871_/Y VGND VGND VPWR VPWR _3872_/Y sky130_fd_sc_hd__o21bai_2
XFILLER_31_274 VGND VGND VPWR VPWR sky130_fd_sc_hd__decap_3
XTAP_TAPCELL_ROW_100_1272 VGND VPWR sky130_fd_sc_hd__tapvpwrvgnd_1
X_7212_ _7490_/CLK _7212_/D VGND VGND VPWR VPWR _7212_/Q sky130_fd_sc_hd__dfxtp_2
X_4424_ _4388_/S _4421_/Y _4422_/X _4423_/X VGND VGND VPWR VPWR _4424_/Y sky130_fd_sc_hd__o31ai_2
X_7143_ _7235_/CLK _7143_/D VGND VGND VPWR VPWR _7143_/Q sky130_fd_sc_hd__dfxtp_2
X_7074_ _7243_/CLK _7074_/D VGND VGND VPWR VPWR _7074_/Q sky130_fd_sc_hd__dfxtp_2
X_6025_ _6449_/B1 _7215_/Q _7131_/Q _6450_/B2 VGND VGND VPWR VPWR _6025_/X sky130_fd_sc_hd__o22a_2
XTAP_TAPCELL_ROW_57_818 VGND VPWR sky130_fd_sc_hd__tapvpwrvgnd_1
XFILLER_54_322 VGND VGND VPWR VPWR sky130_fd_sc_hd__decap_3
XFILLER_64_29 VGND VGND VPWR VPWR sky130_fd_sc_hd__fill_1
XFILLER_66_182 VGND VGND VPWR VPWR sky130_fd_sc_hd__decap_3
XFILLER_42_528 VGND VGND VPWR VPWR sky130_fd_sc_hd__decap_3
XFILLER_35_580 VGND VGND VPWR VPWR sky130_fd_sc_hd__decap_3
XFILLER_54_399 VGND VGND VPWR VPWR sky130_fd_sc_hd__decap_3
X_6927_ _7282_/CLK _6927_/D VGND VGND VPWR VPWR _6927_/Q sky130_fd_sc_hd__dfxtp_2
X_6858_ _7279_/CLK _6858_/D VGND VGND VPWR VPWR _6858_/Q sky130_fd_sc_hd__dfxtp_2
XFILLER_22_263 VGND VGND VPWR VPWR sky130_fd_sc_hd__fill_1
X_5809_ _7193_/Q _6175_/A2 _7221_/Q _6173_/A1 VGND VGND VPWR VPWR _5809_/X sky130_fd_sc_hd__o22a_2
X_6789_ _6789_/A _6789_/B VGND VGND VPWR VPWR _7553_/D sky130_fd_sc_hd__and2_2
XTAP_TAPCELL_ROW_20_431 VGND VPWR sky130_fd_sc_hd__tapvpwrvgnd_1
XFILLER_13_77 VGND VGND VPWR VPWR sky130_fd_sc_hd__fill_1
XPHY_EDGE_ROW_8_Left_112 VGND VGND VPWR VPWR sky130_fd_sc_hd__decap_3
Xplace1180 _5669_/S VGND VGND VPWR VPWR _5654_/S sky130_fd_sc_hd__buf_2
Xplace1191 _5120_/S VGND VGND VPWR VPWR _5118_/S sky130_fd_sc_hd__buf_2
Xrebuffer2170 _6136_/A2 VGND VGND VPWR VPWR _6146_/A2 sky130_fd_sc_hd__buf_2
Xrebuffer2181 _4638_/Y VGND VGND VPWR VPWR _5839_/B2 sky130_fd_sc_hd__buf_2
XFILLER_38_85 VGND VGND VPWR VPWR sky130_fd_sc_hd__fill_1
XFILLER_45_300 VGND VGND VPWR VPWR sky130_fd_sc_hd__decap_3
XFILLER_18_536 VGND VGND VPWR VPWR sky130_fd_sc_hd__decap_3
XFILLER_57_193 VGND VGND VPWR VPWR sky130_fd_sc_hd__decap_3
XTAP_TAPCELL_ROW_28_520 VGND VPWR sky130_fd_sc_hd__tapvpwrvgnd_1
XFILLER_33_517 VGND VGND VPWR VPWR sky130_fd_sc_hd__decap_3
XFILLER_13_252 VGND VGND VPWR VPWR sky130_fd_sc_hd__decap_3
XFILLER_41_561 VGND VGND VPWR VPWR sky130_fd_sc_hd__decap_3
XFILLER_41_594 VGND VGND VPWR VPWR sky130_fd_sc_hd__decap_3
Xclkload26 _7247_/CLK VGND VGND VPWR VPWR clkload26/X sky130_fd_sc_hd__clkbuf_4
Xclkload15 _7608_/CLK VGND VGND VPWR VPWR clkload15/X sky130_fd_sc_hd__clkbuf_8
X_4140_ _3946_/A _3946_/B _3946_/C _4404_/B1 _3930_/Y VGND VGND VPWR VPWR _4168_/C
+ sky130_fd_sc_hd__o41ai_2
XFILLER_95_211 VGND VGND VPWR VPWR sky130_fd_sc_hd__fill_1
X_4071_ _4071_/A _4071_/B VGND VGND VPWR VPWR _7604_/D sky130_fd_sc_hd__and2_2
XFILLER_36_300 VGND VGND VPWR VPWR sky130_fd_sc_hd__decap_3
XFILLER_55_108 VGND VGND VPWR VPWR sky130_fd_sc_hd__decap_3
XFILLER_76_480 VGND VGND VPWR VPWR sky130_fd_sc_hd__fill_1
XFILLER_63_130 VGND VGND VPWR VPWR sky130_fd_sc_hd__fill_1
XFILLER_63_174 VGND VGND VPWR VPWR sky130_fd_sc_hd__decap_3
XFILLER_63_196 VGND VGND VPWR VPWR sky130_fd_sc_hd__decap_3
X_4973_ _4973_/A0 _5673_/A1 _5030_/S VGND VGND VPWR VPWR _6956_/D sky130_fd_sc_hd__mux2_2
Xplace174 _4166_/Y VGND VGND VPWR VPWR place174/X sky130_fd_sc_hd__buf_4
X_6712_ _5855_/X _6712_/A1 _6720_/S VGND VGND VPWR VPWR _7517_/D sky130_fd_sc_hd__mux2_2
X_3924_ _7396_/Q _4150_/A2 _3924_/B1 _3924_/C1 VGND VGND VPWR VPWR _3946_/C sky130_fd_sc_hd__a211oi_2
XTAP_TAPCELL_ROW_62_876 VGND VPWR sky130_fd_sc_hd__tapvpwrvgnd_1
X_6643_ _6643_/A0 _5846_/X _6653_/S VGND VGND VPWR VPWR _7484_/D sky130_fd_sc_hd__mux2_2
XTAP_TAPCELL_ROW_34_578 VGND VPWR sky130_fd_sc_hd__tapvpwrvgnd_1
Xclkload9 clkload9/A VGND VGND VPWR VPWR clkload9/Y sky130_fd_sc_hd__inv_8
X_3855_ _7402_/Q _3855_/A2 _3855_/B1 _7434_/Q _3854_/X VGND VGND VPWR VPWR _3855_/Y
+ sky130_fd_sc_hd__a221oi_4
X_3786_ _4220_/A _4238_/A _4238_/B _4220_/B VGND VGND VPWR VPWR _3835_/A sky130_fd_sc_hd__nand4_2
X_4407_ _4402_/Y _4439_/D _4408_/C _4408_/D VGND VGND VPWR VPWR _4407_/X sky130_fd_sc_hd__and4b_2
XFILLER_99_561 VGND VGND VPWR VPWR sky130_fd_sc_hd__decap_3
X_5387_ _5387_/A0 _5570_/A1 _5423_/S VGND VGND VPWR VPWR _7133_/D sky130_fd_sc_hd__mux2_2
X_7126_ _7266_/CLK _7126_/D VGND VGND VPWR VPWR _7126_/Q sky130_fd_sc_hd__dfxtp_2
X_4338_ _3961_/A _4324_/B _4396_/A _4338_/B1 VGND VGND VPWR VPWR _4338_/X sky130_fd_sc_hd__a31o_2
X_7057_ _7114_/CLK _7057_/D VGND VGND VPWR VPWR _7057_/Q sky130_fd_sc_hd__dfxtp_2
X_4269_ _4269_/A _6389_/B _4269_/C VGND VGND VPWR VPWR _4270_/A sky130_fd_sc_hd__and3_4
XFILLER_27_311 VGND VGND VPWR VPWR sky130_fd_sc_hd__decap_3
X_6008_ _6006_/X _6007_/X _6458_/B2 VGND VGND VPWR VPWR _6008_/Y sky130_fd_sc_hd__a21oi_2
XFILLER_27_344 VGND VGND VPWR VPWR sky130_fd_sc_hd__fill_1
XFILLER_27_366 VGND VGND VPWR VPWR sky130_fd_sc_hd__decap_3
XFILLER_15_539 VGND VGND VPWR VPWR sky130_fd_sc_hd__fill_1
XFILLER_27_388 VGND VGND VPWR VPWR sky130_fd_sc_hd__decap_3
XFILLER_30_509 VGND VGND VPWR VPWR sky130_fd_sc_hd__decap_3
XFILLER_23_561 VGND VGND VPWR VPWR sky130_fd_sc_hd__decap_3
XFILLER_24_54 VGND VGND VPWR VPWR sky130_fd_sc_hd__decap_3
XFILLER_10_211 VGND VGND VPWR VPWR sky130_fd_sc_hd__decap_3
XFILLER_10_233 VGND VGND VPWR VPWR sky130_fd_sc_hd__decap_3
XFILLER_50_391 VGND VGND VPWR VPWR sky130_fd_sc_hd__decap_3
XFILLER_10_288 VGND VGND VPWR VPWR sky130_fd_sc_hd__decap_3
XFILLER_6_248 VGND VGND VPWR VPWR sky130_fd_sc_hd__decap_3
XFILLER_6_259 VGND VGND VPWR VPWR sky130_fd_sc_hd__fill_2
XFILLER_77_244 VGND VGND VPWR VPWR sky130_fd_sc_hd__fill_1
XFILLER_77_277 VGND VGND VPWR VPWR sky130_fd_sc_hd__decap_3
XFILLER_92_214 VGND VGND VPWR VPWR sky130_fd_sc_hd__fill_1
XFILLER_33_303 VGND VGND VPWR VPWR sky130_fd_sc_hd__decap_3
XFILLER_73_472 VGND VGND VPWR VPWR sky130_fd_sc_hd__fill_2
XFILLER_92_269 VGND VGND VPWR VPWR sky130_fd_sc_hd__decap_3
XFILLER_73_483 VGND VGND VPWR VPWR sky130_fd_sc_hd__decap_3
XFILLER_60_144 VGND VGND VPWR VPWR sky130_fd_sc_hd__decap_3
XFILLER_14_572 VGND VGND VPWR VPWR sky130_fd_sc_hd__decap_3
XFILLER_60_166 VGND VGND VPWR VPWR sky130_fd_sc_hd__fill_2
XTAP_TAPCELL_ROW_31_548 VGND VPWR sky130_fd_sc_hd__tapvpwrvgnd_1
X_3571_ _3571_/A1 _3571_/A2 _6302_/A _3490_/C VGND VGND VPWR VPWR _3571_/Y sky130_fd_sc_hd__a211oi_2
XFILLER_53_3 VGND VGND VPWR VPWR sky130_fd_sc_hd__fill_2
Xplace1927 _3844_/A VGND VGND VPWR VPWR _4448_/B sky130_fd_sc_hd__buf_2
Xplace1916 _3462_/A VGND VGND VPWR VPWR _3421_/C sky130_fd_sc_hd__buf_2
Xplace1905 _3459_/B VGND VGND VPWR VPWR _3961_/C sky130_fd_sc_hd__buf_2
X_6290_ _6294_/A _6290_/B VGND VGND VPWR VPWR _7351_/D sky130_fd_sc_hd__and2_2
X_5310_ _5310_/A0 _5310_/A1 _5331_/S VGND VGND VPWR VPWR _7098_/D sky130_fd_sc_hd__mux2_2
Xplace1949 _7372_/Q VGND VGND VPWR VPWR _6328_/B2 sky130_fd_sc_hd__buf_2
Xplace1938 _7420_/Q VGND VGND VPWR VPWR _6416_/A0 sky130_fd_sc_hd__buf_2
XFILLER_68_211 VGND VGND VPWR VPWR sky130_fd_sc_hd__decap_3
XFILLER_96_531 VGND VGND VPWR VPWR sky130_fd_sc_hd__fill_1
Xhold2629 _7074_/Q VGND VGND VPWR VPWR _5237_/A0 sky130_fd_sc_hd__dlygate4sd3_1
Xhold2618 _7039_/Q VGND VGND VPWR VPWR _5152_/A0 sky130_fd_sc_hd__dlygate4sd3_1
Xhold2607 _6918_/Q VGND VGND VPWR VPWR _4883_/A0 sky130_fd_sc_hd__dlygate4sd3_1
XFILLER_68_244 VGND VGND VPWR VPWR sky130_fd_sc_hd__decap_3
X_4123_ _4120_/Y _4123_/A2 _4122_/Y VGND VGND VPWR VPWR _4125_/A sky130_fd_sc_hd__o21ai_2
XFILLER_68_277 VGND VGND VPWR VPWR sky130_fd_sc_hd__fill_2
X_4054_ _4495_/A _4055_/C _7308_/Q VGND VGND VPWR VPWR _4056_/A sky130_fd_sc_hd__a21oi_2
XTAP_TAPCELL_ROW_67_924 VGND VPWR sky130_fd_sc_hd__tapvpwrvgnd_1
XFILLER_83_225 VGND VGND VPWR VPWR sky130_fd_sc_hd__decap_3
XTAP_TAPCELL_ROW_39_637 VGND VPWR sky130_fd_sc_hd__tapvpwrvgnd_1
XFILLER_36_141 VGND VGND VPWR VPWR sky130_fd_sc_hd__fill_1
XFILLER_24_336 VGND VGND VPWR VPWR sky130_fd_sc_hd__decap_3
XFILLER_51_111 VGND VGND VPWR VPWR sky130_fd_sc_hd__fill_1
XFILLER_64_483 VGND VGND VPWR VPWR sky130_fd_sc_hd__fill_1
X_4956_ _4956_/A0 _5661_/A1 _4964_/S VGND VGND VPWR VPWR _6951_/D sky130_fd_sc_hd__mux2_2
XFILLER_20_542 VGND VGND VPWR VPWR sky130_fd_sc_hd__decap_3
XFILLER_51_199 VGND VGND VPWR VPWR sky130_fd_sc_hd__decap_3
X_4887_ _4887_/A0 _5715_/A1 _4902_/S VGND VGND VPWR VPWR _6920_/D sky130_fd_sc_hd__mux2_2
X_3907_ _7431_/Q _3907_/A2 _3907_/B1 _7399_/Q VGND VGND VPWR VPWR _3910_/A sky130_fd_sc_hd__a22oi_2
X_6626_ _6626_/A0 _6185_/X _6638_/S VGND VGND VPWR VPWR _7476_/D sky130_fd_sc_hd__mux2_2
X_3838_ _7467_/Q _3838_/A2 _3880_/B1 _7403_/Q _3837_/X VGND VGND VPWR VPWR _3838_/X
+ sky130_fd_sc_hd__a221o_2
XFILLER_20_586 VGND VGND VPWR VPWR sky130_fd_sc_hd__fill_2
X_6557_ _6557_/A0 _6406_/Y _6567_/S VGND VGND VPWR VPWR _7447_/D sky130_fd_sc_hd__mux2_2
X_3769_ _6335_/B2 _6706_/S _3769_/B1 _7475_/Q VGND VGND VPWR VPWR _3771_/B sky130_fd_sc_hd__a22oi_2
XFILLER_10_45 VGND VGND VPWR VPWR sky130_fd_sc_hd__decap_3
X_6488_ _6489_/A4 _6487_/X _5734_/Y VGND VGND VPWR VPWR _6488_/Y sky130_fd_sc_hd__o21ai_2
XFILLER_59_200 VGND VGND VPWR VPWR sky130_fd_sc_hd__decap_3
XFILLER_101_330 VGND VGND VPWR VPWR sky130_fd_sc_hd__decap_3
X_7109_ _7280_/CLK _7109_/D VGND VGND VPWR VPWR _7109_/Q sky130_fd_sc_hd__dfxtp_2
XFILLER_19_108 VGND VGND VPWR VPWR sky130_fd_sc_hd__decap_3
XFILLER_19_65 VGND VGND VPWR VPWR sky130_fd_sc_hd__decap_3
XFILLER_47_417 VGND VGND VPWR VPWR sky130_fd_sc_hd__decap_3
XFILLER_47_428 VGND VGND VPWR VPWR sky130_fd_sc_hd__decap_3
XPHY_EDGE_ROW_98_Left_202 VGND VGND VPWR VPWR sky130_fd_sc_hd__decap_3
XTAP_TAPCELL_ROW_2_240 VGND VPWR sky130_fd_sc_hd__tapvpwrvgnd_1
XFILLER_27_141 VGND VGND VPWR VPWR sky130_fd_sc_hd__decap_3
XFILLER_62_409 VGND VGND VPWR VPWR sky130_fd_sc_hd__fill_1
XFILLER_27_196 VGND VGND VPWR VPWR sky130_fd_sc_hd__decap_3
XFILLER_42_144 VGND VGND VPWR VPWR sky130_fd_sc_hd__fill_2
XFILLER_35_86 VGND VGND VPWR VPWR sky130_fd_sc_hd__decap_3
XFILLER_30_339 VGND VGND VPWR VPWR sky130_fd_sc_hd__decap_3
XFILLER_11_553 VGND VGND VPWR VPWR sky130_fd_sc_hd__decap_3
XFILLER_11_575 VGND VGND VPWR VPWR sky130_fd_sc_hd__decap_3
XFILLER_7_524 VGND VGND VPWR VPWR sky130_fd_sc_hd__decap_3
XFILLER_18_6 VGND VGND VPWR VPWR sky130_fd_sc_hd__decap_3
XTAP_TAPCELL_ROW_88_1148 VGND VPWR sky130_fd_sc_hd__tapvpwrvgnd_1
XFILLER_18_141 VGND VGND VPWR VPWR sky130_fd_sc_hd__decap_3
XFILLER_46_450 VGND VGND VPWR VPWR sky130_fd_sc_hd__decap_3
XFILLER_93_567 VGND VGND VPWR VPWR sky130_fd_sc_hd__fill_1
XFILLER_18_185 VGND VGND VPWR VPWR sky130_fd_sc_hd__decap_3
XFILLER_33_166 VGND VGND VPWR VPWR sky130_fd_sc_hd__fill_2
XFILLER_33_188 VGND VGND VPWR VPWR sky130_fd_sc_hd__decap_3
XTAP_TAPCELL_ROW_72_982 VGND VPWR sky130_fd_sc_hd__tapvpwrvgnd_1
XTAP_TAPCELL_ROW_44_684 VGND VPWR sky130_fd_sc_hd__tapvpwrvgnd_1
X_4741_ _4741_/A0 _5718_/A1 _4771_/S VGND VGND VPWR VPWR _6865_/D sky130_fd_sc_hd__mux2_2
XTAP_TAPCELL_ROW_16_386 VGND VPWR sky130_fd_sc_hd__tapvpwrvgnd_1
X_7460_ clkload5/A _7460_/D place2064/X VGND VGND VPWR VPWR _7460_/Q sky130_fd_sc_hd__dfrtp_2
X_4672_ _4672_/A0 _5698_/A1 _4672_/S VGND VGND VPWR VPWR _6856_/D sky130_fd_sc_hd__mux2_2
X_6411_ _6706_/A0 _6411_/A2 _6411_/A3 _6411_/B1 _7418_/Q VGND VGND VPWR VPWR _6411_/X
+ sky130_fd_sc_hd__a32o_2
XTAP_TAPCELL_ROW_99_1266 VGND VPWR sky130_fd_sc_hd__tapvpwrvgnd_1
Xplace1702 _4905_/A VGND VGND VPWR VPWR _6404_/A2 sky130_fd_sc_hd__buf_2
X_7391_ clkload7/A _7391_/D place2026/X VGND VGND VPWR VPWR _7391_/Q sky130_fd_sc_hd__dfrtp_2
Xplace1713 _3653_/C1 VGND VGND VPWR VPWR _5843_/A sky130_fd_sc_hd__buf_2
Xplace1724 _3628_/B1 VGND VGND VPWR VPWR _3562_/A4 sky130_fd_sc_hd__buf_2
Xplace1735 _4211_/A VGND VGND VPWR VPWR _3698_/B sky130_fd_sc_hd__clkbuf_4
X_6342_ _7415_/Q _6344_/A2 _6344_/A3 _6344_/B1 _6342_/B2 VGND VGND VPWR VPWR _7383_/D
+ sky130_fd_sc_hd__a32o_2
X_3554_ _4023_/B _3574_/A1 _3481_/A _3536_/D _3529_/A VGND VGND VPWR VPWR _3554_/X
+ sky130_fd_sc_hd__o2111a_2
Xplace1746 _3490_/X VGND VGND VPWR VPWR _4576_/B1 sky130_fd_sc_hd__buf_4
Xplace1757 _3914_/A2 VGND VGND VPWR VPWR _4150_/A2 sky130_fd_sc_hd__buf_4
Xplace1768 _6513_/B1 VGND VGND VPWR VPWR _6547_/A1 sky130_fd_sc_hd__buf_2
X_6273_ _6292_/A _6273_/B VGND VGND VPWR VPWR _7343_/D sky130_fd_sc_hd__and2_2
X_3485_ _4352_/B _4337_/B _3485_/C _4337_/D VGND VGND VPWR VPWR _3490_/B sky130_fd_sc_hd__nand4_2
Xplace1779 _6229_/A1 VGND VGND VPWR VPWR _6220_/A1 sky130_fd_sc_hd__buf_2
Xhold2404 _6989_/Q VGND VGND VPWR VPWR _5045_/A0 sky130_fd_sc_hd__dlygate4sd3_1
X_5224_ _5224_/A0 _5310_/A1 _5255_/S VGND VGND VPWR VPWR _7070_/D sky130_fd_sc_hd__mux2_2
Xhold2437 _6984_/Q VGND VGND VPWR VPWR _5034_/A0 sky130_fd_sc_hd__dlygate4sd3_1
Xhold2426 _7076_/Q VGND VGND VPWR VPWR _5243_/A0 sky130_fd_sc_hd__dlygate4sd3_1
Xhold2415 _6953_/Q VGND VGND VPWR VPWR _4960_/A0 sky130_fd_sc_hd__dlygate4sd3_1
Xhold2459 _7117_/Q VGND VGND VPWR VPWR _5351_/A0 sky130_fd_sc_hd__dlygate4sd3_1
Xhold2448 _7091_/Q VGND VGND VPWR VPWR _5290_/A0 sky130_fd_sc_hd__dlygate4sd3_1
XFILLER_29_439 VGND VGND VPWR VPWR sky130_fd_sc_hd__decap_3
XFILLER_56_225 VGND VGND VPWR VPWR sky130_fd_sc_hd__fill_2
XFILLER_56_236 VGND VGND VPWR VPWR sky130_fd_sc_hd__fill_2
XFILLER_25_601 VGND VGND VPWR VPWR sky130_fd_sc_hd__fill_1
XFILLER_84_589 VGND VGND VPWR VPWR sky130_fd_sc_hd__decap_3
X_4037_ _4036_/A _7299_/Q _4036_/D _7300_/Q VGND VGND VPWR VPWR _4038_/B sky130_fd_sc_hd__a31oi_2
XFILLER_24_100 VGND VGND VPWR VPWR sky130_fd_sc_hd__decap_3
XFILLER_37_483 VGND VGND VPWR VPWR sky130_fd_sc_hd__decap_3
XFILLER_24_144 VGND VGND VPWR VPWR sky130_fd_sc_hd__decap_3
XFILLER_24_177 VGND VGND VPWR VPWR sky130_fd_sc_hd__decap_3
XFILLER_52_486 VGND VGND VPWR VPWR sky130_fd_sc_hd__decap_3
X_5988_ _6451_/B1 _6912_/Q _7248_/Q _5991_/B2 VGND VGND VPWR VPWR _5989_/B sky130_fd_sc_hd__o22a_2
XFILLER_24_188 VGND VGND VPWR VPWR sky130_fd_sc_hd__decap_3
X_4939_ _4939_/A0 _5705_/A1 _4958_/S VGND VGND VPWR VPWR _6943_/D sky130_fd_sc_hd__mux2_2
XANTENNA_40 _6183_/C VGND VGND VPWR VPWR sky130_fd_sc_hd__diode_2
XANTENNA_51 _7056_/Q VGND VGND VPWR VPWR sky130_fd_sc_hd__diode_2
XFILLER_20_372 VGND VGND VPWR VPWR sky130_fd_sc_hd__decap_3
X_6609_ _6609_/A0 _6091_/X _6634_/S VGND VGND VPWR VPWR _7468_/D sky130_fd_sc_hd__mux2_2
XFILLER_21_55 VGND VGND VPWR VPWR sky130_fd_sc_hd__fill_1
X_7589_ clkload5/A _7589_/D place2061/X VGND VGND VPWR VPWR _7589_/Q sky130_fd_sc_hd__dfrtp_2
Xhold2960 _6332_/X VGND VGND VPWR VPWR _7376_/D sky130_fd_sc_hd__dlygate4sd3_1
Xhold2971 _7528_/Q VGND VGND VPWR VPWR _6735_/A1 sky130_fd_sc_hd__dlygate4sd3_1
Xhold2982 _7429_/Q VGND VGND VPWR VPWR _6516_/A0 sky130_fd_sc_hd__dlygate4sd3_1
Xhold2993 _7465_/Q VGND VGND VPWR VPWR _6602_/A0 sky130_fd_sc_hd__dlygate4sd3_1
XFILLER_28_483 VGND VGND VPWR VPWR sky130_fd_sc_hd__decap_3
XFILLER_46_74 VGND VGND VPWR VPWR sky130_fd_sc_hd__fill_1
XFILLER_15_166 VGND VGND VPWR VPWR sky130_fd_sc_hd__fill_2
XFILLER_70_261 VGND VGND VPWR VPWR sky130_fd_sc_hd__fill_1
XTAP_TAPCELL_ROW_41_654 VGND VPWR sky130_fd_sc_hd__tapvpwrvgnd_1
XTAP_TAPCELL_ROW_13_356 VGND VPWR sky130_fd_sc_hd__tapvpwrvgnd_1
XFILLER_7_321 VGND VGND VPWR VPWR sky130_fd_sc_hd__decap_3
XFILLER_7_57 VGND VGND VPWR VPWR sky130_fd_sc_hd__fill_1
XFILLER_3_571 VGND VGND VPWR VPWR sky130_fd_sc_hd__fill_1
XFILLER_3_582 VGND VGND VPWR VPWR sky130_fd_sc_hd__decap_3
XFILLER_38_203 VGND VGND VPWR VPWR sky130_fd_sc_hd__decap_3
XFILLER_97_169 VGND VGND VPWR VPWR sky130_fd_sc_hd__fill_1
XFILLER_16_3 VGND VGND VPWR VPWR sky130_fd_sc_hd__decap_3
X_6960_ _7275_/CLK _6960_/D VGND VGND VPWR VPWR _6960_/Q sky130_fd_sc_hd__dfxtp_2
XFILLER_19_483 VGND VGND VPWR VPWR sky130_fd_sc_hd__fill_2
X_5911_ _7078_/Q _6502_/A2 _6502_/B1 _7106_/Q _5910_/X VGND VGND VPWR VPWR _5911_/X
+ sky130_fd_sc_hd__o221a_2
XFILLER_34_431 VGND VGND VPWR VPWR sky130_fd_sc_hd__decap_3
X_6891_ _7575_/CLK _6891_/D VGND VGND VPWR VPWR _6891_/Q sky130_fd_sc_hd__dfxtp_2
XFILLER_34_464 VGND VGND VPWR VPWR sky130_fd_sc_hd__decap_3
XFILLER_34_486 VGND VGND VPWR VPWR sky130_fd_sc_hd__decap_3
XFILLER_21_136 VGND VGND VPWR VPWR sky130_fd_sc_hd__decap_3
XFILLER_61_294 VGND VGND VPWR VPWR sky130_fd_sc_hd__fill_1
XFILLER_21_147 VGND VGND VPWR VPWR sky130_fd_sc_hd__fill_1
XFILLER_21_158 VGND VGND VPWR VPWR sky130_fd_sc_hd__decap_3
X_7512_ _7577_/CLK _7512_/D place2036/X VGND VGND VPWR VPWR _7512_/Q sky130_fd_sc_hd__dfrtp_2
X_7443_ _7514_/CLK _7443_/D place2037/X VGND VGND VPWR VPWR _7443_/Q sky130_fd_sc_hd__dfrtp_2
X_4655_ _4642_/X _4654_/A1 _4761_/A _4629_/S VGND VGND VPWR VPWR _4655_/X sky130_fd_sc_hd__o2bb2a_2
Xplace1510 _3790_/Y VGND VGND VPWR VPWR _4563_/A1 sky130_fd_sc_hd__buf_2
X_7374_ _7514_/CLK _7374_/D place2040/X VGND VGND VPWR VPWR _7374_/Q sky130_fd_sc_hd__dfrtp_2
X_4586_ _5862_/A3 _4586_/A2 _6465_/B VGND VGND VPWR VPWR _4904_/C sky130_fd_sc_hd__a21oi_2
X_3606_ _3717_/A1 _3792_/A2 _7381_/Q _3792_/B1 _7573_/Q VGND VGND VPWR VPWR _3606_/X
+ sky130_fd_sc_hd__a32o_2
Xplace1521 _3736_/X VGND VGND VPWR VPWR _4297_/D sky130_fd_sc_hd__buf_2
Xplace1532 _3587_/X VGND VGND VPWR VPWR _4117_/A2 sky130_fd_sc_hd__buf_6
Xplace1543 _4095_/X VGND VGND VPWR VPWR _4117_/C1 sky130_fd_sc_hd__buf_2
X_3537_ _7516_/Q _3909_/A2 _3965_/B1 _7452_/Q VGND VGND VPWR VPWR _3538_/C sky130_fd_sc_hd__a22oi_2
Xplace1554 _4755_/A VGND VGND VPWR VPWR _5221_/A1 sky130_fd_sc_hd__buf_2
Xplace1565 _3838_/X VGND VGND VPWR VPWR _4565_/A2 sky130_fd_sc_hd__buf_2
Xplace1576 _3580_/Y VGND VGND VPWR VPWR _3919_/B sky130_fd_sc_hd__buf_6
Xplace1587 _3653_/X VGND VGND VPWR VPWR _4184_/B sky130_fd_sc_hd__buf_2
XFILLER_103_447 VGND VGND VPWR VPWR sky130_fd_sc_hd__fill_1
Xplace1598 _3628_/X VGND VGND VPWR VPWR _3789_/B1 sky130_fd_sc_hd__buf_6
X_6256_ _6298_/A _6256_/B VGND VGND VPWR VPWR _7335_/D sky130_fd_sc_hd__and2_2
X_3468_ _3468_/A _3473_/A _3474_/A VGND VGND VPWR VPWR _3468_/X sky130_fd_sc_hd__and3_2
XFILLER_69_372 VGND VGND VPWR VPWR sky130_fd_sc_hd__fill_2
XFILLER_76_309 VGND VGND VPWR VPWR sky130_fd_sc_hd__decap_3
X_6187_ _7034_/Q _6396_/A1 _6213_/B2 _6978_/Q VGND VGND VPWR VPWR _6187_/X sky130_fd_sc_hd__o22a_2
X_5207_ _5207_/A0 _5357_/A1 _5207_/S VGND VGND VPWR VPWR _7064_/D sky130_fd_sc_hd__mux2_2
XFILLER_29_225 VGND VGND VPWR VPWR sky130_fd_sc_hd__decap_3
XFILLER_29_258 VGND VGND VPWR VPWR sky130_fd_sc_hd__decap_3
XFILLER_44_206 VGND VGND VPWR VPWR sky130_fd_sc_hd__decap_3
XFILLER_25_431 VGND VGND VPWR VPWR sky130_fd_sc_hd__decap_3
XFILLER_25_475 VGND VGND VPWR VPWR sky130_fd_sc_hd__fill_2
XFILLER_12_103 VGND VGND VPWR VPWR sky130_fd_sc_hd__decap_3
XFILLER_25_497 VGND VGND VPWR VPWR sky130_fd_sc_hd__decap_3
XFILLER_80_592 VGND VGND VPWR VPWR sky130_fd_sc_hd__decap_3
XFILLER_40_456 VGND VGND VPWR VPWR sky130_fd_sc_hd__fill_1
XFILLER_32_54 VGND VGND VPWR VPWR sky130_fd_sc_hd__decap_3
XTAP_TAPCELL_ROW_10_326 VGND VPWR sky130_fd_sc_hd__tapvpwrvgnd_1
XFILLER_4_324 VGND VGND VPWR VPWR sky130_fd_sc_hd__decap_3
XFILLER_4_368 VGND VGND VPWR VPWR sky130_fd_sc_hd__decap_3
XFILLER_0_530 VGND VGND VPWR VPWR sky130_fd_sc_hd__fill_2
XFILLER_0_596 VGND VGND VPWR VPWR sky130_fd_sc_hd__decap_3
Xhold2790 _7224_/Q VGND VGND VPWR VPWR _5585_/A0 sky130_fd_sc_hd__dlygate4sd3_1
XFILLER_35_228 VGND VGND VPWR VPWR sky130_fd_sc_hd__decap_3
XFILLER_48_589 VGND VGND VPWR VPWR sky130_fd_sc_hd__fill_2
XTAP_TAPCELL_ROW_85_1118 VGND VPWR sky130_fd_sc_hd__tapvpwrvgnd_1
XTAP_TAPCELL_ROW_46_702 VGND VPWR sky130_fd_sc_hd__tapvpwrvgnd_1
XTAP_TAPCELL_ROW_18_415 VGND VPWR sky130_fd_sc_hd__tapvpwrvgnd_1
XFILLER_28_280 VGND VGND VPWR VPWR sky130_fd_sc_hd__decap_3
XFILLER_63_559 VGND VGND VPWR VPWR sky130_fd_sc_hd__fill_1
XPHY_EDGE_ROW_35_Left_139 VGND VGND VPWR VPWR sky130_fd_sc_hd__decap_3
XFILLER_71_570 VGND VGND VPWR VPWR sky130_fd_sc_hd__decap_3
XTAP_TAPCELL_ROW_54_790 VGND VPWR sky130_fd_sc_hd__tapvpwrvgnd_1
XTAP_TAPCELL_ROW_26_492 VGND VPWR sky130_fd_sc_hd__tapvpwrvgnd_1
XFILLER_31_489 VGND VGND VPWR VPWR sky130_fd_sc_hd__decap_3
XFILLER_7_140 VGND VGND VPWR VPWR sky130_fd_sc_hd__fill_2
X_4440_ _4460_/A _4460_/C _4450_/A VGND VGND VPWR VPWR _4440_/Y sky130_fd_sc_hd__a21oi_2
XTAP_TAPCELL_ROW_96_1236 VGND VPWR sky130_fd_sc_hd__tapvpwrvgnd_1
XPHY_EDGE_ROW_44_Left_148 VGND VGND VPWR VPWR sky130_fd_sc_hd__decap_3
X_6110_ _6107_/X _6109_/X _6153_/B1 _6156_/C1 VGND VGND VPWR VPWR _6110_/X sky130_fd_sc_hd__a211o_2
X_7090_ _7288_/CLK _7090_/D VGND VGND VPWR VPWR _7090_/Q sky130_fd_sc_hd__dfxtp_2
XFILLER_58_309 VGND VGND VPWR VPWR sky130_fd_sc_hd__decap_3
XFILLER_39_534 VGND VGND VPWR VPWR sky130_fd_sc_hd__decap_3
XFILLER_54_504 VGND VGND VPWR VPWR sky130_fd_sc_hd__fill_2
XFILLER_66_342 VGND VGND VPWR VPWR sky130_fd_sc_hd__decap_3
XFILLER_26_228 VGND VGND VPWR VPWR sky130_fd_sc_hd__fill_1
XPHY_EDGE_ROW_53_Left_157 VGND VGND VPWR VPWR sky130_fd_sc_hd__decap_3
X_6943_ _7279_/CLK _6943_/D VGND VGND VPWR VPWR _6943_/Q sky130_fd_sc_hd__dfxtp_2
X_6874_ _7266_/CLK _6874_/D VGND VGND VPWR VPWR _6874_/Q sky130_fd_sc_hd__dfxtp_2
XFILLER_34_294 VGND VGND VPWR VPWR sky130_fd_sc_hd__decap_3
XFILLER_22_467 VGND VGND VPWR VPWR sky130_fd_sc_hd__decap_3
XFILLER_22_489 VGND VGND VPWR VPWR sky130_fd_sc_hd__decap_3
XPHY_EDGE_ROW_62_Left_166 VGND VGND VPWR VPWR sky130_fd_sc_hd__decap_3
X_4707_ _7376_/Q _4707_/A2 _4707_/A3 _4706_/X VGND VGND VPWR VPWR _4707_/X sky130_fd_sc_hd__a31o_2
Xplace2030 place2031/X VGND VGND VPWR VPWR place2030/X sky130_fd_sc_hd__buf_2
X_7426_ _7581_/CLK _7426_/D place2032/X VGND VGND VPWR VPWR _7426_/Q sky130_fd_sc_hd__dfrtp_2
X_4638_ _6465_/B _6436_/B _4735_/D VGND VGND VPWR VPWR _4638_/Y sky130_fd_sc_hd__o21ai_4
Xplace2063 place2065/X VGND VGND VPWR VPWR place2063/X sky130_fd_sc_hd__buf_2
Xplace2052 place2068/X VGND VGND VPWR VPWR place2052/X sky130_fd_sc_hd__buf_2
Xplace2041 place2044/X VGND VGND VPWR VPWR place2041/X sky130_fd_sc_hd__buf_2
Xplace1340 _5746_/X VGND VGND VPWR VPWR _5987_/B2 sky130_fd_sc_hd__buf_8
Xplace1351 _4192_/C VGND VGND VPWR VPWR _4190_/B sky130_fd_sc_hd__buf_2
Xplace1362 _4121_/Y VGND VGND VPWR VPWR _4123_/A2 sky130_fd_sc_hd__buf_2
X_7357_ clkload8/A _7357_/D place2026/X VGND VGND VPWR VPWR _7357_/Q sky130_fd_sc_hd__dfrtp_2
X_4569_ _4569_/A1 _4568_/Y _4569_/B1 VGND VGND VPWR VPWR _4569_/X sky130_fd_sc_hd__o21a_2
Xplace1373 _4189_/A VGND VGND VPWR VPWR _3887_/B sky130_fd_sc_hd__buf_2
Xplace1384 _3585_/Y VGND VGND VPWR VPWR _4675_/B sky130_fd_sc_hd__buf_2
Xplace1395 _4110_/Y VGND VGND VPWR VPWR _5764_/A sky130_fd_sc_hd__buf_2
Xrebuffer2363 _3576_/C VGND VGND VPWR VPWR _4595_/A3 sky130_fd_sc_hd__buf_2
X_7288_ _7288_/CLK _7288_/D VGND VGND VPWR VPWR _7288_/Q sky130_fd_sc_hd__dfxtp_2
X_6308_ _7390_/Q _6313_/A2 _6313_/A3 _6313_/B1 _6308_/B2 VGND VGND VPWR VPWR _7358_/D
+ sky130_fd_sc_hd__a32o_2
XFILLER_49_309 VGND VGND VPWR VPWR sky130_fd_sc_hd__fill_2
X_6239_ _6239_/A _6247_/A VGND VGND VPWR VPWR _7327_/D sky130_fd_sc_hd__or2b_2
XFILLER_69_180 VGND VGND VPWR VPWR sky130_fd_sc_hd__decap_3
XFILLER_57_353 VGND VGND VPWR VPWR sky130_fd_sc_hd__decap_3
XPHY_EDGE_ROW_71_Left_175 VGND VGND VPWR VPWR sky130_fd_sc_hd__decap_3
XFILLER_17_206 VGND VGND VPWR VPWR sky130_fd_sc_hd__decap_3
XFILLER_17_228 VGND VGND VPWR VPWR sky130_fd_sc_hd__decap_3
XFILLER_27_43 VGND VGND VPWR VPWR sky130_fd_sc_hd__decap_3
XFILLER_45_515 VGND VGND VPWR VPWR sky130_fd_sc_hd__decap_3
XFILLER_27_76 VGND VGND VPWR VPWR sky130_fd_sc_hd__fill_1
XFILLER_57_397 VGND VGND VPWR VPWR sky130_fd_sc_hd__decap_3
XFILLER_40_220 VGND VGND VPWR VPWR sky130_fd_sc_hd__decap_3
XFILLER_13_445 VGND VGND VPWR VPWR sky130_fd_sc_hd__decap_3
XFILLER_40_253 VGND VGND VPWR VPWR sky130_fd_sc_hd__decap_3
Xmax_cap2106 _5734_/Y VGND VGND VPWR VPWR _6406_/A3 sky130_fd_sc_hd__buf_2
XTAP_TAPCELL_ROW_80_1059 VGND VPWR sky130_fd_sc_hd__tapvpwrvgnd_1
XFILLER_40_264 VGND VGND VPWR VPWR sky130_fd_sc_hd__fill_1
XFILLER_43_86 VGND VGND VPWR VPWR sky130_fd_sc_hd__decap_3
XPHY_EDGE_ROW_80_Left_184 VGND VGND VPWR VPWR sky130_fd_sc_hd__decap_3
XTAP_TAPCELL_ROW_51_760 VGND VPWR sky130_fd_sc_hd__tapvpwrvgnd_1
XTAP_TAPCELL_ROW_23_462 VGND VPWR sky130_fd_sc_hd__tapvpwrvgnd_1
XFILLER_4_132 VGND VGND VPWR VPWR sky130_fd_sc_hd__decap_3
XTAP_TAPCELL_ROW_91_1177 VGND VPWR sky130_fd_sc_hd__tapvpwrvgnd_1
XFILLER_0_393 VGND VGND VPWR VPWR sky130_fd_sc_hd__decap_3
X_3940_ _3567_/A _4142_/B2 _4352_/C _3939_/X VGND VGND VPWR VPWR _3940_/X sky130_fd_sc_hd__a2bb2o_2
XFILLER_44_592 VGND VGND VPWR VPWR sky130_fd_sc_hd__fill_2
XFILLER_90_197 VGND VGND VPWR VPWR sky130_fd_sc_hd__fill_1
XFILLER_31_220 VGND VGND VPWR VPWR sky130_fd_sc_hd__decap_3
XFILLER_31_231 VGND VGND VPWR VPWR sky130_fd_sc_hd__decap_3
XFILLER_31_253 VGND VGND VPWR VPWR sky130_fd_sc_hd__fill_1
X_3871_ _7303_/Q _3920_/B _3867_/Y VGND VGND VPWR VPWR _3871_/Y sky130_fd_sc_hd__a21oi_2
XFILLER_31_264 VGND VGND VPWR VPWR sky130_fd_sc_hd__decap_3
X_6590_ _6590_/A0 _6496_/X _6590_/S VGND VGND VPWR VPWR _7459_/D sky130_fd_sc_hd__mux2_2
X_5610_ _5671_/A _5610_/B _5671_/B VGND VGND VPWR VPWR _5637_/S sky130_fd_sc_hd__and3_2
XFILLER_31_297 VGND VGND VPWR VPWR sky130_fd_sc_hd__decap_3
X_5541_ _5541_/A0 _5724_/A1 _5545_/S VGND VGND VPWR VPWR _7204_/D sky130_fd_sc_hd__mux2_2
XTAP_TAPCELL_ROW_100_1273 VGND VPWR sky130_fd_sc_hd__tapvpwrvgnd_1
X_7211_ _7272_/CLK _7211_/D VGND VGND VPWR VPWR _7211_/Q sky130_fd_sc_hd__dfxtp_2
X_4423_ _4508_/A _4508_/B _7591_/D VGND VGND VPWR VPWR _4423_/X sky130_fd_sc_hd__or3b_2
X_7142_ _7407_/CLK _7142_/D VGND VGND VPWR VPWR _7142_/Q sky130_fd_sc_hd__dfxtp_2
XFILLER_98_253 VGND VGND VPWR VPWR sky130_fd_sc_hd__fill_1
X_7073_ _7241_/CLK _7073_/D VGND VGND VPWR VPWR _7073_/Q sky130_fd_sc_hd__dfxtp_2
XFILLER_98_275 VGND VGND VPWR VPWR sky130_fd_sc_hd__fill_1
X_4285_ _4285_/A _4289_/B _4285_/C VGND VGND VPWR VPWR _4285_/X sky130_fd_sc_hd__and3_4
XFILLER_39_331 VGND VGND VPWR VPWR sky130_fd_sc_hd__decap_3
XFILLER_27_515 VGND VGND VPWR VPWR sky130_fd_sc_hd__fill_2
XFILLER_66_161 VGND VGND VPWR VPWR sky130_fd_sc_hd__fill_2
XTAP_TAPCELL_ROW_57_819 VGND VPWR sky130_fd_sc_hd__tapvpwrvgnd_1
XFILLER_39_397 VGND VGND VPWR VPWR sky130_fd_sc_hd__decap_3
XFILLER_42_507 VGND VGND VPWR VPWR sky130_fd_sc_hd__decap_3
X_6926_ _7290_/CLK _6926_/D VGND VGND VPWR VPWR _6926_/Q sky130_fd_sc_hd__dfxtp_2
XFILLER_35_592 VGND VGND VPWR VPWR sky130_fd_sc_hd__decap_3
XFILLER_22_231 VGND VGND VPWR VPWR sky130_fd_sc_hd__fill_2
XFILLER_80_29 VGND VGND VPWR VPWR sky130_fd_sc_hd__fill_2
X_6857_ _7280_/CLK _6857_/D VGND VGND VPWR VPWR _6857_/Q sky130_fd_sc_hd__dfxtp_2
XFILLER_22_286 VGND VGND VPWR VPWR sky130_fd_sc_hd__decap_3
X_5808_ _6171_/B1 _7165_/Q _7137_/Q _6165_/B2 VGND VGND VPWR VPWR _5808_/X sky130_fd_sc_hd__o22a_2
X_5739_ _5732_/S _4348_/C _5843_/B _5738_/Y _5739_/B2 VGND VGND VPWR VPWR _5739_/X
+ sky130_fd_sc_hd__o32a_2
XTAP_TAPCELL_ROW_20_432 VGND VPWR sky130_fd_sc_hd__tapvpwrvgnd_1
XFILLER_13_67 VGND VGND VPWR VPWR sky130_fd_sc_hd__decap_3
X_7409_ _7507_/CLK _7409_/D place2041/X VGND VGND VPWR VPWR _7409_/Q sky130_fd_sc_hd__dfrtp_2
XFILLER_1_113 VGND VGND VPWR VPWR sky130_fd_sc_hd__decap_3
Xplace1170 _5213_/S VGND VGND VPWR VPWR _5207_/S sky130_fd_sc_hd__buf_2
Xplace1181 _5637_/S VGND VGND VPWR VPWR _5669_/S sky130_fd_sc_hd__buf_2
Xplace1192 _5095_/S VGND VGND VPWR VPWR _5120_/S sky130_fd_sc_hd__buf_2
Xrebuffer2160 place1326/X VGND VGND VPWR VPWR _6504_/A2 sky130_fd_sc_hd__buf_2
Xrebuffer2171 _3669_/A3 VGND VGND VPWR VPWR place1528/A sky130_fd_sc_hd__buf_2
Xrebuffer2182 _5999_/A1 VGND VGND VPWR VPWR _6397_/A1 sky130_fd_sc_hd__buf_2
XFILLER_49_106 VGND VGND VPWR VPWR sky130_fd_sc_hd__decap_3
Xrebuffer2193 _5984_/B1 VGND VGND VPWR VPWR _6453_/B1 sky130_fd_sc_hd__buf_2
XFILLER_73_610 VGND VGND VPWR VPWR sky130_fd_sc_hd__fill_2
XFILLER_18_548 VGND VGND VPWR VPWR sky130_fd_sc_hd__fill_1
XFILLER_57_172 VGND VGND VPWR VPWR sky130_fd_sc_hd__decap_3
XTAP_TAPCELL_ROW_28_521 VGND VPWR sky130_fd_sc_hd__tapvpwrvgnd_1
XFILLER_33_529 VGND VGND VPWR VPWR sky130_fd_sc_hd__decap_3
XFILLER_54_63 VGND VGND VPWR VPWR sky130_fd_sc_hd__decap_3
XFILLER_60_326 VGND VGND VPWR VPWR sky130_fd_sc_hd__decap_3
XFILLER_13_231 VGND VGND VPWR VPWR sky130_fd_sc_hd__decap_3
XFILLER_60_348 VGND VGND VPWR VPWR sky130_fd_sc_hd__fill_2
XFILLER_60_359 VGND VGND VPWR VPWR sky130_fd_sc_hd__decap_3
XFILLER_13_297 VGND VGND VPWR VPWR sky130_fd_sc_hd__decap_3
XFILLER_9_235 VGND VGND VPWR VPWR sky130_fd_sc_hd__decap_3
XFILLER_9_268 VGND VGND VPWR VPWR sky130_fd_sc_hd__decap_3
Xclkload16 _7610_/CLK VGND VGND VPWR VPWR clkload16/X sky130_fd_sc_hd__clkbuf_8
Xclkload27 _7274_/CLK VGND VGND VPWR VPWR clkload27/Y sky130_fd_sc_hd__clkinv_2
X_4070_ _4532_/B _4077_/D VGND VGND VPWR VPWR _4071_/B sky130_fd_sc_hd__nand2_2
XFILLER_36_345 VGND VGND VPWR VPWR sky130_fd_sc_hd__decap_3
Xplace120 _4235_/Y VGND VGND VPWR VPWR place120/X sky130_fd_sc_hd__buf_4
XFILLER_24_529 VGND VGND VPWR VPWR sky130_fd_sc_hd__decap_3
XFILLER_51_337 VGND VGND VPWR VPWR sky130_fd_sc_hd__fill_1
XFILLER_51_348 VGND VGND VPWR VPWR sky130_fd_sc_hd__decap_3
X_3923_ _7428_/Q _3923_/A2 _3923_/B1 _7332_/Q VGND VGND VPWR VPWR _3923_/X sky130_fd_sc_hd__a22o_2
XFILLER_32_584 VGND VGND VPWR VPWR sky130_fd_sc_hd__decap_3
X_3854_ _7562_/Q _3854_/A2 _3598_/X _7338_/Q _3853_/X VGND VGND VPWR VPWR _3854_/X
+ sky130_fd_sc_hd__a221o_2
XTAP_TAPCELL_ROW_62_877 VGND VPWR sky130_fd_sc_hd__tapvpwrvgnd_1
XTAP_TAPCELL_ROW_34_579 VGND VPWR sky130_fd_sc_hd__tapvpwrvgnd_1
XFILLER_32_595 VGND VGND VPWR VPWR sky130_fd_sc_hd__fill_1
X_6573_ _6302_/A _6302_/B _6302_/C _6304_/B _6347_/A VGND VGND VPWR VPWR _6600_/S
+ sky130_fd_sc_hd__o311a_2
X_3785_ _3785_/A _3785_/B VGND VGND VPWR VPWR _4236_/D sky130_fd_sc_hd__nand2_2
X_5524_ _5524_/A0 _4700_/X _5532_/S VGND VGND VPWR VPWR _7196_/D sky130_fd_sc_hd__mux2_2
X_4406_ _4405_/X _4352_/A _4406_/B1 VGND VGND VPWR VPWR _4408_/D sky130_fd_sc_hd__a21o_2
X_7125_ _7393_/CLK _7125_/D VGND VGND VPWR VPWR _7125_/Q sky130_fd_sc_hd__dfxtp_2
XFILLER_101_501 VGND VGND VPWR VPWR sky130_fd_sc_hd__decap_3
XFILLER_99_584 VGND VGND VPWR VPWR sky130_fd_sc_hd__decap_3
X_4337_ _4352_/B _4337_/B _4473_/B _4337_/D VGND VGND VPWR VPWR _4337_/X sky130_fd_sc_hd__and4_2
X_7056_ _7280_/CLK _7056_/D VGND VGND VPWR VPWR _7056_/Q sky130_fd_sc_hd__dfxtp_2
X_4268_ _4263_/Y _4265_/X _4267_/Y _4300_/A3 _3582_/A VGND VGND VPWR VPWR _4269_/C
+ sky130_fd_sc_hd__o32a_2
XFILLER_101_589 VGND VGND VPWR VPWR sky130_fd_sc_hd__decap_3
X_6007_ _6168_/B2 _6927_/Q _7263_/Q _6173_/B2 VGND VGND VPWR VPWR _6007_/X sky130_fd_sc_hd__o22a_2
XFILLER_39_172 VGND VGND VPWR VPWR sky130_fd_sc_hd__decap_3
X_4199_ _3834_/B _4199_/A2 _4212_/B _4212_/A VGND VGND VPWR VPWR _4200_/C sky130_fd_sc_hd__o211a_2
XFILLER_42_326 VGND VGND VPWR VPWR sky130_fd_sc_hd__decap_3
XFILLER_54_186 VGND VGND VPWR VPWR sky130_fd_sc_hd__decap_3
XFILLER_54_197 VGND VGND VPWR VPWR sky130_fd_sc_hd__decap_3
XFILLER_42_359 VGND VGND VPWR VPWR sky130_fd_sc_hd__decap_3
X_6909_ _7273_/CLK _6909_/D VGND VGND VPWR VPWR _6909_/Q sky130_fd_sc_hd__dfxtp_2
XFILLER_24_66 VGND VGND VPWR VPWR sky130_fd_sc_hd__decap_3
XFILLER_24_88 VGND VGND VPWR VPWR sky130_fd_sc_hd__decap_3
XFILLER_10_256 VGND VGND VPWR VPWR sky130_fd_sc_hd__decap_3
XTAP_TAPCELL_ROW_79_1050 VGND VPWR sky130_fd_sc_hd__tapvpwrvgnd_1
XFILLER_2_477 VGND VGND VPWR VPWR sky130_fd_sc_hd__decap_3
XFILLER_2_499 VGND VGND VPWR VPWR sky130_fd_sc_hd__decap_3
XFILLER_49_85 VGND VGND VPWR VPWR sky130_fd_sc_hd__decap_3
XTAP_TAPCELL_ROW_5_271 VGND VPWR sky130_fd_sc_hd__tapvpwrvgnd_1
XFILLER_18_334 VGND VGND VPWR VPWR sky130_fd_sc_hd__decap_3
XFILLER_45_131 VGND VGND VPWR VPWR sky130_fd_sc_hd__fill_2
XFILLER_65_84 VGND VGND VPWR VPWR sky130_fd_sc_hd__decap_3
XFILLER_33_337 VGND VGND VPWR VPWR sky130_fd_sc_hd__decap_3
XTAP_TAPCELL_ROW_31_549 VGND VPWR sky130_fd_sc_hd__tapvpwrvgnd_1
Xplace1917 _3416_/Y VGND VGND VPWR VPWR _3462_/A sky130_fd_sc_hd__buf_2
Xplace1906 _3516_/A2 VGND VGND VPWR VPWR _3495_/A1 sky130_fd_sc_hd__buf_2
Xplace1939 _7409_/Q VGND VGND VPWR VPWR _6383_/B2 sky130_fd_sc_hd__buf_2
Xplace1928 _3844_/A VGND VGND VPWR VPWR _7582_/D sky130_fd_sc_hd__buf_2
X_5240_ _5240_/A0 _5566_/A1 _5299_/S VGND VGND VPWR VPWR _7075_/D sky130_fd_sc_hd__mux2_2
XFILLER_46_3 VGND VGND VPWR VPWR sky130_fd_sc_hd__decap_3
XPHY_EDGE_ROW_18_Right_18 VGND VGND VPWR VPWR sky130_fd_sc_hd__decap_3
Xhold2619 _7269_/Q VGND VGND VPWR VPWR _5684_/A0 sky130_fd_sc_hd__dlygate4sd3_1
Xhold2608 _7247_/Q VGND VGND VPWR VPWR _5635_/A0 sky130_fd_sc_hd__dlygate4sd3_1
X_5171_ _5171_/A0 _5566_/A1 _5179_/S VGND VGND VPWR VPWR _7047_/D sky130_fd_sc_hd__mux2_2
XFILLER_68_223 VGND VGND VPWR VPWR sky130_fd_sc_hd__fill_1
XFILLER_68_256 VGND VGND VPWR VPWR sky130_fd_sc_hd__decap_3
X_4122_ _4120_/Y _4121_/Y _6465_/B VGND VGND VPWR VPWR _4122_/Y sky130_fd_sc_hd__a21oi_2
XFILLER_56_418 VGND VGND VPWR VPWR sky130_fd_sc_hd__fill_2
X_4053_ _4495_/A _4055_/C VGND VGND VPWR VPWR _7597_/D sky130_fd_sc_hd__xor2_2
XTAP_TAPCELL_ROW_67_925 VGND VPWR sky130_fd_sc_hd__tapvpwrvgnd_1
XFILLER_49_470 VGND VGND VPWR VPWR sky130_fd_sc_hd__decap_3
XFILLER_24_304 VGND VGND VPWR VPWR sky130_fd_sc_hd__decap_3
XFILLER_24_315 VGND VGND VPWR VPWR sky130_fd_sc_hd__decap_3
XFILLER_101_38 VGND VGND VPWR VPWR sky130_fd_sc_hd__fill_1
XFILLER_51_134 VGND VGND VPWR VPWR sky130_fd_sc_hd__decap_3
XPHY_EDGE_ROW_27_Right_27 VGND VGND VPWR VPWR sky130_fd_sc_hd__decap_3
XFILLER_51_156 VGND VGND VPWR VPWR sky130_fd_sc_hd__decap_3
X_3906_ _3906_/A VGND VGND VPWR VPWR _4148_/A sky130_fd_sc_hd__inv_2
XFILLER_20_554 VGND VGND VPWR VPWR sky130_fd_sc_hd__decap_3
X_3837_ _7371_/Q _3544_/B _3544_/C _3984_/B1 _7531_/Q VGND VGND VPWR VPWR _3837_/X
+ sky130_fd_sc_hd__a32o_2
X_3768_ _7507_/Q _3788_/B1 _3810_/B1 _7443_/Q VGND VGND VPWR VPWR _3771_/A sky130_fd_sc_hd__a22oi_2
XFILLER_3_208 VGND VGND VPWR VPWR sky130_fd_sc_hd__decap_3
X_5507_ _5507_/A0 _5690_/A1 _5513_/S VGND VGND VPWR VPWR _7188_/D sky130_fd_sc_hd__mux2_2
X_6487_ _4735_/X _6459_/Y _6472_/X _4639_/Y _6486_/X VGND VGND VPWR VPWR _6487_/X
+ sky130_fd_sc_hd__o221a_2
X_3699_ _3688_/Y _3699_/B _4151_/A _3699_/D VGND VGND VPWR VPWR _3701_/A sky130_fd_sc_hd__and4b_2
XPHY_EDGE_ROW_36_Right_36 VGND VGND VPWR VPWR sky130_fd_sc_hd__decap_3
XFILLER_59_212 VGND VGND VPWR VPWR sky130_fd_sc_hd__decap_3
X_7108_ _7217_/CLK _7108_/D VGND VGND VPWR VPWR _7108_/Q sky130_fd_sc_hd__dfxtp_2
XFILLER_59_278 VGND VGND VPWR VPWR sky130_fd_sc_hd__fill_2
X_7039_ _7565_/CLK _7039_/D VGND VGND VPWR VPWR _7039_/Q sky130_fd_sc_hd__dfxtp_2
XFILLER_101_397 VGND VGND VPWR VPWR sky130_fd_sc_hd__fill_1
XFILLER_74_226 VGND VGND VPWR VPWR sky130_fd_sc_hd__fill_1
XFILLER_19_99 VGND VGND VPWR VPWR sky130_fd_sc_hd__fill_1
XTAP_TAPCELL_ROW_2_241 VGND VPWR sky130_fd_sc_hd__tapvpwrvgnd_1
XFILLER_27_164 VGND VGND VPWR VPWR sky130_fd_sc_hd__decap_3
XPHY_EDGE_ROW_45_Right_45 VGND VGND VPWR VPWR sky130_fd_sc_hd__decap_3
XFILLER_15_337 VGND VGND VPWR VPWR sky130_fd_sc_hd__fill_2
XFILLER_35_54 VGND VGND VPWR VPWR sky130_fd_sc_hd__fill_2
XFILLER_42_189 VGND VGND VPWR VPWR sky130_fd_sc_hd__decap_3
XFILLER_7_536 VGND VGND VPWR VPWR sky130_fd_sc_hd__decap_3
XPHY_EDGE_ROW_54_Right_54 VGND VGND VPWR VPWR sky130_fd_sc_hd__decap_3
XFILLER_78_521 VGND VGND VPWR VPWR sky130_fd_sc_hd__fill_2
XFILLER_65_237 VGND VGND VPWR VPWR sky130_fd_sc_hd__decap_3
XFILLER_76_83 VGND VGND VPWR VPWR sky130_fd_sc_hd__fill_1
XPHY_EDGE_ROW_63_Right_63 VGND VGND VPWR VPWR sky130_fd_sc_hd__decap_3
XTAP_TAPCELL_ROW_88_1149 VGND VPWR sky130_fd_sc_hd__tapvpwrvgnd_1
XFILLER_33_101 VGND VGND VPWR VPWR sky130_fd_sc_hd__fill_1
XFILLER_61_410 VGND VGND VPWR VPWR sky130_fd_sc_hd__fill_2
XFILLER_21_307 VGND VGND VPWR VPWR sky130_fd_sc_hd__decap_3
XTAP_TAPCELL_ROW_72_983 VGND VPWR sky130_fd_sc_hd__tapvpwrvgnd_1
XFILLER_21_329 VGND VGND VPWR VPWR sky130_fd_sc_hd__decap_3
XTAP_TAPCELL_ROW_44_685 VGND VPWR sky130_fd_sc_hd__tapvpwrvgnd_1
XTAP_TAPCELL_ROW_16_387 VGND VPWR sky130_fd_sc_hd__tapvpwrvgnd_1
X_7390_ clkload8/A _7390_/D place2026/X VGND VGND VPWR VPWR _7390_/Q sky130_fd_sc_hd__dfrtp_2
X_6410_ _6704_/A0 _6410_/A2 _6410_/A3 _6410_/B1 _7417_/Q VGND VGND VPWR VPWR _6410_/X
+ sky130_fd_sc_hd__a32o_2
XTAP_TAPCELL_ROW_99_1267 VGND VPWR sky130_fd_sc_hd__tapvpwrvgnd_1
XPHY_EDGE_ROW_72_Right_72 VGND VGND VPWR VPWR sky130_fd_sc_hd__decap_3
X_6341_ _7414_/Q _6344_/A2 _6344_/A3 _6344_/B1 _6341_/B2 VGND VGND VPWR VPWR _6341_/X
+ sky130_fd_sc_hd__a32o_2
Xplace1703 _3567_/A VGND VGND VPWR VPWR _4905_/A sky130_fd_sc_hd__buf_2
Xplace1714 _3535_/Y VGND VGND VPWR VPWR _3653_/C1 sky130_fd_sc_hd__buf_2
Xplace1725 place1725/A VGND VGND VPWR VPWR _3534_/A2 sky130_fd_sc_hd__buf_6
Xplace1736 _3860_/A2 VGND VGND VPWR VPWR _4211_/A sky130_fd_sc_hd__buf_2
X_3553_ _6307_/B2 _3978_/B _7453_/Q _3553_/B2 VGND VGND VPWR VPWR _3563_/B sky130_fd_sc_hd__a22oi_2
XFILLER_88_307 VGND VGND VPWR VPWR sky130_fd_sc_hd__fill_1
Xplace1747 _3793_/A2 VGND VGND VPWR VPWR _3718_/B1 sky130_fd_sc_hd__buf_2
Xplace1758 _3855_/A2 VGND VGND VPWR VPWR _3914_/A2 sky130_fd_sc_hd__buf_4
Xplace1769 _3975_/A VGND VGND VPWR VPWR _6513_/B1 sky130_fd_sc_hd__buf_2
X_3484_ _4473_/C _3460_/Y _3484_/A3 _3481_/Y _3483_/Y VGND VGND VPWR VPWR _3490_/A
+ sky130_fd_sc_hd__o32ai_2
Xhold2427 _7159_/Q VGND VGND VPWR VPWR _5444_/A0 sky130_fd_sc_hd__dlygate4sd3_1
Xhold2416 _7010_/Q VGND VGND VPWR VPWR _5089_/A0 sky130_fd_sc_hd__dlygate4sd3_1
Xhold2405 _6926_/Q VGND VGND VPWR VPWR _4900_/A0 sky130_fd_sc_hd__dlygate4sd3_1
X_5154_ _5671_/A _5304_/B _5671_/C VGND VGND VPWR VPWR _5211_/S sky130_fd_sc_hd__and3_2
Xhold2449 _6946_/Q VGND VGND VPWR VPWR _4945_/A0 sky130_fd_sc_hd__dlygate4sd3_1
Xhold2438 _6988_/Q VGND VGND VPWR VPWR _5042_/A0 sky130_fd_sc_hd__dlygate4sd3_1
X_4105_ _4105_/A VGND VGND VPWR VPWR _4105_/Y sky130_fd_sc_hd__inv_2
XPHY_EDGE_ROW_81_Right_81 VGND VGND VPWR VPWR sky130_fd_sc_hd__decap_3
X_5085_ _5085_/A0 _4757_/Y _5085_/S VGND VGND VPWR VPWR _7008_/D sky130_fd_sc_hd__mux2_2
X_4036_ _4036_/A _7299_/Q _7300_/Q _4036_/D VGND VGND VPWR VPWR _4043_/D sky130_fd_sc_hd__and4_2
XFILLER_52_443 VGND VGND VPWR VPWR sky130_fd_sc_hd__fill_1
XFILLER_64_281 VGND VGND VPWR VPWR sky130_fd_sc_hd__fill_2
X_5987_ _5987_/A1 _6884_/Q _7276_/Q _5987_/B2 VGND VGND VPWR VPWR _5989_/A sky130_fd_sc_hd__o22a_2
XANTENNA_30 _5338_/A0 VGND VGND VPWR VPWR sky130_fd_sc_hd__diode_2
XANTENNA_41 _6153_/B1 VGND VGND VPWR VPWR sky130_fd_sc_hd__diode_2
XANTENNA_52 _7085_/Q VGND VGND VPWR VPWR sky130_fd_sc_hd__diode_2
XPHY_EDGE_ROW_90_Right_90 VGND VGND VPWR VPWR sky130_fd_sc_hd__decap_3
XFILLER_4_506 VGND VGND VPWR VPWR sky130_fd_sc_hd__decap_3
X_7588_ clkload5/A _7588_/D place2062/X VGND VGND VPWR VPWR _7588_/Q sky130_fd_sc_hd__dfrtp_2
XFILLER_4_528 VGND VGND VPWR VPWR sky130_fd_sc_hd__decap_3
X_6539_ _7440_/Q _6159_/X _6541_/S VGND VGND VPWR VPWR _7440_/D sky130_fd_sc_hd__mux2_2
XTAP_TAPCELL_ROW_76_1020 VGND VPWR sky130_fd_sc_hd__tapvpwrvgnd_1
XTAP_TAPCELL_ROW_7_300 VGND VPWR sky130_fd_sc_hd__tapvpwrvgnd_1
Xhold2950 _7492_/Q VGND VGND VPWR VPWR _6363_/A1 sky130_fd_sc_hd__dlygate4sd3_1
XFILLER_75_546 VGND VGND VPWR VPWR sky130_fd_sc_hd__decap_3
Xhold2961 _7490_/Q VGND VGND VPWR VPWR _6655_/A0 sky130_fd_sc_hd__dlygate4sd3_1
Xhold2972 _7504_/Q VGND VGND VPWR VPWR _6685_/A0 sky130_fd_sc_hd__dlygate4sd3_1
Xhold2983 _7542_/Q VGND VGND VPWR VPWR _6765_/A1 sky130_fd_sc_hd__dlygate4sd3_1
XFILLER_28_451 VGND VGND VPWR VPWR sky130_fd_sc_hd__decap_3
Xhold2994 _7521_/Q VGND VGND VPWR VPWR _4350_/A1 sky130_fd_sc_hd__dlygate4sd3_1
XFILLER_16_602 VGND VGND VPWR VPWR sky130_fd_sc_hd__fill_2
XFILLER_43_410 VGND VGND VPWR VPWR sky130_fd_sc_hd__decap_3
XFILLER_28_495 VGND VGND VPWR VPWR sky130_fd_sc_hd__fill_1
XFILLER_55_281 VGND VGND VPWR VPWR sky130_fd_sc_hd__decap_3
XFILLER_30_148 VGND VGND VPWR VPWR sky130_fd_sc_hd__decap_3
XTAP_TAPCELL_ROW_41_655 VGND VPWR sky130_fd_sc_hd__tapvpwrvgnd_1
XTAP_TAPCELL_ROW_13_357 VGND VPWR sky130_fd_sc_hd__tapvpwrvgnd_1
XFILLER_7_333 VGND VGND VPWR VPWR sky130_fd_sc_hd__decap_3
XFILLER_3_561 VGND VGND VPWR VPWR sky130_fd_sc_hd__decap_3
XFILLER_97_148 VGND VGND VPWR VPWR sky130_fd_sc_hd__decap_3
XFILLER_38_237 VGND VGND VPWR VPWR sky130_fd_sc_hd__decap_3
XTAP_TAPCELL_ROW_49_733 VGND VPWR sky130_fd_sc_hd__tapvpwrvgnd_1
XFILLER_81_505 VGND VGND VPWR VPWR sky130_fd_sc_hd__decap_3
X_5910_ _6501_/A1 _7050_/Q _6854_/Q _6510_/B2 VGND VGND VPWR VPWR _5910_/X sky130_fd_sc_hd__o22a_2
XFILLER_34_421 VGND VGND VPWR VPWR sky130_fd_sc_hd__decap_3
X_6890_ _7282_/CLK _6890_/D VGND VGND VPWR VPWR _6890_/Q sky130_fd_sc_hd__dfxtp_2
XFILLER_61_240 VGND VGND VPWR VPWR sky130_fd_sc_hd__decap_3
X_5841_ _5850_/A _5841_/B _5850_/B _5850_/C VGND VGND VPWR VPWR _5841_/X sky130_fd_sc_hd__or4_2
X_5772_ _5771_/Y _5941_/A3 _4904_/A VGND VGND VPWR VPWR _5772_/Y sky130_fd_sc_hd__o21ai_4
X_7511_ _7542_/CLK _7511_/D place2048/X VGND VGND VPWR VPWR _7511_/Q sky130_fd_sc_hd__dfrtp_2
X_4723_ _4723_/A0 _5713_/A1 _4776_/S VGND VGND VPWR VPWR _6863_/D sky130_fd_sc_hd__mux2_2
X_7442_ _7507_/CLK _7442_/D place2037/X VGND VGND VPWR VPWR _7442_/Q sky130_fd_sc_hd__dfrtp_2
X_4654_ _4654_/A1 _4735_/C _4639_/Y VGND VGND VPWR VPWR _4654_/Y sky130_fd_sc_hd__o21ai_2
Xplace1500 _3867_/Y VGND VGND VPWR VPWR _4449_/B1 sky130_fd_sc_hd__buf_2
Xplace1511 _3782_/Y VGND VGND VPWR VPWR _4705_/A1 sky130_fd_sc_hd__buf_2
X_7373_ _7514_/CLK _7373_/D place2043/X VGND VGND VPWR VPWR _7373_/Q sky130_fd_sc_hd__dfrtp_2
X_4585_ _5862_/A3 _4584_/X _5764_/A VGND VGND VPWR VPWR _4904_/B sky130_fd_sc_hd__a21o_2
Xplace1522 _3719_/Y VGND VGND VPWR VPWR _4763_/A2 sky130_fd_sc_hd__buf_2
Xplace1533 _3539_/Y VGND VGND VPWR VPWR _4608_/B1 sky130_fd_sc_hd__buf_2
Xplace1544 _4005_/X VGND VGND VPWR VPWR _4761_/A sky130_fd_sc_hd__buf_2
X_6324_ _6373_/B2 _6324_/A2 _6346_/A3 _6324_/B1 _3842_/A VGND VGND VPWR VPWR _7371_/D
+ sky130_fd_sc_hd__a32o_2
X_3536_ _3536_/A _3536_/B _3536_/C _3536_/D VGND VGND VPWR VPWR _3536_/X sky130_fd_sc_hd__and4_4
Xplace1555 _3959_/A1 VGND VGND VPWR VPWR _4755_/A sky130_fd_sc_hd__buf_2
Xplace1566 _3836_/X VGND VGND VPWR VPWR _4565_/A1 sky130_fd_sc_hd__buf_2
Xplace1577 _3564_/Y VGND VGND VPWR VPWR _3919_/A sky130_fd_sc_hd__buf_6
Xplace1588 _3567_/Y VGND VGND VPWR VPWR _4095_/B2 sky130_fd_sc_hd__buf_2
Xplace1599 _3628_/X VGND VGND VPWR VPWR _3803_/B sky130_fd_sc_hd__buf_2
X_3467_ _3480_/A _3480_/B VGND VGND VPWR VPWR _3524_/B sky130_fd_sc_hd__nand2_2
XFILLER_69_340 VGND VGND VPWR VPWR sky130_fd_sc_hd__decap_3
X_6186_ _4970_/A _4970_/B _4970_/C _7006_/Q _6186_/C1 VGND VGND VPWR VPWR _6186_/X
+ sky130_fd_sc_hd__a311o_2
X_5137_ _5137_/A0 _5532_/A1 _5152_/S VGND VGND VPWR VPWR _7032_/D sky130_fd_sc_hd__mux2_2
XFILLER_57_546 VGND VGND VPWR VPWR sky130_fd_sc_hd__fill_2
XFILLER_57_557 VGND VGND VPWR VPWR sky130_fd_sc_hd__decap_3
X_5068_ _5068_/A0 _5190_/A1 _5085_/S VGND VGND VPWR VPWR _7000_/D sky130_fd_sc_hd__mux2_2
X_4019_ _4609_/A _6465_/B _4609_/C _4018_/Y VGND VGND VPWR VPWR _4020_/A sky130_fd_sc_hd__o31a_4
XFILLER_25_443 VGND VGND VPWR VPWR sky130_fd_sc_hd__fill_1
XFILLER_25_454 VGND VGND VPWR VPWR sky130_fd_sc_hd__decap_3
XFILLER_52_251 VGND VGND VPWR VPWR sky130_fd_sc_hd__fill_1
XPHY_EDGE_ROW_0_Right_0 VGND VGND VPWR VPWR sky130_fd_sc_hd__decap_3
XFILLER_12_115 VGND VGND VPWR VPWR sky130_fd_sc_hd__decap_3
XFILLER_12_126 VGND VGND VPWR VPWR sky130_fd_sc_hd__decap_3
XFILLER_20_181 VGND VGND VPWR VPWR sky130_fd_sc_hd__decap_3
XFILLER_32_88 VGND VGND VPWR VPWR sky130_fd_sc_hd__decap_3
XTAP_TAPCELL_ROW_10_327 VGND VPWR sky130_fd_sc_hd__tapvpwrvgnd_1
XFILLER_0_542 VGND VGND VPWR VPWR sky130_fd_sc_hd__fill_1
XFILLER_0_553 VGND VGND VPWR VPWR sky130_fd_sc_hd__decap_3
XFILLER_0_564 VGND VGND VPWR VPWR sky130_fd_sc_hd__decap_3
XFILLER_95_608 VGND VGND VPWR VPWR sky130_fd_sc_hd__decap_3
XFILLER_75_310 VGND VGND VPWR VPWR sky130_fd_sc_hd__decap_3
XFILLER_48_568 VGND VGND VPWR VPWR sky130_fd_sc_hd__fill_2
Xhold2780 _6866_/Q VGND VGND VPWR VPWR _4747_/A0 sky130_fd_sc_hd__dlygate4sd3_1
Xhold2791 _6979_/Q VGND VGND VPWR VPWR _5022_/A0 sky130_fd_sc_hd__dlygate4sd3_1
XFILLER_35_207 VGND VGND VPWR VPWR sky130_fd_sc_hd__decap_3
XTAP_TAPCELL_ROW_85_1119 VGND VPWR sky130_fd_sc_hd__tapvpwrvgnd_1
XTAP_TAPCELL_ROW_46_703 VGND VPWR sky130_fd_sc_hd__tapvpwrvgnd_1
XTAP_TAPCELL_ROW_18_416 VGND VPWR sky130_fd_sc_hd__tapvpwrvgnd_1
XFILLER_16_421 VGND VGND VPWR VPWR sky130_fd_sc_hd__decap_3
XFILLER_31_424 VGND VGND VPWR VPWR sky130_fd_sc_hd__decap_3
XTAP_TAPCELL_ROW_54_791 VGND VPWR sky130_fd_sc_hd__tapvpwrvgnd_1
XTAP_TAPCELL_ROW_26_493 VGND VPWR sky130_fd_sc_hd__tapvpwrvgnd_1
XFILLER_11_181 VGND VGND VPWR VPWR sky130_fd_sc_hd__decap_3
XTAP_TAPCELL_ROW_96_1226 VGND VPWR sky130_fd_sc_hd__tapvpwrvgnd_1
X_4370_ _4373_/C _4361_/B _4362_/C _4369_/X VGND VGND VPWR VPWR _4375_/A sky130_fd_sc_hd__a22o_2
X_6040_ _6220_/A1 _6229_/A2 _6229_/B1 _7590_/Q _6039_/X VGND VGND VPWR VPWR _6040_/X
+ sky130_fd_sc_hd__o221a_4
XFILLER_85_129 VGND VGND VPWR VPWR sky130_fd_sc_hd__fill_1
XFILLER_66_365 VGND VGND VPWR VPWR sky130_fd_sc_hd__decap_3
XFILLER_19_281 VGND VGND VPWR VPWR sky130_fd_sc_hd__decap_3
X_6942_ _7279_/CLK _6942_/D VGND VGND VPWR VPWR _6942_/Q sky130_fd_sc_hd__dfxtp_2
XFILLER_34_251 VGND VGND VPWR VPWR sky130_fd_sc_hd__fill_1
X_6873_ _7393_/CLK _6873_/D VGND VGND VPWR VPWR _6873_/Q sky130_fd_sc_hd__dfxtp_2
XFILLER_22_424 VGND VGND VPWR VPWR sky130_fd_sc_hd__decap_3
X_5824_ _6180_/A1 _6180_/A2 _6347_/D VGND VGND VPWR VPWR _5824_/Y sky130_fd_sc_hd__a21oi_2
X_5755_ _6088_/A _3802_/C _5759_/D1 _5755_/C1 _4842_/C VGND VGND VPWR VPWR _5755_/Y
+ sky130_fd_sc_hd__o2111ai_4
X_5686_ _5686_/A0 _5686_/A1 _5696_/S VGND VGND VPWR VPWR _7270_/D sky130_fd_sc_hd__mux2_2
X_4706_ _4733_/B1 _4595_/X _4727_/D _4704_/X _4705_/Y VGND VGND VPWR VPWR _4706_/X
+ sky130_fd_sc_hd__o311a_2
Xplace2020 place2021/X VGND VGND VPWR VPWR place2020/X sky130_fd_sc_hd__buf_2
X_7425_ clkload7/A _7425_/D place2025/X VGND VGND VPWR VPWR _7425_/Q sky130_fd_sc_hd__dfrtp_2
X_4637_ _4637_/A _4637_/B VGND VGND VPWR VPWR _6436_/B sky130_fd_sc_hd__nand2_2
Xplace2064 place2065/X VGND VGND VPWR VPWR place2064/X sky130_fd_sc_hd__buf_2
Xplace2053 place2055/X VGND VGND VPWR VPWR place2053/X sky130_fd_sc_hd__buf_2
Xplace2042 place2044/X VGND VGND VPWR VPWR place2042/X sky130_fd_sc_hd__buf_2
Xplace2031 place2032/X VGND VGND VPWR VPWR place2031/X sky130_fd_sc_hd__buf_2
Xplace1330 _5987_/A1 VGND VGND VPWR VPWR _5999_/A1 sky130_fd_sc_hd__buf_8
Xplace1341 _5959_/A1 VGND VGND VPWR VPWR _6476_/A1 sky130_fd_sc_hd__buf_2
Xplace1352 _4190_/A VGND VGND VPWR VPWR _4183_/A2 sky130_fd_sc_hd__buf_2
X_7356_ _7581_/CLK _7356_/D place2019/X VGND VGND VPWR VPWR _7356_/Q sky130_fd_sc_hd__dfrtp_2
X_4568_ _4568_/A _4568_/B _4568_/C _4568_/D VGND VGND VPWR VPWR _4568_/Y sky130_fd_sc_hd__nand4_2
Xplace1363 _4119_/A VGND VGND VPWR VPWR _5755_/C1 sky130_fd_sc_hd__buf_6
Xplace1374 _4197_/B VGND VGND VPWR VPWR _4212_/B sky130_fd_sc_hd__buf_2
Xplace1385 _6304_/X VGND VGND VPWR VPWR _6324_/B1 sky130_fd_sc_hd__buf_2
X_7287_ _7287_/CLK _7287_/D VGND VGND VPWR VPWR _7287_/Q sky130_fd_sc_hd__dfxtp_2
X_6307_ _6356_/B2 _6313_/A2 _6313_/A3 _6313_/B1 _6307_/B2 VGND VGND VPWR VPWR _7357_/D
+ sky130_fd_sc_hd__a32o_2
X_4499_ _4533_/A _4499_/B _4499_/C _4533_/D VGND VGND VPWR VPWR _4499_/X sky130_fd_sc_hd__or4_2
X_3519_ _3519_/A _3519_/B _3519_/C _3519_/D VGND VGND VPWR VPWR _3536_/B sky130_fd_sc_hd__nand4_4
XFILLER_89_457 VGND VGND VPWR VPWR sky130_fd_sc_hd__decap_3
Xplace1396 _4582_/A VGND VGND VPWR VPWR _4970_/B sky130_fd_sc_hd__buf_2
X_6169_ _6167_/X _6168_/X _6457_/B1 _6482_/A2 VGND VGND VPWR VPWR _6169_/X sky130_fd_sc_hd__a211o_2
XFILLER_17_218 VGND VGND VPWR VPWR sky130_fd_sc_hd__decap_3
XFILLER_45_505 VGND VGND VPWR VPWR sky130_fd_sc_hd__decap_3
XFILLER_57_365 VGND VGND VPWR VPWR sky130_fd_sc_hd__fill_1
XFILLER_72_302 VGND VGND VPWR VPWR sky130_fd_sc_hd__decap_3
XFILLER_60_519 VGND VGND VPWR VPWR sky130_fd_sc_hd__decap_3
XFILLER_72_379 VGND VGND VPWR VPWR sky130_fd_sc_hd__fill_1
XFILLER_25_284 VGND VGND VPWR VPWR sky130_fd_sc_hd__decap_3
XFILLER_53_571 VGND VGND VPWR VPWR sky130_fd_sc_hd__fill_1
XFILLER_43_76 VGND VGND VPWR VPWR sky130_fd_sc_hd__fill_2
XFILLER_43_98 VGND VGND VPWR VPWR sky130_fd_sc_hd__decap_3
Xmax_cap2107 _3855_/Y VGND VGND VPWR VPWR _3862_/A3 sky130_fd_sc_hd__clkbuf_2
XTAP_TAPCELL_ROW_51_761 VGND VPWR sky130_fd_sc_hd__tapvpwrvgnd_1
XTAP_TAPCELL_ROW_23_463 VGND VPWR sky130_fd_sc_hd__tapvpwrvgnd_1
XFILLER_40_298 VGND VGND VPWR VPWR sky130_fd_sc_hd__decap_3
Xclkbuf_leaf_20_clk clkload0/A VGND VGND VPWR VPWR _7287_/CLK sky130_fd_sc_hd__clkbuf_16
XFILLER_4_100 VGND VGND VPWR VPWR sky130_fd_sc_hd__decap_3
XFILLER_4_144 VGND VGND VPWR VPWR sky130_fd_sc_hd__decap_3
XFILLER_4_166 VGND VGND VPWR VPWR sky130_fd_sc_hd__decap_3
XFILLER_4_26 VGND VGND VPWR VPWR sky130_fd_sc_hd__fill_2
XFILLER_4_37 VGND VGND VPWR VPWR sky130_fd_sc_hd__fill_1
XFILLER_4_59 VGND VGND VPWR VPWR sky130_fd_sc_hd__fill_2
XTAP_TAPCELL_ROW_91_1178 VGND VPWR sky130_fd_sc_hd__tapvpwrvgnd_1
XFILLER_63_346 VGND VGND VPWR VPWR sky130_fd_sc_hd__decap_3
XFILLER_44_571 VGND VGND VPWR VPWR sky130_fd_sc_hd__decap_3
XFILLER_31_243 VGND VGND VPWR VPWR sky130_fd_sc_hd__decap_3
X_3870_ _7401_/Q _3914_/A2 _3869_/X VGND VGND VPWR VPWR _3870_/Y sky130_fd_sc_hd__a21oi_2
XFILLER_31_287 VGND VGND VPWR VPWR sky130_fd_sc_hd__decap_3
XFILLER_76_3 VGND VGND VPWR VPWR sky130_fd_sc_hd__decap_3
Xclkbuf_leaf_11_clk clkbuf_leaf_9_clk/A VGND VGND VPWR VPWR _7274_/CLK sky130_fd_sc_hd__clkbuf_16
XTAP_TAPCELL_ROW_100_1274 VGND VPWR sky130_fd_sc_hd__tapvpwrvgnd_1
X_5471_ _5471_/A0 _5532_/A1 _5471_/S VGND VGND VPWR VPWR _7172_/D sky130_fd_sc_hd__mux2_2
X_7210_ _7393_/CLK _7210_/D VGND VGND VPWR VPWR _7210_/Q sky130_fd_sc_hd__dfxtp_2
X_4422_ _4422_/A _4422_/B _4430_/C VGND VGND VPWR VPWR _4422_/X sky130_fd_sc_hd__and3_2
XFILLER_98_210 VGND VGND VPWR VPWR sky130_fd_sc_hd__decap_3
X_7141_ _7509_/CLK _7141_/D VGND VGND VPWR VPWR _7141_/Q sky130_fd_sc_hd__dfxtp_2
X_4353_ _4373_/C _4361_/B VGND VGND VPWR VPWR _4362_/B sky130_fd_sc_hd__nand2_2
X_7072_ _7490_/CLK _7072_/D VGND VGND VPWR VPWR _7072_/Q sky130_fd_sc_hd__dfxtp_2
X_4284_ _6180_/A1 _6183_/B _4300_/A3 _4284_/B1 VGND VGND VPWR VPWR _4285_/A sky130_fd_sc_hd__o31a_2
X_6023_ _7075_/Q _6449_/A2 _6449_/B1 _7103_/Q _6022_/X VGND VGND VPWR VPWR _6023_/X
+ sky130_fd_sc_hd__o221a_2
XFILLER_27_527 VGND VGND VPWR VPWR sky130_fd_sc_hd__fill_1
XFILLER_27_538 VGND VGND VPWR VPWR sky130_fd_sc_hd__fill_2
XFILLER_81_121 VGND VGND VPWR VPWR sky130_fd_sc_hd__fill_2
XFILLER_42_519 VGND VGND VPWR VPWR sky130_fd_sc_hd__decap_3
XFILLER_81_132 VGND VGND VPWR VPWR sky130_fd_sc_hd__fill_2
X_6925_ _7290_/CLK _6925_/D VGND VGND VPWR VPWR _6925_/Q sky130_fd_sc_hd__dfxtp_2
XFILLER_22_210 VGND VGND VPWR VPWR sky130_fd_sc_hd__decap_3
X_6856_ _7276_/CLK _6856_/D VGND VGND VPWR VPWR _6856_/Q sky130_fd_sc_hd__dfxtp_2
XFILLER_50_585 VGND VGND VPWR VPWR sky130_fd_sc_hd__decap_3
X_6787_ _6789_/A _6787_/B VGND VGND VPWR VPWR _7552_/D sky130_fd_sc_hd__and2_2
X_5807_ _5807_/A _5807_/B _5807_/C _5807_/D VGND VGND VPWR VPWR _5807_/X sky130_fd_sc_hd__or4_4
X_3999_ _4734_/A2 _3961_/X _3999_/B1 _3998_/Y VGND VGND VPWR VPWR _4001_/B sky130_fd_sc_hd__a2bb2o_2
X_5738_ _7322_/Q _4313_/B _4313_/C _5737_/Y _5732_/S VGND VGND VPWR VPWR _5738_/Y
+ sky130_fd_sc_hd__a311oi_2
XTAP_TAPCELL_ROW_20_433 VGND VPWR sky130_fd_sc_hd__tapvpwrvgnd_1
XFILLER_89_28 VGND VGND VPWR VPWR sky130_fd_sc_hd__decap_3
X_5669_ _5669_/A0 _5730_/A1 _5669_/S VGND VGND VPWR VPWR _7263_/D sky130_fd_sc_hd__mux2_2
X_7408_ _7507_/CLK _7408_/D place2048/X VGND VGND VPWR VPWR _7408_/Q sky130_fd_sc_hd__dfrtp_2
XFILLER_8_6 VGND VGND VPWR VPWR sky130_fd_sc_hd__decap_3
Xplace1160 _4174_/X VGND VGND VPWR VPWR _6073_/A1 sky130_fd_sc_hd__buf_2
X_7339_ _7579_/CLK _7339_/D place2014/X VGND VGND VPWR VPWR _7339_/Q sky130_fd_sc_hd__dfrtp_2
XFILLER_1_136 VGND VGND VPWR VPWR sky130_fd_sc_hd__decap_3
Xplace1171 _5211_/S VGND VGND VPWR VPWR _5213_/S sky130_fd_sc_hd__buf_2
Xplace1182 _5637_/S VGND VGND VPWR VPWR _5635_/S sky130_fd_sc_hd__buf_2
Xplace1193 _5095_/S VGND VGND VPWR VPWR _5152_/S sky130_fd_sc_hd__buf_2
Xrebuffer2150 _3587_/B1 VGND VGND VPWR VPWR _4395_/B1 sky130_fd_sc_hd__buf_2
Xrebuffer2161 _3442_/B VGND VGND VPWR VPWR _3448_/A2 sky130_fd_sc_hd__buf_2
Xrebuffer2172 _4607_/B VGND VGND VPWR VPWR _4017_/A sky130_fd_sc_hd__buf_2
Xrebuffer2183 _6138_/B2 VGND VGND VPWR VPWR _6165_/B2 sky130_fd_sc_hd__buf_2
XFILLER_1_169 VGND VGND VPWR VPWR sky130_fd_sc_hd__fill_1
Xrebuffer2194 _6160_/B VGND VGND VPWR VPWR _5923_/A2_N sky130_fd_sc_hd__buf_2
XFILLER_38_54 VGND VGND VPWR VPWR sky130_fd_sc_hd__decap_3
XFILLER_18_505 VGND VGND VPWR VPWR sky130_fd_sc_hd__decap_3
XFILLER_92_419 VGND VGND VPWR VPWR sky130_fd_sc_hd__fill_1
XFILLER_18_527 VGND VGND VPWR VPWR sky130_fd_sc_hd__decap_3
XFILLER_45_324 VGND VGND VPWR VPWR sky130_fd_sc_hd__decap_3
XFILLER_57_184 VGND VGND VPWR VPWR sky130_fd_sc_hd__decap_3
XTAP_TAPCELL_ROW_28_522 VGND VPWR sky130_fd_sc_hd__tapvpwrvgnd_1
XFILLER_33_508 VGND VGND VPWR VPWR sky130_fd_sc_hd__decap_3
XFILLER_45_357 VGND VGND VPWR VPWR sky130_fd_sc_hd__decap_3
XFILLER_54_53 VGND VGND VPWR VPWR sky130_fd_sc_hd__fill_1
XFILLER_72_187 VGND VGND VPWR VPWR sky130_fd_sc_hd__fill_2
XFILLER_13_210 VGND VGND VPWR VPWR sky130_fd_sc_hd__decap_3
XFILLER_13_243 VGND VGND VPWR VPWR sky130_fd_sc_hd__decap_3
XFILLER_41_541 VGND VGND VPWR VPWR sky130_fd_sc_hd__decap_3
XFILLER_41_585 VGND VGND VPWR VPWR sky130_fd_sc_hd__decap_3
XFILLER_9_214 VGND VGND VPWR VPWR sky130_fd_sc_hd__fill_1
XFILLER_70_85 VGND VGND VPWR VPWR sky130_fd_sc_hd__decap_3
Xclkload17 _7287_/CLK VGND VGND VPWR VPWR clkload17/X sky130_fd_sc_hd__clkbuf_8
Xclkload28 _7241_/CLK VGND VGND VPWR VPWR clkload28/Y sky130_fd_sc_hd__clkinv_2
XFILLER_0_191 VGND VGND VPWR VPWR sky130_fd_sc_hd__decap_3
Xclkbuf_leaf_0_clk clkbuf_leaf_0_clk/A VGND VGND VPWR VPWR clkload2/A sky130_fd_sc_hd__clkbuf_16
XFILLER_63_165 VGND VGND VPWR VPWR sky130_fd_sc_hd__decap_3
X_4971_ _5427_/A _5093_/C _5671_/C VGND VGND VPWR VPWR _5030_/S sky130_fd_sc_hd__and3_2
X_6710_ _5846_/X _6710_/A1 _6720_/S VGND VGND VPWR VPWR _7516_/D sky130_fd_sc_hd__mux2_2
X_3922_ _4767_/B2 _5839_/B1 _7364_/Q _3936_/B1 _7556_/Q VGND VGND VPWR VPWR _3922_/X
+ sky130_fd_sc_hd__a32o_2
XFILLER_32_552 VGND VGND VPWR VPWR sky130_fd_sc_hd__decap_3
X_6641_ _6228_/Y _6607_/S _6229_/X _6640_/X VGND VGND VPWR VPWR _7483_/D sky130_fd_sc_hd__a31o_2
X_3853_ _7370_/Q _3853_/B _3853_/C VGND VGND VPWR VPWR _3853_/X sky130_fd_sc_hd__and3_2
XTAP_TAPCELL_ROW_62_878 VGND VPWR sky130_fd_sc_hd__tapvpwrvgnd_1
X_6572_ _6228_/Y _6529_/S _6229_/X _6571_/X VGND VGND VPWR VPWR _7451_/D sky130_fd_sc_hd__a31o_2
X_3784_ _4225_/A1 _3784_/A2 _3784_/B1 _4562_/A1 VGND VGND VPWR VPWR _3785_/B sky130_fd_sc_hd__o211ai_2
X_5454_ _5454_/A0 _5698_/A1 _5454_/S VGND VGND VPWR VPWR _7164_/D sky130_fd_sc_hd__mux2_2
X_5385_ _5385_/A0 _5446_/A1 _5391_/S VGND VGND VPWR VPWR _7132_/D sky130_fd_sc_hd__mux2_2
X_4405_ _6231_/A1 _4448_/C _4337_/D _4437_/A3 VGND VGND VPWR VPWR _4405_/X sky130_fd_sc_hd__a31o_2
X_7124_ _7264_/CLK _7124_/D VGND VGND VPWR VPWR _7124_/Q sky130_fd_sc_hd__dfxtp_2
X_7055_ _7114_/CLK _7055_/D VGND VGND VPWR VPWR _7055_/Q sky130_fd_sc_hd__dfxtp_2
X_4267_ _4267_/A1 _4266_/X _4260_/B VGND VGND VPWR VPWR _4267_/Y sky130_fd_sc_hd__a21oi_2
XFILLER_27_302 VGND VGND VPWR VPWR sky130_fd_sc_hd__decap_3
XFILLER_55_611 VGND VGND VPWR VPWR sky130_fd_sc_hd__fill_1
X_6006_ _6397_/A1 _6899_/Q _7291_/Q _6397_/B2 VGND VGND VPWR VPWR _6006_/X sky130_fd_sc_hd__o22a_2
X_4198_ _4212_/A _4212_/B _4198_/B1 _4194_/Y VGND VGND VPWR VPWR _4202_/C sky130_fd_sc_hd__o22ai_2
XFILLER_27_335 VGND VGND VPWR VPWR sky130_fd_sc_hd__fill_1
XFILLER_67_482 VGND VGND VPWR VPWR sky130_fd_sc_hd__decap_3
XFILLER_15_508 VGND VGND VPWR VPWR sky130_fd_sc_hd__decap_3
XFILLER_27_357 VGND VGND VPWR VPWR sky130_fd_sc_hd__decap_3
XFILLER_24_23 VGND VGND VPWR VPWR sky130_fd_sc_hd__decap_3
X_6908_ _7272_/CLK _6908_/D VGND VGND VPWR VPWR _6908_/Q sky130_fd_sc_hd__dfxtp_2
XFILLER_50_371 VGND VGND VPWR VPWR sky130_fd_sc_hd__fill_2
XFILLER_10_268 VGND VGND VPWR VPWR sky130_fd_sc_hd__decap_3
XFILLER_6_206 VGND VGND VPWR VPWR sky130_fd_sc_hd__decap_3
XFILLER_10_279 VGND VGND VPWR VPWR sky130_fd_sc_hd__decap_3
XTAP_TAPCELL_ROW_79_1051 VGND VPWR sky130_fd_sc_hd__tapvpwrvgnd_1
XFILLER_40_88 VGND VGND VPWR VPWR sky130_fd_sc_hd__decap_3
XFILLER_6_3 VGND VGND VPWR VPWR sky130_fd_sc_hd__fill_2
XFILLER_49_53 VGND VGND VPWR VPWR sky130_fd_sc_hd__decap_3
XFILLER_49_97 VGND VGND VPWR VPWR sky130_fd_sc_hd__decap_3
XTAP_TAPCELL_ROW_5_272 VGND VPWR sky130_fd_sc_hd__tapvpwrvgnd_1
XFILLER_18_368 VGND VGND VPWR VPWR sky130_fd_sc_hd__fill_2
XFILLER_65_74 VGND VGND VPWR VPWR sky130_fd_sc_hd__fill_2
XFILLER_85_290 VGND VGND VPWR VPWR sky130_fd_sc_hd__fill_1
XFILLER_33_316 VGND VGND VPWR VPWR sky130_fd_sc_hd__fill_1
XFILLER_45_176 VGND VGND VPWR VPWR sky130_fd_sc_hd__decap_3
XFILLER_41_360 VGND VGND VPWR VPWR sky130_fd_sc_hd__decap_3
XFILLER_41_393 VGND VGND VPWR VPWR sky130_fd_sc_hd__fill_2
Xplace1918 _3413_/Y VGND VGND VPWR VPWR _4510_/B sky130_fd_sc_hd__buf_2
Xplace1907 _3516_/A2 VGND VGND VPWR VPWR _3628_/A3 sky130_fd_sc_hd__buf_2
XFILLER_5_272 VGND VGND VPWR VPWR sky130_fd_sc_hd__decap_3
Xplace1929 _3458_/A VGND VGND VPWR VPWR _3844_/A sky130_fd_sc_hd__buf_2
XFILLER_39_3 VGND VGND VPWR VPWR sky130_fd_sc_hd__decap_3
Xhold2609 _7257_/Q VGND VGND VPWR VPWR _5657_/A0 sky130_fd_sc_hd__dlygate4sd3_1
XFILLER_96_533 VGND VGND VPWR VPWR sky130_fd_sc_hd__decap_3
X_4121_ _4579_/C _4579_/D VGND VGND VPWR VPWR _4121_/Y sky130_fd_sc_hd__nand2_2
XFILLER_68_268 VGND VGND VPWR VPWR sky130_fd_sc_hd__decap_3
X_4052_ _4055_/C _4052_/B VGND VGND VPWR VPWR _7596_/D sky130_fd_sc_hd__nor2_2
XTAP_TAPCELL_ROW_67_926 VGND VPWR sky130_fd_sc_hd__tapvpwrvgnd_1
XTAP_TAPCELL_ROW_39_628 VGND VPWR sky130_fd_sc_hd__tapvpwrvgnd_1
XFILLER_36_187 VGND VGND VPWR VPWR sky130_fd_sc_hd__decap_3
XFILLER_51_102 VGND VGND VPWR VPWR sky130_fd_sc_hd__fill_1
X_4954_ _4954_/A0 _4745_/Y _4964_/S VGND VGND VPWR VPWR _6950_/D sky130_fd_sc_hd__mux2_2
XFILLER_32_360 VGND VGND VPWR VPWR sky130_fd_sc_hd__decap_3
X_3905_ _3946_/A _3946_/B _3905_/C _3904_/Y VGND VGND VPWR VPWR _3906_/A sky130_fd_sc_hd__nor4b_2
XFILLER_20_533 VGND VGND VPWR VPWR sky130_fd_sc_hd__decap_3
XFILLER_32_371 VGND VGND VPWR VPWR sky130_fd_sc_hd__decap_3
XFILLER_32_393 VGND VGND VPWR VPWR sky130_fd_sc_hd__fill_2
X_4885_ _4885_/A0 _5713_/A1 _4902_/S VGND VGND VPWR VPWR _6919_/D sky130_fd_sc_hd__mux2_2
XFILLER_20_566 VGND VGND VPWR VPWR sky130_fd_sc_hd__fill_2
X_6624_ _6624_/A0 _6548_/Y _6638_/S VGND VGND VPWR VPWR _7475_/D sky130_fd_sc_hd__mux2_2
X_3836_ _3836_/A1 _3903_/A2 _7499_/Q _3858_/B1 _7435_/Q VGND VGND VPWR VPWR _3836_/X
+ sky130_fd_sc_hd__a32o_2
XFILLER_20_577 VGND VGND VPWR VPWR sky130_fd_sc_hd__decap_3
X_6555_ _6555_/A0 _6217_/X _6567_/S VGND VGND VPWR VPWR _7446_/D sky130_fd_sc_hd__mux2_2
X_3767_ _7411_/Q _6706_/S _3766_/X VGND VGND VPWR VPWR _3767_/Y sky130_fd_sc_hd__a21oi_4
X_6486_ _6486_/A _6486_/B _6486_/C VGND VGND VPWR VPWR _6486_/X sky130_fd_sc_hd__or3_2
X_3698_ _7321_/Q _3698_/B VGND VGND VPWR VPWR _3699_/D sky130_fd_sc_hd__nand2_2
X_5437_ _5437_/A0 _5681_/A1 _5454_/S VGND VGND VPWR VPWR _7156_/D sky130_fd_sc_hd__mux2_2
X_5368_ _5368_/A0 _5612_/A1 _5425_/S VGND VGND VPWR VPWR _7124_/D sky130_fd_sc_hd__mux2_2
XFILLER_99_393 VGND VGND VPWR VPWR sky130_fd_sc_hd__fill_2
X_7107_ _7243_/CLK _7107_/D VGND VGND VPWR VPWR _7107_/Q sky130_fd_sc_hd__dfxtp_2
X_5299_ _5299_/A0 _5606_/A1 _5299_/S VGND VGND VPWR VPWR _7094_/D sky130_fd_sc_hd__mux2_2
X_4319_ _4319_/A1 _4396_/A _4315_/X VGND VGND VPWR VPWR _4324_/A sky130_fd_sc_hd__a21o_2
XFILLER_101_354 VGND VGND VPWR VPWR sky130_fd_sc_hd__decap_3
XFILLER_59_257 VGND VGND VPWR VPWR sky130_fd_sc_hd__fill_2
X_7038_ _7287_/CLK _7038_/D VGND VGND VPWR VPWR _7038_/Q sky130_fd_sc_hd__dfxtp_2
XFILLER_27_110 VGND VGND VPWR VPWR sky130_fd_sc_hd__fill_2
XFILLER_55_452 VGND VGND VPWR VPWR sky130_fd_sc_hd__decap_3
XTAP_TAPCELL_ROW_2_242 VGND VPWR sky130_fd_sc_hd__tapvpwrvgnd_1
XFILLER_27_187 VGND VGND VPWR VPWR sky130_fd_sc_hd__decap_3
XFILLER_82_293 VGND VGND VPWR VPWR sky130_fd_sc_hd__fill_1
XFILLER_35_77 VGND VGND VPWR VPWR sky130_fd_sc_hd__decap_3
XFILLER_70_477 VGND VGND VPWR VPWR sky130_fd_sc_hd__fill_2
XFILLER_23_360 VGND VGND VPWR VPWR sky130_fd_sc_hd__fill_1
XFILLER_23_393 VGND VGND VPWR VPWR sky130_fd_sc_hd__fill_1
XFILLER_50_190 VGND VGND VPWR VPWR sky130_fd_sc_hd__decap_3
XFILLER_7_515 VGND VGND VPWR VPWR sky130_fd_sc_hd__decap_3
XFILLER_2_253 VGND VGND VPWR VPWR sky130_fd_sc_hd__decap_3
XFILLER_38_419 VGND VGND VPWR VPWR sky130_fd_sc_hd__fill_1
XFILLER_78_577 VGND VGND VPWR VPWR sky130_fd_sc_hd__decap_3
XFILLER_93_514 VGND VGND VPWR VPWR sky130_fd_sc_hd__decap_3
XFILLER_19_611 VGND VGND VPWR VPWR sky130_fd_sc_hd__fill_1
XFILLER_18_121 VGND VGND VPWR VPWR sky130_fd_sc_hd__decap_3
XFILLER_46_430 VGND VGND VPWR VPWR sky130_fd_sc_hd__decap_3
XFILLER_46_485 VGND VGND VPWR VPWR sky130_fd_sc_hd__decap_3
XFILLER_33_113 VGND VGND VPWR VPWR sky130_fd_sc_hd__fill_1
XTAP_TAPCELL_ROW_72_984 VGND VPWR sky130_fd_sc_hd__tapvpwrvgnd_1
XTAP_TAPCELL_ROW_44_686 VGND VPWR sky130_fd_sc_hd__tapvpwrvgnd_1
XTAP_TAPCELL_ROW_16_388 VGND VPWR sky130_fd_sc_hd__tapvpwrvgnd_1
X_4670_ _3842_/A _6178_/A1 _6178_/A3 _4669_/X VGND VGND VPWR VPWR _4670_/X sky130_fd_sc_hd__a31o_2
X_3621_ _7509_/Q _3788_/B1 _3757_/B1 _7445_/Q VGND VGND VPWR VPWR _3631_/A sky130_fd_sc_hd__a22oi_2
X_6340_ _7413_/Q _6344_/A2 _6344_/A3 _6344_/B1 _6340_/B2 VGND VGND VPWR VPWR _6340_/X
+ sky130_fd_sc_hd__a32o_2
X_3552_ _3541_/X _4743_/A _4395_/A1 VGND VGND VPWR VPWR _3552_/Y sky130_fd_sc_hd__a21oi_2
Xplace1704 _3565_/Y VGND VGND VPWR VPWR _3567_/A sky130_fd_sc_hd__buf_2
Xplace1715 _3909_/A2 VGND VGND VPWR VPWR _3950_/A2 sky130_fd_sc_hd__buf_8
Xplace1726 _3568_/B VGND VGND VPWR VPWR _3957_/B sky130_fd_sc_hd__buf_2
XFILLER_103_608 VGND VGND VPWR VPWR sky130_fd_sc_hd__decap_3
XFILLER_6_592 VGND VGND VPWR VPWR sky130_fd_sc_hd__fill_1
Xplace1737 _3505_/Y VGND VGND VPWR VPWR _3860_/A2 sky130_fd_sc_hd__buf_4
Xplace1748 _3913_/A2 VGND VGND VPWR VPWR _3793_/A2 sky130_fd_sc_hd__buf_2
Xplace1759 _6662_/S VGND VGND VPWR VPWR _4725_/A2 sky130_fd_sc_hd__buf_2
X_6271_ _6298_/A _6271_/B VGND VGND VPWR VPWR _7342_/D sky130_fd_sc_hd__and2_2
X_3483_ _3482_/Y _3413_/Y _3491_/B VGND VGND VPWR VPWR _3483_/Y sky130_fd_sc_hd__o21bai_2
Xhold2428 _7079_/Q VGND VGND VPWR VPWR _5252_/A0 sky130_fd_sc_hd__dlygate4sd3_1
Xhold2417 _7279_/Q VGND VGND VPWR VPWR _5705_/A0 sky130_fd_sc_hd__dlygate4sd3_1
Xhold2406 _6846_/Q VGND VGND VPWR VPWR _4597_/A0 sky130_fd_sc_hd__dlygate4sd3_1
XFILLER_29_408 VGND VGND VPWR VPWR sky130_fd_sc_hd__decap_3
XFILLER_96_363 VGND VGND VPWR VPWR sky130_fd_sc_hd__fill_1
Xhold2439 _6935_/Q VGND VGND VPWR VPWR _4922_/A0 sky130_fd_sc_hd__dlygate4sd3_1
X_4104_ _6088_/A _3802_/C _4098_/Y _5862_/A3 VGND VGND VPWR VPWR _4105_/A sky130_fd_sc_hd__o211ai_2
X_4035_ _7299_/Q _4035_/B VGND VGND VPWR VPWR _7589_/D sky130_fd_sc_hd__xnor2_2
XFILLER_24_135 VGND VGND VPWR VPWR sky130_fd_sc_hd__decap_3
X_5986_ _5984_/X _5985_/X _6457_/B1 _6482_/A2 VGND VGND VPWR VPWR _6082_/C sky130_fd_sc_hd__a211o_2
X_4937_ _4937_/A0 _5336_/A1 _4958_/S VGND VGND VPWR VPWR _6942_/D sky130_fd_sc_hd__mux2_2
XANTENNA_20 _7064_/Q VGND VGND VPWR VPWR sky130_fd_sc_hd__diode_2
XANTENNA_31 _5271_/A0 VGND VGND VPWR VPWR sky130_fd_sc_hd__diode_2
XFILLER_20_330 VGND VGND VPWR VPWR sky130_fd_sc_hd__decap_3
X_4868_ _4868_/A0 _5635_/A1 _4868_/S VGND VGND VPWR VPWR _6911_/D sky130_fd_sc_hd__mux2_2
XANTENNA_42 _6153_/B1 VGND VGND VPWR VPWR sky130_fd_sc_hd__diode_2
XANTENNA_53 _7134_/Q VGND VGND VPWR VPWR sky130_fd_sc_hd__diode_2
X_6607_ _6607_/A0 _6086_/X _6607_/S VGND VGND VPWR VPWR _7467_/D sky130_fd_sc_hd__mux2_2
X_3819_ _3819_/A VGND VGND VPWR VPWR _3821_/A sky130_fd_sc_hd__inv_2
XFILLER_21_46 VGND VGND VPWR VPWR sky130_fd_sc_hd__decap_3
X_7587_ clkload6/A _7587_/D place2061/X VGND VGND VPWR VPWR _7587_/Q sky130_fd_sc_hd__dfrtp_2
XFILLER_21_57 VGND VGND VPWR VPWR sky130_fd_sc_hd__decap_3
XTAP_TAPCELL_ROW_76_1021 VGND VPWR sky130_fd_sc_hd__tapvpwrvgnd_1
X_6469_ _6467_/X _6468_/X _6509_/B1 _6512_/C1 VGND VGND VPWR VPWR _6469_/X sky130_fd_sc_hd__a211o_2
XTAP_TAPCELL_ROW_7_301 VGND VPWR sky130_fd_sc_hd__tapvpwrvgnd_1
XPHY_EDGE_ROW_102_Right_102 VGND VGND VPWR VPWR sky130_fd_sc_hd__decap_3
Xhold2940 _7455_/Q VGND VGND VPWR VPWR _6581_/A0 sky130_fd_sc_hd__dlygate4sd3_1
Xhold2951 _7404_/Q VGND VGND VPWR VPWR _6328_/A1 sky130_fd_sc_hd__dlygate4sd3_1
Xhold2962 _6361_/X VGND VGND VPWR VPWR _7394_/D sky130_fd_sc_hd__dlygate4sd3_1
Xhold2973 _6382_/X VGND VGND VPWR VPWR _7408_/D sky130_fd_sc_hd__dlygate4sd3_1
Xhold2984 _7430_/Q VGND VGND VPWR VPWR _6518_/A0 sky130_fd_sc_hd__dlygate4sd3_1
XFILLER_28_430 VGND VGND VPWR VPWR sky130_fd_sc_hd__decap_3
XFILLER_47_238 VGND VGND VPWR VPWR sky130_fd_sc_hd__fill_1
XFILLER_75_569 VGND VGND VPWR VPWR sky130_fd_sc_hd__decap_3
Xhold2995 _7457_/Q VGND VGND VPWR VPWR _6585_/A0 sky130_fd_sc_hd__dlygate4sd3_1
XFILLER_28_463 VGND VGND VPWR VPWR sky130_fd_sc_hd__decap_3
XFILLER_62_219 VGND VGND VPWR VPWR sky130_fd_sc_hd__decap_3
XFILLER_15_113 VGND VGND VPWR VPWR sky130_fd_sc_hd__decap_3
XFILLER_43_444 VGND VGND VPWR VPWR sky130_fd_sc_hd__decap_3
XFILLER_102_82 VGND VGND VPWR VPWR sky130_fd_sc_hd__fill_2
XFILLER_15_146 VGND VGND VPWR VPWR sky130_fd_sc_hd__fill_2
XFILLER_43_477 VGND VGND VPWR VPWR sky130_fd_sc_hd__decap_3
XFILLER_30_105 VGND VGND VPWR VPWR sky130_fd_sc_hd__decap_3
XFILLER_70_285 VGND VGND VPWR VPWR sky130_fd_sc_hd__decap_3
XFILLER_23_190 VGND VGND VPWR VPWR sky130_fd_sc_hd__decap_3
XTAP_TAPCELL_ROW_41_656 VGND VPWR sky130_fd_sc_hd__tapvpwrvgnd_1
XTAP_TAPCELL_ROW_13_358 VGND VPWR sky130_fd_sc_hd__tapvpwrvgnd_1
XFILLER_7_48 VGND VGND VPWR VPWR sky130_fd_sc_hd__decap_3
XFILLER_98_606 VGND VGND VPWR VPWR sky130_fd_sc_hd__decap_3
XFILLER_3_551 VGND VGND VPWR VPWR sky130_fd_sc_hd__fill_1
XFILLER_23_6 VGND VGND VPWR VPWR sky130_fd_sc_hd__decap_3
XFILLER_78_330 VGND VGND VPWR VPWR sky130_fd_sc_hd__decap_3
XFILLER_78_341 VGND VGND VPWR VPWR sky130_fd_sc_hd__decap_3
XFILLER_19_441 VGND VGND VPWR VPWR sky130_fd_sc_hd__decap_3
XTAP_TAPCELL_ROW_49_734 VGND VPWR sky130_fd_sc_hd__tapvpwrvgnd_1
XFILLER_19_474 VGND VGND VPWR VPWR sky130_fd_sc_hd__decap_3
XFILLER_34_400 VGND VGND VPWR VPWR sky130_fd_sc_hd__decap_3
XFILLER_53_208 VGND VGND VPWR VPWR sky130_fd_sc_hd__fill_2
XFILLER_81_517 VGND VGND VPWR VPWR sky130_fd_sc_hd__fill_1
XFILLER_46_293 VGND VGND VPWR VPWR sky130_fd_sc_hd__decap_3
XFILLER_22_606 VGND VGND VPWR VPWR sky130_fd_sc_hd__decap_3
X_5840_ _5829_/Y _5832_/Y _5835_/Y _5838_/Y _6486_/C VGND VGND VPWR VPWR _5840_/X
+ sky130_fd_sc_hd__a41o_2
XFILLER_21_116 VGND VGND VPWR VPWR sky130_fd_sc_hd__decap_3
XFILLER_61_285 VGND VGND VPWR VPWR sky130_fd_sc_hd__decap_3
X_5771_ _5862_/A3 _4584_/X _5764_/A VGND VGND VPWR VPWR _5771_/Y sky130_fd_sc_hd__a21oi_2
XFILLER_14_190 VGND VGND VPWR VPWR sky130_fd_sc_hd__decap_3
X_7510_ _7542_/CLK _7510_/D place2048/X VGND VGND VPWR VPWR _7510_/Q sky130_fd_sc_hd__dfrtp_2
X_7441_ clkload3/A _7441_/D place2057/X VGND VGND VPWR VPWR _7441_/Q sky130_fd_sc_hd__dfrtp_2
Xplace1501 _3859_/Y VGND VGND VPWR VPWR _4461_/A sky130_fd_sc_hd__buf_6
X_7372_ _7514_/CLK _7372_/D place2040/X VGND VGND VPWR VPWR _7372_/Q sky130_fd_sc_hd__dfrtp_2
X_4584_ _3969_/D _4398_/A _4398_/C _4398_/B _4584_/B1 VGND VGND VPWR VPWR _4584_/X
+ sky130_fd_sc_hd__a41o_2
Xplace1512 _3782_/Y VGND VGND VPWR VPWR _3784_/A2 sky130_fd_sc_hd__buf_2
Xplace1523 _3712_/B VGND VGND VPWR VPWR _4283_/D sky130_fd_sc_hd__buf_2
Xplace1534 _5843_/X VGND VGND VPWR VPWR _6440_/B1 sky130_fd_sc_hd__buf_2
X_6323_ _6372_/B2 _6324_/A2 _6346_/A3 _6324_/B1 _6323_/B2 VGND VGND VPWR VPWR _7370_/D
+ sky130_fd_sc_hd__a32o_2
X_3535_ _3628_/A1 _3628_/A3 _3826_/A _3826_/C VGND VGND VPWR VPWR _3535_/Y sky130_fd_sc_hd__a211oi_4
Xplace1545 _5310_/A1 VGND VGND VPWR VPWR _5677_/A1 sky130_fd_sc_hd__buf_2
Xplace1556 _3955_/Y VGND VGND VPWR VPWR _3959_/A1 sky130_fd_sc_hd__buf_2
Xplace1567 _3823_/X VGND VGND VPWR VPWR _4683_/B1 sky130_fd_sc_hd__buf_2
Xplace1578 _3538_/Y VGND VGND VPWR VPWR _3587_/B1 sky130_fd_sc_hd__buf_6
X_6254_ _6254_/A _6254_/B VGND VGND VPWR VPWR _7334_/D sky130_fd_sc_hd__and2_2
X_3466_ _3541_/A _3975_/C _3975_/B _3975_/A VGND VGND VPWR VPWR _3466_/Y sky130_fd_sc_hd__nand4_4
XFILLER_88_138 VGND VGND VPWR VPWR sky130_fd_sc_hd__fill_2
Xplace1589 _3504_/A VGND VGND VPWR VPWR _4737_/B1 sky130_fd_sc_hd__buf_2
X_5205_ _5205_/A0 _5600_/A1 _5211_/S VGND VGND VPWR VPWR _7063_/D sky130_fd_sc_hd__mux2_2
X_6185_ _6559_/A1 _3761_/C _6185_/B1 _7604_/Q _6184_/X VGND VGND VPWR VPWR _6185_/X
+ sky130_fd_sc_hd__o221a_4
XFILLER_29_205 VGND VGND VPWR VPWR sky130_fd_sc_hd__decap_3
XFILLER_57_514 VGND VGND VPWR VPWR sky130_fd_sc_hd__fill_2
XFILLER_96_182 VGND VGND VPWR VPWR sky130_fd_sc_hd__fill_1
XFILLER_84_377 VGND VGND VPWR VPWR sky130_fd_sc_hd__fill_1
X_4018_ _4305_/B _4018_/B _4305_/A _4018_/D VGND VGND VPWR VPWR _4018_/Y sky130_fd_sc_hd__nand4_4
XFILLER_25_466 VGND VGND VPWR VPWR sky130_fd_sc_hd__decap_3
XFILLER_52_241 VGND VGND VPWR VPWR sky130_fd_sc_hd__decap_3
XFILLER_52_285 VGND VGND VPWR VPWR sky130_fd_sc_hd__fill_2
X_5969_ _6213_/A1 _7088_/Q _7060_/Q _6171_/B1 VGND VGND VPWR VPWR _5969_/Y sky130_fd_sc_hd__o22ai_2
XFILLER_12_138 VGND VGND VPWR VPWR sky130_fd_sc_hd__fill_2
XFILLER_8_109 VGND VGND VPWR VPWR sky130_fd_sc_hd__decap_3
XTAP_TAPCELL_ROW_82_1080 VGND VPWR sky130_fd_sc_hd__tapvpwrvgnd_1
XFILLER_20_160 VGND VGND VPWR VPWR sky130_fd_sc_hd__decap_3
XTAP_TAPCELL_ROW_10_328 VGND VPWR sky130_fd_sc_hd__tapvpwrvgnd_1
XFILLER_4_304 VGND VGND VPWR VPWR sky130_fd_sc_hd__decap_3
XFILLER_0_521 VGND VGND VPWR VPWR sky130_fd_sc_hd__decap_3
XFILLER_0_576 VGND VGND VPWR VPWR sky130_fd_sc_hd__decap_3
Xhold2770 _6978_/Q VGND VGND VPWR VPWR _5020_/A0 sky130_fd_sc_hd__dlygate4sd3_1
Xhold2781 _6900_/Q VGND VGND VPWR VPWR _4845_/A0 sky130_fd_sc_hd__dlygate4sd3_1
Xhold2792 _7166_/Q VGND VGND VPWR VPWR _5459_/A0 sky130_fd_sc_hd__dlygate4sd3_1
XFILLER_35_219 VGND VGND VPWR VPWR sky130_fd_sc_hd__decap_3
XFILLER_63_528 VGND VGND VPWR VPWR sky130_fd_sc_hd__fill_1
XTAP_TAPCELL_ROW_46_704 VGND VPWR sky130_fd_sc_hd__tapvpwrvgnd_1
XFILLER_28_271 VGND VGND VPWR VPWR sky130_fd_sc_hd__decap_3
XTAP_TAPCELL_ROW_18_417 VGND VPWR sky130_fd_sc_hd__tapvpwrvgnd_1
XFILLER_43_252 VGND VGND VPWR VPWR sky130_fd_sc_hd__decap_3
XFILLER_73_74 VGND VGND VPWR VPWR sky130_fd_sc_hd__fill_2
XFILLER_16_477 VGND VGND VPWR VPWR sky130_fd_sc_hd__decap_3
XFILLER_31_403 VGND VGND VPWR VPWR sky130_fd_sc_hd__decap_3
XFILLER_43_285 VGND VGND VPWR VPWR sky130_fd_sc_hd__fill_2
XFILLER_73_85 VGND VGND VPWR VPWR sky130_fd_sc_hd__fill_1
XFILLER_31_447 VGND VGND VPWR VPWR sky130_fd_sc_hd__fill_1
XFILLER_43_296 VGND VGND VPWR VPWR sky130_fd_sc_hd__decap_3
XTAP_TAPCELL_ROW_54_792 VGND VPWR sky130_fd_sc_hd__tapvpwrvgnd_1
XTAP_TAPCELL_ROW_26_494 VGND VPWR sky130_fd_sc_hd__tapvpwrvgnd_1
XFILLER_11_160 VGND VGND VPWR VPWR sky130_fd_sc_hd__decap_3
XFILLER_7_131 VGND VGND VPWR VPWR sky130_fd_sc_hd__decap_3
XFILLER_7_175 VGND VGND VPWR VPWR sky130_fd_sc_hd__decap_3
XTAP_TAPCELL_ROW_96_1227 VGND VPWR sky130_fd_sc_hd__tapvpwrvgnd_1
XFILLER_21_3 VGND VGND VPWR VPWR sky130_fd_sc_hd__fill_1
XFILLER_26_219 VGND VGND VPWR VPWR sky130_fd_sc_hd__decap_3
XFILLER_19_293 VGND VGND VPWR VPWR sky130_fd_sc_hd__decap_3
XFILLER_66_399 VGND VGND VPWR VPWR sky130_fd_sc_hd__decap_3
X_6941_ _7280_/CLK _6941_/D VGND VGND VPWR VPWR _6941_/Q sky130_fd_sc_hd__dfxtp_2
X_6872_ _7264_/CLK _6872_/D VGND VGND VPWR VPWR _6872_/Q sky130_fd_sc_hd__dfxtp_2
XFILLER_34_285 VGND VGND VPWR VPWR sky130_fd_sc_hd__decap_3
X_5823_ _6231_/A1 _6302_/B _4337_/D _5850_/B _5850_/C VGND VGND VPWR VPWR _6347_/D
+ sky130_fd_sc_hd__a311o_2
XFILLER_22_436 VGND VGND VPWR VPWR sky130_fd_sc_hd__decap_3
XFILLER_22_458 VGND VGND VPWR VPWR sky130_fd_sc_hd__decap_3
X_5754_ _6456_/B2 _7285_/Q _7257_/Q _6448_/B2 VGND VGND VPWR VPWR _5754_/X sky130_fd_sc_hd__o22a_2
XFILLER_30_480 VGND VGND VPWR VPWR sky130_fd_sc_hd__decap_3
X_4705_ _4705_/A1 _4726_/A2 _4726_/B1 VGND VGND VPWR VPWR _4705_/Y sky130_fd_sc_hd__o21ai_2
Xplace2021 place2022/X VGND VGND VPWR VPWR place2021/X sky130_fd_sc_hd__buf_2
Xplace2010 _3437_/D VGND VGND VPWR VPWR _4352_/B sky130_fd_sc_hd__buf_2
X_7424_ clkload7/A _7424_/D place2021/X VGND VGND VPWR VPWR _7424_/Q sky130_fd_sc_hd__dfrtp_2
Xplace2054 place2055/X VGND VGND VPWR VPWR place2054/X sky130_fd_sc_hd__buf_2
Xplace2043 place2044/X VGND VGND VPWR VPWR place2043/X sky130_fd_sc_hd__buf_2
Xplace2032 place2033/X VGND VGND VPWR VPWR place2032/X sky130_fd_sc_hd__buf_2
X_7355_ _7579_/CLK _7355_/D place2016/X VGND VGND VPWR VPWR _7355_/Q sky130_fd_sc_hd__dfrtp_2
Xplace1320 _6456_/A1 VGND VGND VPWR VPWR _6449_/A2 sky130_fd_sc_hd__buf_2
Xplace1331 _6171_/B1 VGND VGND VPWR VPWR _6165_/A1 sky130_fd_sc_hd__buf_6
Xplace1342 _6483_/A1 VGND VGND VPWR VPWR _6480_/B2 sky130_fd_sc_hd__buf_2
Xplace1353 _4154_/A VGND VGND VPWR VPWR _4149_/B sky130_fd_sc_hd__buf_2
Xplace2065 place2066/X VGND VGND VPWR VPWR place2065/X sky130_fd_sc_hd__buf_2
X_6306_ _7388_/Q _6313_/A2 _6313_/A3 _6313_/B1 _3530_/A VGND VGND VPWR VPWR _7356_/D
+ sky130_fd_sc_hd__a32o_2
X_4567_ _4562_/X _4567_/B _4567_/C _4567_/D VGND VGND VPWR VPWR _4568_/A sky130_fd_sc_hd__and4b_2
XFILLER_89_447 VGND VGND VPWR VPWR sky130_fd_sc_hd__fill_1
Xplace1364 _4111_/X VGND VGND VPWR VPWR _4586_/A2 sky130_fd_sc_hd__buf_2
Xplace1375 _4209_/A VGND VGND VPWR VPWR _3834_/C sky130_fd_sc_hd__buf_2
Xplace1386 _6345_/B1 VGND VGND VPWR VPWR _6344_/B1 sky130_fd_sc_hd__buf_2
Xrebuffer2365 _4726_/B1 VGND VGND VPWR VPWR _4719_/B1 sky130_fd_sc_hd__buf_2
X_7286_ _7288_/CLK _7286_/D VGND VGND VPWR VPWR _7286_/Q sky130_fd_sc_hd__dfxtp_2
X_4498_ _4498_/A _4498_/B _4498_/C VGND VGND VPWR VPWR _4498_/X sky130_fd_sc_hd__and3_2
X_3518_ _3446_/A _3446_/B _6302_/A VGND VGND VPWR VPWR _3519_/D sky130_fd_sc_hd__a21oi_4
Xplace1397 _4579_/D VGND VGND VPWR VPWR _4582_/A sky130_fd_sc_hd__buf_2
X_6237_ _6247_/A _6237_/B VGND VGND VPWR VPWR _7326_/D sky130_fd_sc_hd__and2_2
X_6168_ _7199_/Q _6213_/A1 _7227_/Q _6168_/B2 VGND VGND VPWR VPWR _6168_/X sky130_fd_sc_hd__o22a_2
XFILLER_57_333 VGND VGND VPWR VPWR sky130_fd_sc_hd__decap_3
XFILLER_94_29 VGND VGND VPWR VPWR sky130_fd_sc_hd__decap_3
XFILLER_84_141 VGND VGND VPWR VPWR sky130_fd_sc_hd__fill_2
X_6099_ _7082_/Q _6139_/A1 _6138_/A1 _7110_/Q _6098_/X VGND VGND VPWR VPWR _6099_/X
+ sky130_fd_sc_hd__o221a_2
XFILLER_27_67 VGND VGND VPWR VPWR sky130_fd_sc_hd__decap_3
XFILLER_25_274 VGND VGND VPWR VPWR sky130_fd_sc_hd__decap_3
XFILLER_40_244 VGND VGND VPWR VPWR sky130_fd_sc_hd__decap_3
XFILLER_40_277 VGND VGND VPWR VPWR sky130_fd_sc_hd__decap_3
XFILLER_9_418 VGND VGND VPWR VPWR sky130_fd_sc_hd__fill_2
Xmax_cap2108 _3478_/Y VGND VGND VPWR VPWR _3863_/A2 sky130_fd_sc_hd__buf_4
XTAP_TAPCELL_ROW_51_762 VGND VPWR sky130_fd_sc_hd__tapvpwrvgnd_1
XTAP_TAPCELL_ROW_23_464 VGND VPWR sky130_fd_sc_hd__tapvpwrvgnd_1
XFILLER_21_480 VGND VGND VPWR VPWR sky130_fd_sc_hd__decap_3
XFILLER_21_491 VGND VGND VPWR VPWR sky130_fd_sc_hd__decap_3
XFILLER_4_112 VGND VGND VPWR VPWR sky130_fd_sc_hd__decap_3
XFILLER_4_16 VGND VGND VPWR VPWR sky130_fd_sc_hd__fill_1
XTAP_TAPCELL_ROW_91_1179 VGND VPWR sky130_fd_sc_hd__tapvpwrvgnd_1
XFILLER_0_340 VGND VGND VPWR VPWR sky130_fd_sc_hd__decap_3
XFILLER_0_362 VGND VGND VPWR VPWR sky130_fd_sc_hd__fill_2
XFILLER_68_85 VGND VGND VPWR VPWR sky130_fd_sc_hd__fill_1
XFILLER_95_428 VGND VGND VPWR VPWR sky130_fd_sc_hd__decap_3
XFILLER_48_333 VGND VGND VPWR VPWR sky130_fd_sc_hd__decap_3
XTAP_TAPCELL_ROW_59_840 VGND VPWR sky130_fd_sc_hd__tapvpwrvgnd_1
XFILLER_36_517 VGND VGND VPWR VPWR sky130_fd_sc_hd__decap_3
XFILLER_48_355 VGND VGND VPWR VPWR sky130_fd_sc_hd__fill_1
XFILLER_63_325 VGND VGND VPWR VPWR sky130_fd_sc_hd__fill_1
XFILLER_51_509 VGND VGND VPWR VPWR sky130_fd_sc_hd__decap_3
XFILLER_63_358 VGND VGND VPWR VPWR sky130_fd_sc_hd__decap_3
XFILLER_31_277 VGND VGND VPWR VPWR sky130_fd_sc_hd__decap_3
XTAP_TAPCELL_ROW_100_1275 VGND VPWR sky130_fd_sc_hd__tapvpwrvgnd_1
XFILLER_8_462 VGND VGND VPWR VPWR sky130_fd_sc_hd__fill_1
XFILLER_69_3 VGND VGND VPWR VPWR sky130_fd_sc_hd__decap_3
X_4421_ _4422_/A _4422_/B _4430_/C VGND VGND VPWR VPWR _4421_/Y sky130_fd_sc_hd__a21oi_2
X_7140_ _7282_/CLK _7140_/D VGND VGND VPWR VPWR _7140_/Q sky130_fd_sc_hd__dfxtp_2
X_4352_ _4352_/A _4352_/B _4352_/C VGND VGND VPWR VPWR _4361_/B sky130_fd_sc_hd__and3_2
X_7071_ _7272_/CLK _7071_/D VGND VGND VPWR VPWR _7071_/Q sky130_fd_sc_hd__dfxtp_2
X_4283_ _4283_/A _4297_/A _4283_/C _4283_/D VGND VGND VPWR VPWR _4283_/X sky130_fd_sc_hd__or4_2
XFILLER_86_417 VGND VGND VPWR VPWR sky130_fd_sc_hd__decap_3
X_6022_ _6448_/A1 _7047_/Q _6851_/Q _6450_/B2 VGND VGND VPWR VPWR _6022_/X sky130_fd_sc_hd__o22a_2
XFILLER_100_238 VGND VGND VPWR VPWR sky130_fd_sc_hd__decap_3
XFILLER_39_355 VGND VGND VPWR VPWR sky130_fd_sc_hd__fill_1
XFILLER_39_377 VGND VGND VPWR VPWR sky130_fd_sc_hd__decap_3
XFILLER_66_141 VGND VGND VPWR VPWR sky130_fd_sc_hd__decap_3
XFILLER_54_325 VGND VGND VPWR VPWR sky130_fd_sc_hd__decap_3
XFILLER_66_174 VGND VGND VPWR VPWR sky130_fd_sc_hd__fill_1
XFILLER_66_185 VGND VGND VPWR VPWR sky130_fd_sc_hd__fill_1
X_6924_ _7291_/CLK _6924_/D VGND VGND VPWR VPWR _6924_/Q sky130_fd_sc_hd__dfxtp_2
XFILLER_35_561 VGND VGND VPWR VPWR sky130_fd_sc_hd__fill_1
XFILLER_35_583 VGND VGND VPWR VPWR sky130_fd_sc_hd__decap_3
XFILLER_81_177 VGND VGND VPWR VPWR sky130_fd_sc_hd__fill_2
XFILLER_22_222 VGND VGND VPWR VPWR sky130_fd_sc_hd__decap_3
XFILLER_50_542 VGND VGND VPWR VPWR sky130_fd_sc_hd__decap_3
X_6855_ _7274_/CLK _6855_/D VGND VGND VPWR VPWR _6855_/Q sky130_fd_sc_hd__dfxtp_2
XFILLER_10_417 VGND VGND VPWR VPWR sky130_fd_sc_hd__decap_3
X_5806_ _5804_/X _5805_/X _5778_/X VGND VGND VPWR VPWR _5807_/D sky130_fd_sc_hd__a21oi_2
X_3998_ _3995_/X _3998_/B _3998_/C VGND VGND VPWR VPWR _3998_/Y sky130_fd_sc_hd__nand3b_2
X_5737_ _7322_/Q _4313_/B _4313_/C VGND VGND VPWR VPWR _5737_/Y sky130_fd_sc_hd__a21oi_2
XTAP_TAPCELL_ROW_20_434 VGND VPWR sky130_fd_sc_hd__tapvpwrvgnd_1
X_7407_ _7407_/CLK _7407_/D place2069/A VGND VGND VPWR VPWR _7407_/Q sky130_fd_sc_hd__dfrtp_2
XFILLER_89_222 VGND VGND VPWR VPWR sky130_fd_sc_hd__fill_2
Xplace1150 _4183_/Y VGND VGND VPWR VPWR _6079_/A1 sky130_fd_sc_hd__buf_4
Xplace1161 _5730_/S VGND VGND VPWR VPWR _5711_/S sky130_fd_sc_hd__buf_2
Xrebuffer2140 _3466_/Y VGND VGND VPWR VPWR _3981_/A sky130_fd_sc_hd__buf_4
X_7338_ _7579_/CLK _7338_/D place2014/X VGND VGND VPWR VPWR _7338_/Q sky130_fd_sc_hd__dfrtp_2
Xplace1172 _5028_/S VGND VGND VPWR VPWR _5024_/S sky130_fd_sc_hd__buf_2
Xplace1183 _5329_/S VGND VGND VPWR VPWR _5331_/S sky130_fd_sc_hd__buf_2
Xplace1194 _5095_/S VGND VGND VPWR VPWR _5146_/S sky130_fd_sc_hd__buf_2
Xrebuffer2151 _3533_/Y VGND VGND VPWR VPWR _3628_/C1 sky130_fd_sc_hd__buf_6
Xrebuffer2162 _3442_/B VGND VGND VPWR VPWR _3421_/B sky130_fd_sc_hd__buf_2
Xrebuffer2173 place1295/X VGND VGND VPWR VPWR _5959_/B2 sky130_fd_sc_hd__buf_2
X_7269_ _7273_/CLK _7269_/D VGND VGND VPWR VPWR _7269_/Q sky130_fd_sc_hd__dfxtp_2
Xrebuffer2184 _6138_/B2 VGND VGND VPWR VPWR _5905_/B2 sky130_fd_sc_hd__buf_2
Xrebuffer2195 _3409_/A VGND VGND VPWR VPWR _3497_/B1 sky130_fd_sc_hd__buf_2
XFILLER_45_303 VGND VGND VPWR VPWR sky130_fd_sc_hd__decap_3
XFILLER_57_141 VGND VGND VPWR VPWR sky130_fd_sc_hd__decap_3
XFILLER_57_152 VGND VGND VPWR VPWR sky130_fd_sc_hd__fill_1
XFILLER_18_539 VGND VGND VPWR VPWR sky130_fd_sc_hd__decap_3
XTAP_TAPCELL_ROW_56_810 VGND VPWR sky130_fd_sc_hd__tapvpwrvgnd_1
XTAP_TAPCELL_ROW_28_512 VGND VPWR sky130_fd_sc_hd__tapvpwrvgnd_1
XFILLER_54_32 VGND VGND VPWR VPWR sky130_fd_sc_hd__decap_3
XFILLER_13_222 VGND VGND VPWR VPWR sky130_fd_sc_hd__fill_2
XFILLER_41_564 VGND VGND VPWR VPWR sky130_fd_sc_hd__decap_3
XFILLER_41_597 VGND VGND VPWR VPWR sky130_fd_sc_hd__fill_2
Xclkload29 _7276_/CLK VGND VGND VPWR VPWR clkload29/Y sky130_fd_sc_hd__clkinv_2
Xclkload18 _7577_/CLK VGND VGND VPWR VPWR clkload18/X sky130_fd_sc_hd__clkbuf_4
XFILLER_95_225 VGND VGND VPWR VPWR sky130_fd_sc_hd__fill_1
XFILLER_48_141 VGND VGND VPWR VPWR sky130_fd_sc_hd__decap_3
XFILLER_36_303 VGND VGND VPWR VPWR sky130_fd_sc_hd__decap_3
XFILLER_17_561 VGND VGND VPWR VPWR sky130_fd_sc_hd__decap_3
XFILLER_63_177 VGND VGND VPWR VPWR sky130_fd_sc_hd__fill_2
Xplace122 _4208_/Y VGND VGND VPWR VPWR place122/X sky130_fd_sc_hd__buf_4
X_4970_ _4970_/A _4970_/B _4970_/C _4970_/D VGND VGND VPWR VPWR _5671_/C sky130_fd_sc_hd__and4_2
XFILLER_63_199 VGND VGND VPWR VPWR sky130_fd_sc_hd__decap_3
X_3921_ _3900_/Y _3832_/A _3920_/Y _3904_/Y VGND VGND VPWR VPWR _4148_/B sky130_fd_sc_hd__a2bb2o_2
X_6640_ _6607_/S _7483_/Q VGND VGND VPWR VPWR _6640_/X sky130_fd_sc_hd__and2b_2
XTAP_TAPCELL_ROW_62_879 VGND VPWR sky130_fd_sc_hd__tapvpwrvgnd_1
X_6571_ _6529_/S _7451_/Q VGND VGND VPWR VPWR _6571_/X sky130_fd_sc_hd__and2b_2
X_5522_ _5522_/A0 _4693_/X _5532_/S VGND VGND VPWR VPWR _7195_/D sky130_fd_sc_hd__mux2_2
X_3783_ _3778_/Y _3779_/Y _3782_/Y _4225_/A1 VGND VGND VPWR VPWR _3785_/A sky130_fd_sc_hd__a211o_2
XFILLER_8_270 VGND VGND VPWR VPWR sky130_fd_sc_hd__fill_1
X_4404_ _4448_/A _4437_/A2 _4437_/A3 _4404_/B1 VGND VGND VPWR VPWR _4408_/C sky130_fd_sc_hd__a31o_2
XFILLER_5_81 VGND VGND VPWR VPWR sky130_fd_sc_hd__fill_1
XFILLER_99_542 VGND VGND VPWR VPWR sky130_fd_sc_hd__fill_1
X_7123_ _7575_/CLK _7123_/D VGND VGND VPWR VPWR _7123_/Q sky130_fd_sc_hd__dfxtp_2
X_7054_ _7114_/CLK _7054_/D VGND VGND VPWR VPWR _7054_/Q sky130_fd_sc_hd__dfxtp_2
X_4266_ _4253_/A _4252_/Y _4745_/A2 _4253_/X VGND VGND VPWR VPWR _4266_/X sky130_fd_sc_hd__o31a_4
X_6005_ _6005_/A _6005_/B VGND VGND VPWR VPWR _6005_/Y sky130_fd_sc_hd__nand2_2
X_4197_ _4197_/A _4197_/B VGND VGND VPWR VPWR _4209_/B sky130_fd_sc_hd__or2_4
XFILLER_27_314 VGND VGND VPWR VPWR sky130_fd_sc_hd__decap_3
XFILLER_54_177 VGND VGND VPWR VPWR sky130_fd_sc_hd__decap_3
XFILLER_23_542 VGND VGND VPWR VPWR sky130_fd_sc_hd__fill_1
XFILLER_35_391 VGND VGND VPWR VPWR sky130_fd_sc_hd__fill_1
XPHY_EDGE_ROW_59_Left_163 VGND VGND VPWR VPWR sky130_fd_sc_hd__decap_3
X_6907_ _7243_/CLK _6907_/D VGND VGND VPWR VPWR _6907_/Q sky130_fd_sc_hd__dfxtp_2
XFILLER_23_564 VGND VGND VPWR VPWR sky130_fd_sc_hd__decap_3
XFILLER_24_46 VGND VGND VPWR VPWR sky130_fd_sc_hd__fill_1
XFILLER_24_57 VGND VGND VPWR VPWR sky130_fd_sc_hd__decap_3
X_6838_ _6838_/A _6838_/B VGND VGND VPWR VPWR _7577_/D sky130_fd_sc_hd__and2_2
XFILLER_10_214 VGND VGND VPWR VPWR sky130_fd_sc_hd__decap_3
XFILLER_10_225 VGND VGND VPWR VPWR sky130_fd_sc_hd__fill_1
XTAP_TAPCELL_ROW_33_570 VGND VPWR sky130_fd_sc_hd__tapvpwrvgnd_1
XFILLER_10_236 VGND VGND VPWR VPWR sky130_fd_sc_hd__fill_2
X_6769_ _6219_/X _6769_/A1 _6769_/S VGND VGND VPWR VPWR _7544_/D sky130_fd_sc_hd__mux2_2
XTAP_TAPCELL_ROW_79_1052 VGND VPWR sky130_fd_sc_hd__tapvpwrvgnd_1
XFILLER_49_10 VGND VGND VPWR VPWR sky130_fd_sc_hd__fill_1
XPHY_EDGE_ROW_68_Left_172 VGND VGND VPWR VPWR sky130_fd_sc_hd__decap_3
XFILLER_46_601 VGND VGND VPWR VPWR sky130_fd_sc_hd__fill_2
XTAP_TAPCELL_ROW_5_273 VGND VPWR sky130_fd_sc_hd__tapvpwrvgnd_1
XFILLER_45_100 VGND VGND VPWR VPWR sky130_fd_sc_hd__decap_3
XFILLER_45_122 VGND VGND VPWR VPWR sky130_fd_sc_hd__fill_2
XFILLER_33_306 VGND VGND VPWR VPWR sky130_fd_sc_hd__fill_1
XFILLER_45_166 VGND VGND VPWR VPWR sky130_fd_sc_hd__fill_2
XFILLER_73_486 VGND VGND VPWR VPWR sky130_fd_sc_hd__fill_2
XPHY_EDGE_ROW_77_Left_181 VGND VGND VPWR VPWR sky130_fd_sc_hd__decap_3
XFILLER_26_380 VGND VGND VPWR VPWR sky130_fd_sc_hd__decap_3
XFILLER_14_575 VGND VGND VPWR VPWR sky130_fd_sc_hd__fill_1
XFILLER_60_147 VGND VGND VPWR VPWR sky130_fd_sc_hd__decap_3
XFILLER_41_372 VGND VGND VPWR VPWR sky130_fd_sc_hd__decap_3
Xplace1908 _3459_/B VGND VGND VPWR VPWR _3516_/A2 sky130_fd_sc_hd__buf_2
XFILLER_5_262 VGND VGND VPWR VPWR sky130_fd_sc_hd__fill_2
XPHY_EDGE_ROW_86_Left_190 VGND VGND VPWR VPWR sky130_fd_sc_hd__decap_3
Xplace1919 _3412_/Y VGND VGND VPWR VPWR _3441_/A2 sky130_fd_sc_hd__buf_2
XFILLER_68_214 VGND VGND VPWR VPWR sky130_fd_sc_hd__decap_3
XFILLER_68_247 VGND VGND VPWR VPWR sky130_fd_sc_hd__decap_3
X_4120_ _4579_/A _4579_/B VGND VGND VPWR VPWR _4120_/Y sky130_fd_sc_hd__nand2_2
XFILLER_37_601 VGND VGND VPWR VPWR sky130_fd_sc_hd__fill_1
X_4051_ _4051_/A _4051_/B VGND VGND VPWR VPWR _4052_/B sky130_fd_sc_hd__nor2_2
XFILLER_36_100 VGND VGND VPWR VPWR sky130_fd_sc_hd__decap_3
XTAP_TAPCELL_ROW_67_927 VGND VPWR sky130_fd_sc_hd__tapvpwrvgnd_1
XTAP_TAPCELL_ROW_39_629 VGND VPWR sky130_fd_sc_hd__tapvpwrvgnd_1
XFILLER_36_155 VGND VGND VPWR VPWR sky130_fd_sc_hd__decap_3
XFILLER_51_147 VGND VGND VPWR VPWR sky130_fd_sc_hd__decap_3
X_3904_ _6318_/B2 _3904_/A2 _3901_/X _3902_/X _3903_/X VGND VGND VPWR VPWR _3904_/Y
+ sky130_fd_sc_hd__a2111oi_4
XFILLER_20_512 VGND VGND VPWR VPWR sky130_fd_sc_hd__decap_3
XFILLER_20_545 VGND VGND VPWR VPWR sky130_fd_sc_hd__decap_3
X_3835_ _3835_/A _3835_/B VGND VGND VPWR VPWR _4018_/B sky130_fd_sc_hd__nor2_2
XTAP_TAPCELL_ROW_30_540 VGND VPWR sky130_fd_sc_hd__tapvpwrvgnd_1
X_3766_ _7443_/Q _3913_/A2 _3816_/B1 _7347_/Q _3765_/X VGND VGND VPWR VPWR _3766_/X
+ sky130_fd_sc_hd__a221o_2
X_6485_ _6483_/X _6484_/X _6048_/A VGND VGND VPWR VPWR _6486_/B sky130_fd_sc_hd__a21oi_2
X_5505_ _5505_/A0 _5566_/A1 _5545_/S VGND VGND VPWR VPWR _7187_/D sky130_fd_sc_hd__mux2_2
XFILLER_10_26 VGND VGND VPWR VPWR sky130_fd_sc_hd__fill_2
XFILLER_59_203 VGND VGND VPWR VPWR sky130_fd_sc_hd__decap_3
XFILLER_59_225 VGND VGND VPWR VPWR sky130_fd_sc_hd__fill_1
X_7106_ _7274_/CLK _7106_/D VGND VGND VPWR VPWR _7106_/Q sky130_fd_sc_hd__dfxtp_2
X_4318_ _6714_/A1 _5732_/S _4317_/X VGND VGND VPWR VPWR _7292_/D sky130_fd_sc_hd__a21o_2
XFILLER_101_333 VGND VGND VPWR VPWR sky130_fd_sc_hd__decap_3
XFILLER_19_24 VGND VGND VPWR VPWR sky130_fd_sc_hd__decap_3
X_7037_ _7287_/CLK _7037_/D VGND VGND VPWR VPWR _7037_/Q sky130_fd_sc_hd__dfxtp_2
X_4249_ _4249_/A _4249_/B _4249_/C VGND VGND VPWR VPWR _4254_/A sky130_fd_sc_hd__and3_2
XFILLER_19_57 VGND VGND VPWR VPWR sky130_fd_sc_hd__fill_1
XFILLER_19_68 VGND VGND VPWR VPWR sky130_fd_sc_hd__decap_3
XFILLER_27_144 VGND VGND VPWR VPWR sky130_fd_sc_hd__fill_2
XTAP_TAPCELL_ROW_2_243 VGND VPWR sky130_fd_sc_hd__tapvpwrvgnd_1
XFILLER_55_475 VGND VGND VPWR VPWR sky130_fd_sc_hd__decap_3
XFILLER_27_199 VGND VGND VPWR VPWR sky130_fd_sc_hd__decap_3
XFILLER_30_309 VGND VGND VPWR VPWR sky130_fd_sc_hd__decap_3
XFILLER_35_89 VGND VGND VPWR VPWR sky130_fd_sc_hd__fill_2
XFILLER_42_169 VGND VGND VPWR VPWR sky130_fd_sc_hd__fill_1
XFILLER_23_372 VGND VGND VPWR VPWR sky130_fd_sc_hd__fill_2
XFILLER_23_383 VGND VGND VPWR VPWR sky130_fd_sc_hd__decap_3
XFILLER_11_556 VGND VGND VPWR VPWR sky130_fd_sc_hd__decap_3
XFILLER_7_505 VGND VGND VPWR VPWR sky130_fd_sc_hd__fill_2
XFILLER_11_578 VGND VGND VPWR VPWR sky130_fd_sc_hd__fill_2
XFILLER_7_527 VGND VGND VPWR VPWR sky130_fd_sc_hd__decap_3
XFILLER_51_99 VGND VGND VPWR VPWR sky130_fd_sc_hd__decap_3
XFILLER_2_232 VGND VGND VPWR VPWR sky130_fd_sc_hd__fill_2
XFILLER_2_298 VGND VGND VPWR VPWR sky130_fd_sc_hd__decap_3
XFILLER_18_9 VGND VGND VPWR VPWR sky130_fd_sc_hd__decap_3
XFILLER_18_144 VGND VGND VPWR VPWR sky130_fd_sc_hd__decap_3
XFILLER_46_453 VGND VGND VPWR VPWR sky130_fd_sc_hd__decap_3
XFILLER_18_188 VGND VGND VPWR VPWR sky130_fd_sc_hd__decap_3
XFILLER_33_147 VGND VGND VPWR VPWR sky130_fd_sc_hd__fill_1
XFILLER_33_169 VGND VGND VPWR VPWR sky130_fd_sc_hd__fill_2
XTAP_TAPCELL_ROW_72_974 VGND VPWR sky130_fd_sc_hd__tapvpwrvgnd_1
XTAP_TAPCELL_ROW_44_687 VGND VPWR sky130_fd_sc_hd__tapvpwrvgnd_1
XTAP_TAPCELL_ROW_16_389 VGND VPWR sky130_fd_sc_hd__tapvpwrvgnd_1
XFILLER_41_191 VGND VGND VPWR VPWR sky130_fd_sc_hd__decap_3
XTAP_TAPCELL_ROW_99_1258 VGND VPWR sky130_fd_sc_hd__tapvpwrvgnd_1
Xplace1705 _3561_/Y VGND VGND VPWR VPWR _5739_/B2 sky130_fd_sc_hd__buf_2
Xplace1716 place1720/X VGND VGND VPWR VPWR _3909_/A2 sky130_fd_sc_hd__clkbuf_4
Xplace1727 _3505_/Y VGND VGND VPWR VPWR _3568_/B sky130_fd_sc_hd__buf_4
XFILLER_51_3 VGND VGND VPWR VPWR sky130_fd_sc_hd__decap_3
Xplace1738 _3500_/Y VGND VGND VPWR VPWR _4312_/B sky130_fd_sc_hd__buf_2
Xplace1749 _3490_/X VGND VGND VPWR VPWR _3913_/A2 sky130_fd_sc_hd__buf_2
X_3482_ _3961_/A _4337_/B VGND VGND VPWR VPWR _3482_/Y sky130_fd_sc_hd__nor2b_2
X_5221_ _5221_/A0 _5221_/A1 _5230_/S VGND VGND VPWR VPWR _7069_/D sky130_fd_sc_hd__mux2_2
Xhold2418 _7147_/Q VGND VGND VPWR VPWR _5417_/A0 sky130_fd_sc_hd__dlygate4sd3_1
Xhold2407 _6887_/Q VGND VGND VPWR VPWR _4815_/A0 sky130_fd_sc_hd__dlygate4sd3_1
X_5152_ _5152_/A0 _5608_/A1 _5152_/S VGND VGND VPWR VPWR _7039_/D sky130_fd_sc_hd__mux2_2
Xhold2429 _6985_/Q VGND VGND VPWR VPWR _5036_/A0 sky130_fd_sc_hd__dlygate4sd3_1
X_4103_ _3970_/X _3972_/Y _4099_/Y _4102_/Y VGND VGND VPWR VPWR _4103_/Y sky130_fd_sc_hd__o22ai_4
XFILLER_2_71 VGND VGND VPWR VPWR sky130_fd_sc_hd__decap_3
X_5083_ _5083_/A0 _4751_/Y _5089_/S VGND VGND VPWR VPWR _7007_/D sky130_fd_sc_hd__mux2_2
XFILLER_24_103 VGND VGND VPWR VPWR sky130_fd_sc_hd__fill_1
XFILLER_24_125 VGND VGND VPWR VPWR sky130_fd_sc_hd__decap_3
XFILLER_37_486 VGND VGND VPWR VPWR sky130_fd_sc_hd__decap_3
XFILLER_52_412 VGND VGND VPWR VPWR sky130_fd_sc_hd__fill_1
XFILLER_64_272 VGND VGND VPWR VPWR sky130_fd_sc_hd__decap_3
XFILLER_92_592 VGND VGND VPWR VPWR sky130_fd_sc_hd__decap_3
XFILLER_12_309 VGND VGND VPWR VPWR sky130_fd_sc_hd__decap_3
XFILLER_24_147 VGND VGND VPWR VPWR sky130_fd_sc_hd__decap_3
X_5985_ _5987_/A1 _7192_/Q _7136_/Q _6171_/A2 VGND VGND VPWR VPWR _5985_/X sky130_fd_sc_hd__o22a_2
XFILLER_52_489 VGND VGND VPWR VPWR sky130_fd_sc_hd__decap_3
XANTENNA_10 rst VGND VGND VPWR VPWR sky130_fd_sc_hd__diode_2
XANTENNA_21 _7083_/Q VGND VGND VPWR VPWR sky130_fd_sc_hd__diode_2
XANTENNA_32 _5190_/A0 VGND VGND VPWR VPWR sky130_fd_sc_hd__diode_2
XANTENNA_43 _4105_/Y VGND VGND VPWR VPWR sky130_fd_sc_hd__diode_2
XANTENNA_54 _7274_/Q VGND VGND VPWR VPWR sky130_fd_sc_hd__diode_2
XFILLER_20_375 VGND VGND VPWR VPWR sky130_fd_sc_hd__fill_1
X_7586_ clkload6/A _7586_/D place2061/X VGND VGND VPWR VPWR _7586_/Q sky130_fd_sc_hd__dfrtp_2
X_3818_ _4237_/C _3818_/B _3818_/C _4279_/D VGND VGND VPWR VPWR _3819_/A sky130_fd_sc_hd__and4b_2
XFILLER_21_25 VGND VGND VPWR VPWR sky130_fd_sc_hd__decap_3
X_6537_ _6537_/A0 _6144_/X _6541_/S VGND VGND VPWR VPWR _7439_/D sky130_fd_sc_hd__mux2_4
X_4798_ _4798_/A0 _5688_/A1 _4808_/S VGND VGND VPWR VPWR _6879_/D sky130_fd_sc_hd__mux2_2
X_3749_ _6383_/B2 _6706_/S _3748_/X VGND VGND VPWR VPWR _3751_/A sky130_fd_sc_hd__a21oi_2
XTAP_TAPCELL_ROW_76_1022 VGND VPWR sky130_fd_sc_hd__tapvpwrvgnd_1
XFILLER_97_29 VGND VGND VPWR VPWR sky130_fd_sc_hd__fill_2
X_6468_ _6995_/Q _6468_/A2 _7023_/Q _6502_/B1 VGND VGND VPWR VPWR _6468_/X sky130_fd_sc_hd__o22a_2
X_6399_ _6399_/A1 _6924_/Q _7260_/Q _6399_/B2 VGND VGND VPWR VPWR _6399_/X sky130_fd_sc_hd__o22a_2
X_5419_ _5419_/A0 _5724_/A1 _5423_/S VGND VGND VPWR VPWR _7148_/D sky130_fd_sc_hd__mux2_2
XFILLER_87_331 VGND VGND VPWR VPWR sky130_fd_sc_hd__fill_1
Xhold2930 _7381_/Q VGND VGND VPWR VPWR _6340_/B2 sky130_fd_sc_hd__dlygate4sd3_1
Xhold2941 _7507_/Q VGND VGND VPWR VPWR _6692_/A0 sky130_fd_sc_hd__dlygate4sd3_1
Xhold2952 _7458_/Q VGND VGND VPWR VPWR _6588_/A0 sky130_fd_sc_hd__dlygate4sd3_1
Xhold2963 _7469_/Q VGND VGND VPWR VPWR _6611_/A0 sky130_fd_sc_hd__dlygate4sd3_1
Xhold2974 _7398_/Q VGND VGND VPWR VPWR _6319_/A1 sky130_fd_sc_hd__dlygate4sd3_1
Xhold2985 _7526_/Q VGND VGND VPWR VPWR _6731_/A1 sky130_fd_sc_hd__dlygate4sd3_1
Xhold2996 _7428_/Q VGND VGND VPWR VPWR _6499_/A0 sky130_fd_sc_hd__dlygate4sd3_1
XFILLER_28_475 VGND VGND VPWR VPWR sky130_fd_sc_hd__fill_1
XTAP_TAPCELL_ROW_87_1140 VGND VPWR sky130_fd_sc_hd__tapvpwrvgnd_1
XFILLER_28_486 VGND VGND VPWR VPWR sky130_fd_sc_hd__decap_3
XFILLER_83_581 VGND VGND VPWR VPWR sky130_fd_sc_hd__fill_2
XFILLER_15_169 VGND VGND VPWR VPWR sky130_fd_sc_hd__decap_3
XFILLER_43_456 VGND VGND VPWR VPWR sky130_fd_sc_hd__decap_3
XFILLER_70_231 VGND VGND VPWR VPWR sky130_fd_sc_hd__decap_3
XFILLER_30_139 VGND VGND VPWR VPWR sky130_fd_sc_hd__fill_1
XTAP_TAPCELL_ROW_41_657 VGND VPWR sky130_fd_sc_hd__tapvpwrvgnd_1
XFILLER_7_324 VGND VGND VPWR VPWR sky130_fd_sc_hd__decap_3
XTAP_TAPCELL_ROW_13_359 VGND VPWR sky130_fd_sc_hd__tapvpwrvgnd_1
XFILLER_3_585 VGND VGND VPWR VPWR sky130_fd_sc_hd__decap_3
XFILLER_3_596 VGND VGND VPWR VPWR sky130_fd_sc_hd__fill_2
XFILLER_93_356 VGND VGND VPWR VPWR sky130_fd_sc_hd__decap_3
XTAP_TAPCELL_ROW_49_735 VGND VPWR sky130_fd_sc_hd__tapvpwrvgnd_1
XFILLER_34_434 VGND VGND VPWR VPWR sky130_fd_sc_hd__decap_3
XFILLER_74_592 VGND VGND VPWR VPWR sky130_fd_sc_hd__decap_3
XFILLER_34_467 VGND VGND VPWR VPWR sky130_fd_sc_hd__decap_3
XFILLER_61_231 VGND VGND VPWR VPWR sky130_fd_sc_hd__decap_3
XFILLER_34_489 VGND VGND VPWR VPWR sky130_fd_sc_hd__fill_1
XFILLER_99_3 VGND VGND VPWR VPWR sky130_fd_sc_hd__decap_3
X_5770_ _6449_/A2 _7201_/Q _7173_/Q _5797_/A1 VGND VGND VPWR VPWR _5770_/X sky130_fd_sc_hd__o22a_2
XFILLER_21_139 VGND VGND VPWR VPWR sky130_fd_sc_hd__decap_3
X_4721_ _4718_/X _4719_/Y _4720_/X _4757_/A1 _6334_/B2 VGND VGND VPWR VPWR _4721_/X
+ sky130_fd_sc_hd__a32o_2
X_7440_ _7610_/CLK _7440_/D place2067/X VGND VGND VPWR VPWR _7440_/Q sky130_fd_sc_hd__dfrtp_2
X_4652_ _4652_/A0 _5692_/A1 _4672_/S VGND VGND VPWR VPWR _6853_/D sky130_fd_sc_hd__mux2_2
Xplace1502 _3848_/X VGND VGND VPWR VPWR _4669_/B2 sky130_fd_sc_hd__buf_2
X_7371_ _7493_/CLK _7371_/D place2042/X VGND VGND VPWR VPWR _7371_/Q sky130_fd_sc_hd__dfrtp_2
X_4583_ _4842_/B _4842_/C _6465_/C _6465_/B VGND VGND VPWR VPWR _5610_/B sky130_fd_sc_hd__o2bb2a_2
Xplace1513 _3778_/Y VGND VGND VPWR VPWR _4562_/A1 sky130_fd_sc_hd__buf_2
Xplace1524 _3707_/Y VGND VGND VPWR VPWR _4568_/B sky130_fd_sc_hd__buf_2
Xplace1535 _5843_/X VGND VGND VPWR VPWR _6184_/C1 sky130_fd_sc_hd__buf_2
X_6322_ _7401_/Q _6324_/A2 _6322_/A3 _6324_/B1 _6322_/B2 VGND VGND VPWR VPWR _6322_/X
+ sky130_fd_sc_hd__a32o_2
X_3534_ _3536_/D _3534_/A2 _3562_/A4 _3576_/C _7388_/Q VGND VGND VPWR VPWR _3538_/B
+ sky130_fd_sc_hd__o2111ai_2
Xplace1546 _5099_/A1 VGND VGND VPWR VPWR _5310_/A1 sky130_fd_sc_hd__buf_2
Xplace1557 _3951_/Y VGND VGND VPWR VPWR _4399_/A2 sky130_fd_sc_hd__buf_2
Xplace1568 _3781_/X VGND VGND VPWR VPWR _4704_/B1 sky130_fd_sc_hd__buf_2
X_3465_ _4613_/A2 _4613_/A3 _4613_/B1 _3463_/X VGND VGND VPWR VPWR _3541_/D sky130_fd_sc_hd__a211o_2
Xplace1579 _3504_/Y VGND VGND VPWR VPWR _3592_/B1 sky130_fd_sc_hd__buf_2
X_6184_ _6184_/A1 _6564_/D _6184_/B1 _6183_/X _6184_/C1 VGND VGND VPWR VPWR _6184_/X
+ sky130_fd_sc_hd__a221o_2
XFILLER_29_217 VGND VGND VPWR VPWR sky130_fd_sc_hd__decap_3
X_5135_ _5135_/A0 _5591_/A1 _5152_/S VGND VGND VPWR VPWR _7031_/D sky130_fd_sc_hd__mux2_2
XFILLER_57_537 VGND VGND VPWR VPWR sky130_fd_sc_hd__fill_1
X_5066_ _5066_/A0 _5188_/A1 _5085_/S VGND VGND VPWR VPWR _6999_/D sky130_fd_sc_hd__mux2_2
XFILLER_44_209 VGND VGND VPWR VPWR sky130_fd_sc_hd__decap_3
X_4017_ _4017_/A _4017_/B _4017_/C _4017_/D VGND VGND VPWR VPWR _4017_/Y sky130_fd_sc_hd__nor4_4
XFILLER_25_434 VGND VGND VPWR VPWR sky130_fd_sc_hd__decap_3
XFILLER_37_272 VGND VGND VPWR VPWR sky130_fd_sc_hd__decap_3
XFILLER_16_47 VGND VGND VPWR VPWR sky130_fd_sc_hd__decap_3
XFILLER_12_106 VGND VGND VPWR VPWR sky130_fd_sc_hd__decap_3
X_5968_ _5967_/Y _5965_/Y _5549_/C VGND VGND VPWR VPWR _5978_/C sky130_fd_sc_hd__o21ai_2
XTAP_TAPCELL_ROW_82_1081 VGND VPWR sky130_fd_sc_hd__tapvpwrvgnd_1
X_5899_ _6146_/B1 _7030_/Q _6946_/Q _6399_/B2 VGND VGND VPWR VPWR _5899_/X sky130_fd_sc_hd__o22a_2
XFILLER_20_172 VGND VGND VPWR VPWR sky130_fd_sc_hd__decap_3
XFILLER_32_57 VGND VGND VPWR VPWR sky130_fd_sc_hd__fill_2
XTAP_TAPCELL_ROW_10_329 VGND VPWR sky130_fd_sc_hd__tapvpwrvgnd_1
X_7569_ _7579_/CLK _7569_/D place2016/X VGND VGND VPWR VPWR _7569_/Q sky130_fd_sc_hd__dfrtp_2
XFILLER_4_327 VGND VGND VPWR VPWR sky130_fd_sc_hd__decap_3
Xoutput2090 _4278_/X VGND VGND VPWR VPWR result[28] sky130_fd_sc_hd__buf_6
XFILLER_0_533 VGND VGND VPWR VPWR sky130_fd_sc_hd__decap_3
XFILLER_0_599 VGND VGND VPWR VPWR sky130_fd_sc_hd__decap_3
XFILLER_57_65 VGND VGND VPWR VPWR sky130_fd_sc_hd__fill_2
XFILLER_57_76 VGND VGND VPWR VPWR sky130_fd_sc_hd__decap_3
Xhold2760 _6863_/Q VGND VGND VPWR VPWR _4723_/A0 sky130_fd_sc_hd__dlygate4sd3_1
Xhold2771 _6936_/Q VGND VGND VPWR VPWR _4924_/A0 sky130_fd_sc_hd__dlygate4sd3_1
Xhold2782 _6886_/Q VGND VGND VPWR VPWR _4813_/A0 sky130_fd_sc_hd__dlygate4sd3_1
Xhold2793 _7053_/Q VGND VGND VPWR VPWR _5184_/A0 sky130_fd_sc_hd__dlygate4sd3_1
XTAP_TAPCELL_ROW_46_705 VGND VPWR sky130_fd_sc_hd__tapvpwrvgnd_1
XTAP_TAPCELL_ROW_18_407 VGND VPWR sky130_fd_sc_hd__tapvpwrvgnd_1
XFILLER_28_283 VGND VGND VPWR VPWR sky130_fd_sc_hd__decap_3
XFILLER_43_231 VGND VGND VPWR VPWR sky130_fd_sc_hd__decap_3
XFILLER_31_415 VGND VGND VPWR VPWR sky130_fd_sc_hd__decap_3
XFILLER_71_573 VGND VGND VPWR VPWR sky130_fd_sc_hd__fill_1
XTAP_TAPCELL_ROW_54_793 VGND VPWR sky130_fd_sc_hd__tapvpwrvgnd_1
XTAP_TAPCELL_ROW_26_495 VGND VPWR sky130_fd_sc_hd__tapvpwrvgnd_1
XFILLER_11_172 VGND VGND VPWR VPWR sky130_fd_sc_hd__decap_3
XFILLER_11_194 VGND VGND VPWR VPWR sky130_fd_sc_hd__decap_3
XTAP_TAPCELL_ROW_96_1228 VGND VPWR sky130_fd_sc_hd__tapvpwrvgnd_1
XFILLER_3_393 VGND VGND VPWR VPWR sky130_fd_sc_hd__fill_2
XPHY_EDGE_ROW_13_Left_117 VGND VGND VPWR VPWR sky130_fd_sc_hd__decap_3
XFILLER_14_3 VGND VGND VPWR VPWR sky130_fd_sc_hd__decap_3
XFILLER_39_537 VGND VGND VPWR VPWR sky130_fd_sc_hd__fill_1
XFILLER_39_548 VGND VGND VPWR VPWR sky130_fd_sc_hd__decap_3
XFILLER_66_345 VGND VGND VPWR VPWR sky130_fd_sc_hd__decap_3
XFILLER_66_378 VGND VGND VPWR VPWR sky130_fd_sc_hd__decap_3
X_6940_ _7241_/CLK _6940_/D VGND VGND VPWR VPWR _6940_/Q sky130_fd_sc_hd__dfxtp_2
XFILLER_19_261 VGND VGND VPWR VPWR sky130_fd_sc_hd__decap_3
XFILLER_93_186 VGND VGND VPWR VPWR sky130_fd_sc_hd__fill_2
XFILLER_34_242 VGND VGND VPWR VPWR sky130_fd_sc_hd__decap_3
X_6871_ _7287_/CLK _6871_/D VGND VGND VPWR VPWR _6871_/Q sky130_fd_sc_hd__dfxtp_2
XFILLER_34_253 VGND VGND VPWR VPWR sky130_fd_sc_hd__fill_1
XFILLER_34_264 VGND VGND VPWR VPWR sky130_fd_sc_hd__decap_3
XPHY_EDGE_ROW_22_Left_126 VGND VGND VPWR VPWR sky130_fd_sc_hd__decap_3
X_5822_ _4629_/S _5807_/X _5820_/X _5821_/X VGND VGND VPWR VPWR _5822_/X sky130_fd_sc_hd__o22a_2
XFILLER_34_297 VGND VGND VPWR VPWR sky130_fd_sc_hd__decap_3
X_4704_ _7408_/Q _6376_/A2 _6335_/A3 _4704_/B1 _5979_/A VGND VGND VPWR VPWR _4704_/X
+ sky130_fd_sc_hd__a311o_2
XFILLER_30_470 VGND VGND VPWR VPWR sky130_fd_sc_hd__decap_3
X_5684_ _5684_/A0 _5684_/A1 _5698_/S VGND VGND VPWR VPWR _7269_/D sky130_fd_sc_hd__mux2_2
XFILLER_8_70 VGND VGND VPWR VPWR sky130_fd_sc_hd__decap_3
XFILLER_8_81 VGND VGND VPWR VPWR sky130_fd_sc_hd__decap_3
Xplace2011 _3481_/A VGND VGND VPWR VPWR _3437_/D sky130_fd_sc_hd__buf_2
Xplace2000 _7292_/Q VGND VGND VPWR VPWR _3444_/A sky130_fd_sc_hd__buf_8
X_7423_ _7581_/CLK _7423_/D place2023/X VGND VGND VPWR VPWR _7423_/Q sky130_fd_sc_hd__dfrtp_2
X_4635_ _3508_/C _4734_/A3 _4734_/A2 _5839_/B1 VGND VGND VPWR VPWR _4735_/C sky130_fd_sc_hd__a31o_2
Xplace1310 _4105_/A VGND VGND VPWR VPWR _4778_/A sky130_fd_sc_hd__buf_2
Xplace2055 place2056/X VGND VGND VPWR VPWR place2055/X sky130_fd_sc_hd__buf_2
Xplace2044 place2045/X VGND VGND VPWR VPWR place2044/X sky130_fd_sc_hd__buf_2
Xplace2033 place2034/X VGND VGND VPWR VPWR place2033/X sky130_fd_sc_hd__buf_2
Xplace2022 place2025/X VGND VGND VPWR VPWR place2022/X sky130_fd_sc_hd__buf_2
X_7354_ _7579_/CLK _7354_/D place2016/X VGND VGND VPWR VPWR _7354_/Q sky130_fd_sc_hd__dfrtp_2
X_4566_ _4464_/B _4566_/A2 _4563_/X _4565_/X VGND VGND VPWR VPWR _4567_/C sky130_fd_sc_hd__o211a_2
Xplace1321 _6204_/A2 VGND VGND VPWR VPWR _6394_/A1 sky130_fd_sc_hd__buf_2
Xplace1332 _6171_/B1 VGND VGND VPWR VPWR _6397_/B2 sky130_fd_sc_hd__buf_4
Xplace1343 _6501_/A1 VGND VGND VPWR VPWR _6511_/B2 sky130_fd_sc_hd__buf_2
Xplace2066 place2067/X VGND VGND VPWR VPWR place2066/X sky130_fd_sc_hd__buf_2
X_3517_ _3459_/A _3460_/A _3499_/A _3430_/Y VGND VGND VPWR VPWR _3519_/B sky130_fd_sc_hd__o22a_4
XFILLER_103_225 VGND VGND VPWR VPWR sky130_fd_sc_hd__decap_3
XFILLER_89_415 VGND VGND VPWR VPWR sky130_fd_sc_hd__decap_3
XPHY_EDGE_ROW_31_Left_135 VGND VGND VPWR VPWR sky130_fd_sc_hd__decap_3
Xplace1354 _4168_/C VGND VGND VPWR VPWR _4152_/B sky130_fd_sc_hd__buf_2
Xplace1365 _4097_/X VGND VGND VPWR VPWR _5759_/D1 sky130_fd_sc_hd__buf_4
Xplace1376 _4197_/A VGND VGND VPWR VPWR _3834_/B sky130_fd_sc_hd__buf_2
X_7285_ _7290_/CLK _7285_/D VGND VGND VPWR VPWR _7285_/Q sky130_fd_sc_hd__dfxtp_2
X_4497_ _4498_/A _4498_/B _4498_/C VGND VGND VPWR VPWR _4497_/Y sky130_fd_sc_hd__a21oi_2
Xplace1387 _6304_/X VGND VGND VPWR VPWR _6345_/B1 sky130_fd_sc_hd__buf_2
Xplace1398 _4096_/Y VGND VGND VPWR VPWR _4579_/D sky130_fd_sc_hd__buf_6
Xrebuffer2366 _4667_/A VGND VGND VPWR VPWR _4726_/B1 sky130_fd_sc_hd__buf_4
X_3448_ _3445_/A _3448_/A2 _3411_/Y _3412_/Y VGND VGND VPWR VPWR _3519_/C sky130_fd_sc_hd__o22ai_4
X_6167_ _6213_/B2 _7171_/Q _7143_/Q _6171_/A2 VGND VGND VPWR VPWR _6167_/X sky130_fd_sc_hd__o22a_2
XFILLER_69_183 VGND VGND VPWR VPWR sky130_fd_sc_hd__fill_1
X_5118_ _5118_/A0 _5696_/A1 _5118_/S VGND VGND VPWR VPWR _7023_/D sky130_fd_sc_hd__mux2_2
XFILLER_17_209 VGND VGND VPWR VPWR sky130_fd_sc_hd__decap_3
XFILLER_45_518 VGND VGND VPWR VPWR sky130_fd_sc_hd__decap_3
XFILLER_57_356 VGND VGND VPWR VPWR sky130_fd_sc_hd__fill_2
X_6098_ _6397_/B2 _7054_/Q _6858_/Q _6399_/B2 VGND VGND VPWR VPWR _6098_/X sky130_fd_sc_hd__o22a_2
XFILLER_27_46 VGND VGND VPWR VPWR sky130_fd_sc_hd__decap_3
XFILLER_38_570 VGND VGND VPWR VPWR sky130_fd_sc_hd__fill_1
X_5049_ _5049_/A0 _4631_/X _5059_/S VGND VGND VPWR VPWR _6991_/D sky130_fd_sc_hd__mux2_2
XTAP_TAPCELL_ROW_84_1110 VGND VPWR sky130_fd_sc_hd__tapvpwrvgnd_1
XFILLER_25_231 VGND VGND VPWR VPWR sky130_fd_sc_hd__decap_3
XPHY_EDGE_ROW_40_Left_144 VGND VGND VPWR VPWR sky130_fd_sc_hd__decap_3
XFILLER_40_223 VGND VGND VPWR VPWR sky130_fd_sc_hd__decap_3
XFILLER_40_256 VGND VGND VPWR VPWR sky130_fd_sc_hd__decap_3
XFILLER_43_89 VGND VGND VPWR VPWR sky130_fd_sc_hd__decap_3
XTAP_TAPCELL_ROW_51_763 VGND VPWR sky130_fd_sc_hd__tapvpwrvgnd_1
XTAP_TAPCELL_ROW_23_465 VGND VPWR sky130_fd_sc_hd__tapvpwrvgnd_1
XFILLER_4_135 VGND VGND VPWR VPWR sky130_fd_sc_hd__decap_3
XFILLER_0_330 VGND VGND VPWR VPWR sky130_fd_sc_hd__decap_3
XFILLER_68_75 VGND VGND VPWR VPWR sky130_fd_sc_hd__fill_1
XFILLER_0_396 VGND VGND VPWR VPWR sky130_fd_sc_hd__decap_3
XTAP_TAPCELL_ROW_59_841 VGND VPWR sky130_fd_sc_hd__tapvpwrvgnd_1
XFILLER_75_142 VGND VGND VPWR VPWR sky130_fd_sc_hd__fill_1
XFILLER_91_602 VGND VGND VPWR VPWR sky130_fd_sc_hd__fill_1
Xhold2590 _7036_/Q VGND VGND VPWR VPWR _5146_/A0 sky130_fd_sc_hd__dlygate4sd3_1
XFILLER_63_337 VGND VGND VPWR VPWR sky130_fd_sc_hd__decap_3
XFILLER_44_551 VGND VGND VPWR VPWR sky130_fd_sc_hd__decap_3
XFILLER_31_201 VGND VGND VPWR VPWR sky130_fd_sc_hd__fill_1
XFILLER_31_212 VGND VGND VPWR VPWR sky130_fd_sc_hd__fill_2
XFILLER_31_223 VGND VGND VPWR VPWR sky130_fd_sc_hd__fill_1
XFILLER_31_234 VGND VGND VPWR VPWR sky130_fd_sc_hd__decap_3
XTAP_TAPCELL_ROW_100_1276 VGND VPWR sky130_fd_sc_hd__tapvpwrvgnd_1
X_4420_ _7301_/Q _4420_/B VGND VGND VPWR VPWR _4430_/C sky130_fd_sc_hd__xnor2_2
X_7070_ _7266_/CLK _7070_/D VGND VGND VPWR VPWR _7070_/Q sky130_fd_sc_hd__dfxtp_2
X_4282_ _4273_/Y _4276_/C _4281_/X VGND VGND VPWR VPWR _4282_/Y sky130_fd_sc_hd__o21bai_4
XFILLER_86_429 VGND VGND VPWR VPWR sky130_fd_sc_hd__fill_1
XFILLER_39_334 VGND VGND VPWR VPWR sky130_fd_sc_hd__fill_2
XFILLER_66_197 VGND VGND VPWR VPWR sky130_fd_sc_hd__fill_2
X_6923_ _7291_/CLK _6923_/D VGND VGND VPWR VPWR _6923_/Q sky130_fd_sc_hd__dfxtp_2
XFILLER_35_595 VGND VGND VPWR VPWR sky130_fd_sc_hd__decap_3
X_6854_ _7274_/CLK _6854_/D VGND VGND VPWR VPWR _6854_/Q sky130_fd_sc_hd__dfxtp_2
X_6785_ _6789_/A _6785_/B VGND VGND VPWR VPWR _7551_/D sky130_fd_sc_hd__and2_2
X_5805_ _6502_/A2 _6989_/Q _6961_/Q _6501_/A1 VGND VGND VPWR VPWR _5805_/X sky130_fd_sc_hd__o22a_2
X_3997_ _7394_/Q _6658_/S VGND VGND VPWR VPWR _3998_/C sky130_fd_sc_hd__nand2_2
XFILLER_22_289 VGND VGND VPWR VPWR sky130_fd_sc_hd__decap_3
X_5667_ _5667_/A0 _5728_/A1 _5669_/S VGND VGND VPWR VPWR _7262_/D sky130_fd_sc_hd__mux2_2
XTAP_TAPCELL_ROW_20_435 VGND VPWR sky130_fd_sc_hd__tapvpwrvgnd_1
X_7406_ _7507_/CLK _7406_/D place2048/X VGND VGND VPWR VPWR _7406_/Q sky130_fd_sc_hd__dfrtp_2
XFILLER_2_606 VGND VGND VPWR VPWR sky130_fd_sc_hd__decap_3
X_5598_ _5598_/A0 _5720_/A1 _5606_/S VGND VGND VPWR VPWR _7230_/D sky130_fd_sc_hd__mux2_2
XFILLER_1_105 VGND VGND VPWR VPWR sky130_fd_sc_hd__decap_3
XFILLER_1_116 VGND VGND VPWR VPWR sky130_fd_sc_hd__fill_1
Xplace1140 _5661_/A1 VGND VGND VPWR VPWR _5600_/A1 sky130_fd_sc_hd__buf_2
Xplace1151 _4178_/X VGND VGND VPWR VPWR _6077_/A1 sky130_fd_sc_hd__buf_2
Xrebuffer2130 _3949_/A2 VGND VGND VPWR VPWR _3901_/B sky130_fd_sc_hd__buf_2
X_7337_ clkload9/A _7337_/D place2034/X VGND VGND VPWR VPWR _7337_/Q sky130_fd_sc_hd__dfrtp_2
X_4549_ _4548_/X _7608_/D _4559_/A VGND VGND VPWR VPWR _4549_/X sky130_fd_sc_hd__mux2_2
XFILLER_1_127 VGND VGND VPWR VPWR sky130_fd_sc_hd__decap_3
XFILLER_89_234 VGND VGND VPWR VPWR sky130_fd_sc_hd__fill_1
Xplace1162 _5728_/S VGND VGND VPWR VPWR _5730_/S sky130_fd_sc_hd__buf_2
Xplace1173 _4998_/S VGND VGND VPWR VPWR _4994_/S sky130_fd_sc_hd__buf_2
Xplace1184 _5329_/S VGND VGND VPWR VPWR _5361_/S sky130_fd_sc_hd__buf_2
Xplace1195 _5057_/S VGND VGND VPWR VPWR _5059_/S sky130_fd_sc_hd__buf_2
Xrebuffer2141 _6012_/X VGND VGND VPWR VPWR _6083_/B1 sky130_fd_sc_hd__buf_6
Xrebuffer2152 _3579_/X VGND VGND VPWR VPWR _4394_/B sky130_fd_sc_hd__buf_2
Xrebuffer2163 _5746_/X VGND VGND VPWR VPWR _5959_/A1 sky130_fd_sc_hd__buf_2
Xrebuffer2174 place1295/X VGND VGND VPWR VPWR _5981_/B2 sky130_fd_sc_hd__buf_2
X_7268_ _7275_/CLK _7268_/D VGND VGND VPWR VPWR _7268_/Q sky130_fd_sc_hd__dfxtp_2
XFILLER_49_109 VGND VGND VPWR VPWR sky130_fd_sc_hd__decap_3
Xrebuffer2185 _5987_/B2 VGND VGND VPWR VPWR _5797_/A1 sky130_fd_sc_hd__buf_2
X_6219_ _6219_/A1 _6220_/A2 _6560_/B _7608_/Q VGND VGND VPWR VPWR _6219_/X sky130_fd_sc_hd__o22a_2
X_7199_ _7235_/CLK _7199_/D VGND VGND VPWR VPWR _7199_/Q sky130_fd_sc_hd__dfxtp_2
XFILLER_38_78 VGND VGND VPWR VPWR sky130_fd_sc_hd__decap_3
XFILLER_18_518 VGND VGND VPWR VPWR sky130_fd_sc_hd__fill_1
XFILLER_57_175 VGND VGND VPWR VPWR sky130_fd_sc_hd__decap_3
XTAP_TAPCELL_ROW_56_811 VGND VPWR sky130_fd_sc_hd__tapvpwrvgnd_1
XTAP_TAPCELL_ROW_28_513 VGND VPWR sky130_fd_sc_hd__tapvpwrvgnd_1
XFILLER_45_337 VGND VGND VPWR VPWR sky130_fd_sc_hd__fill_2
XFILLER_45_348 VGND VGND VPWR VPWR sky130_fd_sc_hd__decap_3
XFILLER_72_134 VGND VGND VPWR VPWR sky130_fd_sc_hd__fill_2
XFILLER_54_66 VGND VGND VPWR VPWR sky130_fd_sc_hd__decap_3
XFILLER_13_201 VGND VGND VPWR VPWR sky130_fd_sc_hd__decap_3
XFILLER_13_234 VGND VGND VPWR VPWR sky130_fd_sc_hd__decap_3
XFILLER_41_576 VGND VGND VPWR VPWR sky130_fd_sc_hd__decap_3
XFILLER_5_400 VGND VGND VPWR VPWR sky130_fd_sc_hd__decap_3
Xclkload19 _7575_/CLK VGND VGND VPWR VPWR clkload19/X sky130_fd_sc_hd__clkbuf_4
XFILLER_76_473 VGND VGND VPWR VPWR sky130_fd_sc_hd__decap_3
XFILLER_36_348 VGND VGND VPWR VPWR sky130_fd_sc_hd__decap_3
XFILLER_63_156 VGND VGND VPWR VPWR sky130_fd_sc_hd__decap_3
XFILLER_91_487 VGND VGND VPWR VPWR sky130_fd_sc_hd__fill_2
X_3920_ _7299_/Q _3920_/B VGND VGND VPWR VPWR _3920_/Y sky130_fd_sc_hd__nand2_2
XFILLER_44_392 VGND VGND VPWR VPWR sky130_fd_sc_hd__decap_3
XFILLER_32_543 VGND VGND VPWR VPWR sky130_fd_sc_hd__decap_3
XFILLER_32_565 VGND VGND VPWR VPWR sky130_fd_sc_hd__decap_3
XTAP_TAPCELL_ROW_62_869 VGND VPWR sky130_fd_sc_hd__tapvpwrvgnd_1
XFILLER_32_587 VGND VGND VPWR VPWR sky130_fd_sc_hd__fill_1
X_3782_ _7408_/Q _6706_/S _3781_/X VGND VGND VPWR VPWR _3782_/Y sky130_fd_sc_hd__a21oi_2
X_5452_ _5452_/A0 _5635_/A1 _5452_/S VGND VGND VPWR VPWR _7163_/D sky130_fd_sc_hd__mux2_2
X_5383_ _5383_/A0 _5566_/A1 _5391_/S VGND VGND VPWR VPWR _7131_/D sky130_fd_sc_hd__mux2_2
X_4403_ _4613_/B1 _4613_/A2 _4403_/B1 VGND VGND VPWR VPWR _4439_/D sky130_fd_sc_hd__o21ai_2
XFILLER_5_60 VGND VGND VPWR VPWR sky130_fd_sc_hd__fill_1
X_7122_ _7290_/CLK _7122_/D VGND VGND VPWR VPWR _7122_/Q sky130_fd_sc_hd__dfxtp_2
X_4334_ _6718_/A1 _5732_/S _4332_/X _6720_/S VGND VGND VPWR VPWR _7294_/D sky130_fd_sc_hd__a22o_2
XFILLER_59_418 VGND VGND VPWR VPWR sky130_fd_sc_hd__fill_1
XFILLER_99_587 VGND VGND VPWR VPWR sky130_fd_sc_hd__fill_1
X_7053_ _7280_/CLK _7053_/D VGND VGND VPWR VPWR _7053_/Q sky130_fd_sc_hd__dfxtp_2
X_6004_ _6213_/A1 _7095_/Q _6871_/Q _6173_/B2 VGND VGND VPWR VPWR _6005_/B sky130_fd_sc_hd__o22a_2
X_4265_ _3738_/B _4751_/A2 _4568_/C _4279_/D VGND VGND VPWR VPWR _4265_/X sky130_fd_sc_hd__and4bb_2
X_4196_ _3834_/B _4199_/A2 _4195_/Y VGND VGND VPWR VPWR _4196_/X sky130_fd_sc_hd__o21a_2
XFILLER_39_175 VGND VGND VPWR VPWR sky130_fd_sc_hd__decap_3
XFILLER_27_337 VGND VGND VPWR VPWR sky130_fd_sc_hd__fill_2
XFILLER_35_370 VGND VGND VPWR VPWR sky130_fd_sc_hd__decap_3
XFILLER_42_329 VGND VGND VPWR VPWR sky130_fd_sc_hd__decap_3
XFILLER_54_189 VGND VGND VPWR VPWR sky130_fd_sc_hd__decap_3
X_6906_ _7274_/CLK _6906_/D VGND VGND VPWR VPWR _6906_/Q sky130_fd_sc_hd__dfxtp_2
XFILLER_24_69 VGND VGND VPWR VPWR sky130_fd_sc_hd__decap_3
XTAP_TAPCELL_ROW_33_571 VGND VPWR sky130_fd_sc_hd__tapvpwrvgnd_1
XFILLER_10_248 VGND VGND VPWR VPWR sky130_fd_sc_hd__decap_3
XFILLER_10_259 VGND VGND VPWR VPWR sky130_fd_sc_hd__decap_3
XFILLER_40_24 VGND VGND VPWR VPWR sky130_fd_sc_hd__decap_3
XFILLER_40_68 VGND VGND VPWR VPWR sky130_fd_sc_hd__decap_3
XTAP_TAPCELL_ROW_79_1053 VGND VPWR sky130_fd_sc_hd__tapvpwrvgnd_1
XFILLER_2_403 VGND VGND VPWR VPWR sky130_fd_sc_hd__decap_3
XFILLER_2_425 VGND VGND VPWR VPWR sky130_fd_sc_hd__decap_3
XFILLER_49_88 VGND VGND VPWR VPWR sky130_fd_sc_hd__decap_3
XFILLER_18_304 VGND VGND VPWR VPWR sky130_fd_sc_hd__decap_3
XFILLER_18_315 VGND VGND VPWR VPWR sky130_fd_sc_hd__decap_3
XFILLER_58_473 VGND VGND VPWR VPWR sky130_fd_sc_hd__decap_3
XTAP_TAPCELL_ROW_5_274 VGND VPWR sky130_fd_sc_hd__tapvpwrvgnd_1
XFILLER_18_337 VGND VGND VPWR VPWR sky130_fd_sc_hd__decap_3
XFILLER_65_54 VGND VGND VPWR VPWR sky130_fd_sc_hd__fill_2
XFILLER_85_281 VGND VGND VPWR VPWR sky130_fd_sc_hd__fill_1
XFILLER_65_87 VGND VGND VPWR VPWR sky130_fd_sc_hd__decap_3
XFILLER_14_80 VGND VGND VPWR VPWR sky130_fd_sc_hd__decap_3
Xplace1909 _4379_/A VGND VGND VPWR VPWR _4561_/A1 sky130_fd_sc_hd__buf_2
XFILLER_46_6 VGND VGND VPWR VPWR sky130_fd_sc_hd__fill_2
XFILLER_68_259 VGND VGND VPWR VPWR sky130_fd_sc_hd__decap_3
X_4050_ _7304_/Q _7305_/Q _7306_/Q _4050_/D VGND VGND VPWR VPWR _4055_/C sky130_fd_sc_hd__and4_2
XFILLER_49_473 VGND VGND VPWR VPWR sky130_fd_sc_hd__decap_3
XFILLER_76_270 VGND VGND VPWR VPWR sky130_fd_sc_hd__decap_3
XTAP_TAPCELL_ROW_67_928 VGND VPWR sky130_fd_sc_hd__tapvpwrvgnd_1
XFILLER_24_307 VGND VGND VPWR VPWR sky130_fd_sc_hd__fill_1
XFILLER_24_318 VGND VGND VPWR VPWR sky130_fd_sc_hd__fill_1
XFILLER_51_137 VGND VGND VPWR VPWR sky130_fd_sc_hd__fill_1
X_4952_ _4952_/A0 _5351_/A1 _4952_/S VGND VGND VPWR VPWR _6949_/D sky130_fd_sc_hd__mux2_2
XFILLER_32_351 VGND VGND VPWR VPWR sky130_fd_sc_hd__decap_3
XFILLER_51_159 VGND VGND VPWR VPWR sky130_fd_sc_hd__fill_2
X_4883_ _4883_/A0 _5711_/A1 _4896_/S VGND VGND VPWR VPWR _6918_/D sky130_fd_sc_hd__mux2_2
X_3903_ _3990_/A1 _3903_/A2 _7493_/Q _4009_/B1 _7429_/Q VGND VGND VPWR VPWR _3903_/X
+ sky130_fd_sc_hd__a32o_2
X_6622_ _6622_/A0 _6181_/X _6634_/S VGND VGND VPWR VPWR _7474_/D sky130_fd_sc_hd__mux2_4
X_3834_ _4206_/B _3834_/B _3834_/C _4212_/B VGND VGND VPWR VPWR _3835_/B sky130_fd_sc_hd__nand4b_2
XFILLER_20_557 VGND VGND VPWR VPWR sky130_fd_sc_hd__decap_3
X_6553_ _6553_/A0 _6201_/X _6567_/S VGND VGND VPWR VPWR _7445_/D sky130_fd_sc_hd__mux2_2
X_3765_ _3815_/A1 _3792_/A2 _7379_/Q _3815_/B1 _7571_/Q VGND VGND VPWR VPWR _3765_/X
+ sky130_fd_sc_hd__a32o_2
XTAP_TAPCELL_ROW_30_541 VGND VPWR sky130_fd_sc_hd__tapvpwrvgnd_1
X_6484_ _7071_/Q _6484_/A2 _7099_/Q _6484_/B2 VGND VGND VPWR VPWR _6484_/X sky130_fd_sc_hd__o22a_2
X_3696_ _3696_/A _3696_/B VGND VGND VPWR VPWR _3699_/B sky130_fd_sc_hd__nor2_2
XPHY_EDGE_ROW_5_Left_109 VGND VGND VPWR VPWR sky130_fd_sc_hd__decap_3
X_5435_ _5435_/A0 _5679_/A1 _5452_/S VGND VGND VPWR VPWR _7155_/D sky130_fd_sc_hd__mux2_2
XFILLER_87_502 VGND VGND VPWR VPWR sky130_fd_sc_hd__fill_2
X_5366_ _5427_/A _5610_/B _5549_/C VGND VGND VPWR VPWR _5425_/S sky130_fd_sc_hd__and3_2
XFILLER_87_513 VGND VGND VPWR VPWR sky130_fd_sc_hd__fill_1
X_7105_ _7273_/CLK _7105_/D VGND VGND VPWR VPWR _7105_/Q sky130_fd_sc_hd__dfxtp_2
X_4317_ _7582_/D _4317_/B VGND VGND VPWR VPWR _4317_/X sky130_fd_sc_hd__xor2_2
XFILLER_87_557 VGND VGND VPWR VPWR sky130_fd_sc_hd__decap_3
X_7036_ _7291_/CLK _7036_/D VGND VGND VPWR VPWR _7036_/Q sky130_fd_sc_hd__dfxtp_2
X_4248_ _4248_/A1 _4240_/Y _4249_/C _4248_/C1 VGND VGND VPWR VPWR _4251_/A sky130_fd_sc_hd__a211oi_2
XFILLER_67_281 VGND VGND VPWR VPWR sky130_fd_sc_hd__decap_3
XTAP_TAPCELL_ROW_2_244 VGND VPWR sky130_fd_sc_hd__tapvpwrvgnd_1
XFILLER_27_167 VGND VGND VPWR VPWR sky130_fd_sc_hd__fill_1
XFILLER_35_57 VGND VGND VPWR VPWR sky130_fd_sc_hd__decap_3
XFILLER_35_68 VGND VGND VPWR VPWR sky130_fd_sc_hd__decap_3
XFILLER_23_351 VGND VGND VPWR VPWR sky130_fd_sc_hd__fill_1
XPHY_EDGE_ROW_14_Right_14 VGND VGND VPWR VPWR sky130_fd_sc_hd__decap_3
Xclkbuf_3_3__f_clk clkbuf_0_clk/X VGND VGND VPWR VPWR clkload0/A sky130_fd_sc_hd__clkbuf_8
XFILLER_51_67 VGND VGND VPWR VPWR sky130_fd_sc_hd__fill_2
XPHY_EDGE_ROW_23_Right_23 VGND VGND VPWR VPWR sky130_fd_sc_hd__decap_3
XFILLER_76_42 VGND VGND VPWR VPWR sky130_fd_sc_hd__decap_3
XFILLER_65_218 VGND VGND VPWR VPWR sky130_fd_sc_hd__decap_3
XFILLER_65_229 VGND VGND VPWR VPWR sky130_fd_sc_hd__decap_3
XFILLER_18_112 VGND VGND VPWR VPWR sky130_fd_sc_hd__decap_3
XFILLER_18_156 VGND VGND VPWR VPWR sky130_fd_sc_hd__decap_3
XFILLER_46_465 VGND VGND VPWR VPWR sky130_fd_sc_hd__fill_2
XFILLER_61_457 VGND VGND VPWR VPWR sky130_fd_sc_hd__fill_1
XPHY_EDGE_ROW_32_Right_32 VGND VGND VPWR VPWR sky130_fd_sc_hd__decap_3
XTAP_TAPCELL_ROW_72_975 VGND VPWR sky130_fd_sc_hd__tapvpwrvgnd_1
XFILLER_25_90 VGND VGND VPWR VPWR sky130_fd_sc_hd__decap_3
XTAP_TAPCELL_ROW_44_688 VGND VPWR sky130_fd_sc_hd__tapvpwrvgnd_1
XTAP_TAPCELL_ROW_99_1259 VGND VPWR sky130_fd_sc_hd__tapvpwrvgnd_1
Xplace1706 _3544_/C VGND VGND VPWR VPWR _3776_/A3 sky130_fd_sc_hd__buf_2
Xplace1717 _3984_/B1 VGND VGND VPWR VPWR _3879_/A2 sky130_fd_sc_hd__buf_2
Xplace1728 _5850_/B VGND VGND VPWR VPWR _3946_/A sky130_fd_sc_hd__buf_2
Xplace1739 _3548_/B1 VGND VGND VPWR VPWR _4395_/A1 sky130_fd_sc_hd__buf_2
X_3481_ _3481_/A _3481_/B VGND VGND VPWR VPWR _3481_/Y sky130_fd_sc_hd__nand2_2
XPHY_EDGE_ROW_41_Right_41 VGND VGND VPWR VPWR sky130_fd_sc_hd__decap_3
XFILLER_69_535 VGND VGND VPWR VPWR sky130_fd_sc_hd__fill_1
Xhold2419 _7177_/Q VGND VGND VPWR VPWR _5482_/A0 sky130_fd_sc_hd__dlygate4sd3_1
Xhold2408 _7029_/Q VGND VGND VPWR VPWR _5131_/A0 sky130_fd_sc_hd__dlygate4sd3_1
XFILLER_69_557 VGND VGND VPWR VPWR sky130_fd_sc_hd__decap_3
X_4102_ _4100_/Y _4101_/X _4096_/Y _3988_/Y VGND VGND VPWR VPWR _4102_/Y sky130_fd_sc_hd__a2bb2oi_2
XFILLER_96_365 VGND VGND VPWR VPWR sky130_fd_sc_hd__decap_3
X_4033_ _4035_/B _4033_/B VGND VGND VPWR VPWR _7588_/D sky130_fd_sc_hd__and2_2
XFILLER_49_281 VGND VGND VPWR VPWR sky130_fd_sc_hd__decap_3
XFILLER_52_402 VGND VGND VPWR VPWR sky130_fd_sc_hd__fill_1
XFILLER_37_498 VGND VGND VPWR VPWR sky130_fd_sc_hd__decap_3
XPHY_EDGE_ROW_50_Right_50 VGND VGND VPWR VPWR sky130_fd_sc_hd__decap_3
X_5984_ _7220_/Q _6451_/B1 _5984_/B1 _7164_/Q VGND VGND VPWR VPWR _5984_/X sky130_fd_sc_hd__o22a_2
X_4935_ _4935_/A0 _5334_/A1 _4958_/S VGND VGND VPWR VPWR _6941_/D sky130_fd_sc_hd__mux2_2
XANTENNA_11 rst VGND VGND VPWR VPWR sky130_fd_sc_hd__diode_2
XANTENNA_22 _7113_/Q VGND VGND VPWR VPWR sky130_fd_sc_hd__diode_2
XFILLER_20_321 VGND VGND VPWR VPWR sky130_fd_sc_hd__decap_3
XFILLER_32_192 VGND VGND VPWR VPWR sky130_fd_sc_hd__decap_3
X_4866_ _4866_/A0 _5694_/A1 _4868_/S VGND VGND VPWR VPWR _6910_/D sky130_fd_sc_hd__mux2_2
XANTENNA_33 _5265_/A0 VGND VGND VPWR VPWR sky130_fd_sc_hd__diode_2
XANTENNA_44 _7320_/Q VGND VGND VPWR VPWR sky130_fd_sc_hd__diode_2
XANTENNA_55 _5192_/A0 VGND VGND VPWR VPWR sky130_fd_sc_hd__diode_2
XFILLER_20_354 VGND VGND VPWR VPWR sky130_fd_sc_hd__decap_3
X_7585_ clkload6/A _7585_/D place2030/X VGND VGND VPWR VPWR _7585_/Q sky130_fd_sc_hd__dfrtp_2
X_6605_ _6605_/A0 _6080_/X _6607_/S VGND VGND VPWR VPWR _7466_/D sky130_fd_sc_hd__mux2_2
X_3817_ _7406_/Q _6376_/A2 _3817_/A3 _3816_/X VGND VGND VPWR VPWR _3818_/C sky130_fd_sc_hd__a31o_2
X_3748_ _6541_/A0 _3913_/A2 _3816_/B1 _7345_/Q _3747_/X VGND VGND VPWR VPWR _3748_/X
+ sky130_fd_sc_hd__a221o_2
XTAP_TAPCELL_ROW_76_1023 VGND VPWR sky130_fd_sc_hd__tapvpwrvgnd_1
X_6467_ _6483_/A1 _6967_/Q _6939_/Q _6483_/B2 VGND VGND VPWR VPWR _6467_/X sky130_fd_sc_hd__o22a_2
X_3679_ _7382_/Q _3811_/A2 _3907_/B1 _7414_/Q VGND VGND VPWR VPWR _3680_/C sky130_fd_sc_hd__a22oi_2
X_6398_ _6396_/X _6397_/X _6398_/B1 VGND VGND VPWR VPWR _6403_/C sky130_fd_sc_hd__a21oi_2
Xhold2920 _7550_/Q VGND VGND VPWR VPWR _6783_/B sky130_fd_sc_hd__dlygate4sd3_1
Xhold2931 _6340_/X VGND VGND VPWR VPWR _7381_/D sky130_fd_sc_hd__dlygate4sd3_1
Xhold2942 _7497_/Q VGND VGND VPWR VPWR _6371_/A1 sky130_fd_sc_hd__dlygate4sd3_1
Xhold2953 _7456_/Q VGND VGND VPWR VPWR _6583_/A0 sky130_fd_sc_hd__dlygate4sd3_1
Xhold2964 _7508_/Q VGND VGND VPWR VPWR _6694_/A0 sky130_fd_sc_hd__dlygate4sd3_1
Xhold2975 _7424_/Q VGND VGND VPWR VPWR _6444_/A0 sky130_fd_sc_hd__dlygate4sd3_1
XFILLER_28_421 VGND VGND VPWR VPWR sky130_fd_sc_hd__decap_3
XFILLER_75_549 VGND VGND VPWR VPWR sky130_fd_sc_hd__fill_2
Xhold2986 _7549_/Q VGND VGND VPWR VPWR _6781_/B sky130_fd_sc_hd__dlygate4sd3_1
Xhold2997 _7454_/Q VGND VGND VPWR VPWR _6579_/A0 sky130_fd_sc_hd__dlygate4sd3_1
X_7019_ _7243_/CLK _7019_/D VGND VGND VPWR VPWR _7019_/Q sky130_fd_sc_hd__dfxtp_2
XFILLER_28_454 VGND VGND VPWR VPWR sky130_fd_sc_hd__decap_3
XTAP_TAPCELL_ROW_87_1141 VGND VPWR sky130_fd_sc_hd__tapvpwrvgnd_1
XFILLER_15_104 VGND VGND VPWR VPWR sky130_fd_sc_hd__decap_3
XFILLER_55_284 VGND VGND VPWR VPWR sky130_fd_sc_hd__decap_3
XFILLER_43_468 VGND VGND VPWR VPWR sky130_fd_sc_hd__decap_3
XFILLER_70_276 VGND VGND VPWR VPWR sky130_fd_sc_hd__decap_3
XTAP_TAPCELL_ROW_41_658 VGND VPWR sky130_fd_sc_hd__tapvpwrvgnd_1
XFILLER_7_358 VGND VGND VPWR VPWR sky130_fd_sc_hd__decap_3
XFILLER_66_527 VGND VGND VPWR VPWR sky130_fd_sc_hd__decap_3
XFILLER_78_365 VGND VGND VPWR VPWR sky130_fd_sc_hd__fill_2
XFILLER_87_96 VGND VGND VPWR VPWR sky130_fd_sc_hd__decap_3
XFILLER_93_346 VGND VGND VPWR VPWR sky130_fd_sc_hd__fill_1
XTAP_TAPCELL_ROW_49_736 VGND VPWR sky130_fd_sc_hd__tapvpwrvgnd_1
XFILLER_34_424 VGND VGND VPWR VPWR sky130_fd_sc_hd__fill_2
XFILLER_46_262 VGND VGND VPWR VPWR sky130_fd_sc_hd__fill_2
XFILLER_61_210 VGND VGND VPWR VPWR sky130_fd_sc_hd__decap_3
XFILLER_61_243 VGND VGND VPWR VPWR sky130_fd_sc_hd__decap_3
Xclkbuf_leaf_41_clk clkbuf_leaf_0_clk/A VGND VGND VPWR VPWR clkload3/A sky130_fd_sc_hd__clkbuf_16
X_4720_ _6436_/A _6436_/B _4720_/C _4727_/D VGND VGND VPWR VPWR _4720_/X sky130_fd_sc_hd__or4_2
X_7370_ _7493_/CLK _7370_/D place2042/X VGND VGND VPWR VPWR _7370_/Q sky130_fd_sc_hd__dfrtp_2
X_4582_ _4582_/A _4582_/B VGND VGND VPWR VPWR _6465_/C sky130_fd_sc_hd__nand2_2
Xplace1503 _3850_/A VGND VGND VPWR VPWR _4188_/C1 sky130_fd_sc_hd__buf_2
Xplace1514 _3773_/A VGND VGND VPWR VPWR _4237_/D sky130_fd_sc_hd__buf_2
Xplace1525 _3680_/Y VGND VGND VPWR VPWR _4568_/C sky130_fd_sc_hd__buf_2
X_6321_ _6321_/A1 _6324_/A2 _6322_/A3 _6324_/B1 _6321_/B2 VGND VGND VPWR VPWR _7368_/D
+ sky130_fd_sc_hd__a32o_2
X_3533_ _3529_/B _3529_/A _3536_/A _3536_/B VGND VGND VPWR VPWR _3533_/Y sky130_fd_sc_hd__a22oi_4
Xplace1536 _6220_/B1 VGND VGND VPWR VPWR _6229_/B1 sky130_fd_sc_hd__buf_2
Xplace1547 _4005_/X VGND VGND VPWR VPWR _5099_/A1 sky130_fd_sc_hd__buf_2
Xplace1558 _3951_/Y VGND VGND VPWR VPWR _3958_/B1 sky130_fd_sc_hd__buf_2
Xplace1569 _3766_/X VGND VGND VPWR VPWR _4725_/B1 sky130_fd_sc_hd__buf_2
X_6252_ _6298_/A _6252_/B VGND VGND VPWR VPWR _7333_/D sky130_fd_sc_hd__and2_2
XFILLER_69_310 VGND VGND VPWR VPWR sky130_fd_sc_hd__fill_2
X_6183_ _6183_/A _6183_/B _6183_/C _5789_/X VGND VGND VPWR VPWR _6183_/X sky130_fd_sc_hd__or4b_4
X_5203_ _5203_/A0 _5720_/A1 _5213_/S VGND VGND VPWR VPWR _7062_/D sky130_fd_sc_hd__mux2_2
XFILLER_69_343 VGND VGND VPWR VPWR sky130_fd_sc_hd__decap_3
XFILLER_84_346 VGND VGND VPWR VPWR sky130_fd_sc_hd__fill_1
X_4016_ _4579_/C _3989_/Y _4016_/B1 _4015_/X VGND VGND VPWR VPWR _4017_/B sky130_fd_sc_hd__a211o_2
XFILLER_25_402 VGND VGND VPWR VPWR sky130_fd_sc_hd__decap_3
XFILLER_13_608 VGND VGND VPWR VPWR sky130_fd_sc_hd__decap_3
XFILLER_25_457 VGND VGND VPWR VPWR sky130_fd_sc_hd__decap_3
XFILLER_12_118 VGND VGND VPWR VPWR sky130_fd_sc_hd__decap_3
X_5967_ _7228_/Q _6168_/B2 _7144_/Q _6173_/B2 VGND VGND VPWR VPWR _5967_/Y sky130_fd_sc_hd__o22ai_2
XFILLER_12_129 VGND VGND VPWR VPWR sky130_fd_sc_hd__decap_3
Xclkbuf_leaf_32_clk clkload0/A VGND VGND VPWR VPWR _7575_/CLK sky130_fd_sc_hd__clkbuf_16
X_4918_ _4918_/A0 _5317_/A1 _4952_/S VGND VGND VPWR VPWR _6933_/D sky130_fd_sc_hd__mux2_2
XTAP_TAPCELL_ROW_82_1082 VGND VPWR sky130_fd_sc_hd__tapvpwrvgnd_1
X_5898_ _6392_/A _5894_/X _6395_/B1 _5897_/X VGND VGND VPWR VPWR _5908_/B sky130_fd_sc_hd__o22a_2
XFILLER_20_184 VGND VGND VPWR VPWR sky130_fd_sc_hd__decap_3
X_4849_ _4849_/A0 _5677_/A1 _4868_/S VGND VGND VPWR VPWR _6902_/D sky130_fd_sc_hd__mux2_2
X_7568_ _7579_/CLK _7568_/D place2035/X VGND VGND VPWR VPWR _7568_/Q sky130_fd_sc_hd__dfrtp_2
X_7499_ clkload3/A _7499_/D place2059/X VGND VGND VPWR VPWR _7499_/Q sky130_fd_sc_hd__dfrtp_2
XFILLER_0_512 VGND VGND VPWR VPWR sky130_fd_sc_hd__decap_3
Xoutput2080 place122/X VGND VGND VPWR VPWR result[19] sky130_fd_sc_hd__clkbuf_2
Xoutput2091 _4285_/X VGND VGND VPWR VPWR result[29] sky130_fd_sc_hd__buf_8
XFILLER_0_556 VGND VGND VPWR VPWR sky130_fd_sc_hd__decap_3
XFILLER_0_567 VGND VGND VPWR VPWR sky130_fd_sc_hd__decap_3
XFILLER_102_473 VGND VGND VPWR VPWR sky130_fd_sc_hd__decap_3
Xhold2750 _7198_/Q VGND VGND VPWR VPWR _5528_/A0 sky130_fd_sc_hd__dlygate4sd3_1
XFILLER_75_313 VGND VGND VPWR VPWR sky130_fd_sc_hd__decap_3
Xhold2761 _7054_/Q VGND VGND VPWR VPWR _5186_/A0 sky130_fd_sc_hd__dlygate4sd3_1
Xhold2772 _7138_/Q VGND VGND VPWR VPWR _5398_/A0 sky130_fd_sc_hd__dlygate4sd3_1
Xhold2783 _7059_/Q VGND VGND VPWR VPWR _5196_/A0 sky130_fd_sc_hd__dlygate4sd3_1
Xhold2794 _6948_/Q VGND VGND VPWR VPWR _4949_/A0 sky130_fd_sc_hd__dlygate4sd3_1
XTAP_TAPCELL_ROW_46_706 VGND VPWR sky130_fd_sc_hd__tapvpwrvgnd_1
XFILLER_16_424 VGND VGND VPWR VPWR sky130_fd_sc_hd__fill_1
XFILLER_28_251 VGND VGND VPWR VPWR sky130_fd_sc_hd__fill_1
XFILLER_28_262 VGND VGND VPWR VPWR sky130_fd_sc_hd__decap_3
XFILLER_43_210 VGND VGND VPWR VPWR sky130_fd_sc_hd__decap_3
XTAP_TAPCELL_ROW_18_408 VGND VPWR sky130_fd_sc_hd__tapvpwrvgnd_1
XFILLER_16_446 VGND VGND VPWR VPWR sky130_fd_sc_hd__decap_3
XFILLER_28_295 VGND VGND VPWR VPWR sky130_fd_sc_hd__decap_3
XFILLER_16_468 VGND VGND VPWR VPWR sky130_fd_sc_hd__decap_3
XFILLER_43_276 VGND VGND VPWR VPWR sky130_fd_sc_hd__decap_3
XFILLER_31_427 VGND VGND VPWR VPWR sky130_fd_sc_hd__decap_3
XFILLER_31_438 VGND VGND VPWR VPWR sky130_fd_sc_hd__decap_3
XFILLER_31_449 VGND VGND VPWR VPWR sky130_fd_sc_hd__decap_3
Xclkbuf_leaf_23_clk clkload1/A VGND VGND VPWR VPWR _7288_/CLK sky130_fd_sc_hd__clkbuf_16
XTAP_TAPCELL_ROW_54_794 VGND VPWR sky130_fd_sc_hd__tapvpwrvgnd_1
XTAP_TAPCELL_ROW_26_496 VGND VPWR sky130_fd_sc_hd__tapvpwrvgnd_1
XFILLER_11_184 VGND VGND VPWR VPWR sky130_fd_sc_hd__decap_3
XTAP_TAPCELL_ROW_96_1229 VGND VPWR sky130_fd_sc_hd__tapvpwrvgnd_1
XFILLER_22_91 VGND VGND VPWR VPWR sky130_fd_sc_hd__decap_3
XFILLER_3_383 VGND VGND VPWR VPWR sky130_fd_sc_hd__decap_3
XFILLER_39_505 VGND VGND VPWR VPWR sky130_fd_sc_hd__decap_3
XFILLER_94_611 VGND VGND VPWR VPWR sky130_fd_sc_hd__fill_1
XFILLER_66_368 VGND VGND VPWR VPWR sky130_fd_sc_hd__fill_1
XFILLER_19_284 VGND VGND VPWR VPWR sky130_fd_sc_hd__decap_3
XFILLER_47_571 VGND VGND VPWR VPWR sky130_fd_sc_hd__fill_1
XFILLER_47_593 VGND VGND VPWR VPWR sky130_fd_sc_hd__fill_1
XFILLER_34_210 VGND VGND VPWR VPWR sky130_fd_sc_hd__decap_3
X_6870_ _7217_/CLK _6870_/D VGND VGND VPWR VPWR _6870_/Q sky130_fd_sc_hd__dfxtp_2
X_5821_ _6465_/B _6436_/B _6436_/C VGND VGND VPWR VPWR _5821_/X sky130_fd_sc_hd__or3_2
XFILLER_22_427 VGND VGND VPWR VPWR sky130_fd_sc_hd__decap_3
Xclkbuf_leaf_14_clk clkbuf_leaf_9_clk/A VGND VGND VPWR VPWR _7273_/CLK sky130_fd_sc_hd__clkbuf_16
Xplace2012 place2013/X VGND VGND VPWR VPWR place2012/X sky130_fd_sc_hd__buf_2
Xplace2001 _7292_/Q VGND VGND VPWR VPWR _3500_/B sky130_fd_sc_hd__buf_6
X_7422_ clkload7/A _7422_/D place2020/X VGND VGND VPWR VPWR _7422_/Q sky130_fd_sc_hd__dfrtp_2
Xplace1300 _4131_/Y VGND VGND VPWR VPWR _4134_/A sky130_fd_sc_hd__buf_2
Xplace2045 place2046/X VGND VGND VPWR VPWR place2045/X sky130_fd_sc_hd__buf_2
Xplace2034 place2035/X VGND VGND VPWR VPWR place2034/X sky130_fd_sc_hd__buf_2
Xplace2023 place2024/X VGND VGND VPWR VPWR place2023/X sky130_fd_sc_hd__buf_2
X_7353_ _7577_/CLK _7353_/D place2036/X VGND VGND VPWR VPWR _7353_/Q sky130_fd_sc_hd__dfrtp_2
X_4565_ _4565_/A1 _4565_/A2 _4464_/B _4564_/Y VGND VGND VPWR VPWR _4565_/X sky130_fd_sc_hd__o31a_2
Xplace1311 _4017_/Y VGND VGND VPWR VPWR _4305_/B sky130_fd_sc_hd__buf_6
Xplace1322 place1325/X VGND VGND VPWR VPWR _6204_/A2 sky130_fd_sc_hd__buf_2
Xplace1333 _5987_/B2 VGND VGND VPWR VPWR _6171_/B1 sky130_fd_sc_hd__clkbuf_4
Xplace1344 _6483_/A1 VGND VGND VPWR VPWR _6501_/A1 sky130_fd_sc_hd__buf_2
Xplace2067 place2068/X VGND VGND VPWR VPWR place2067/X sky130_fd_sc_hd__buf_2
Xplace2056 place2067/X VGND VGND VPWR VPWR place2056/X sky130_fd_sc_hd__buf_2
X_6304_ _6347_/A _6304_/B _6347_/C _6347_/D VGND VGND VPWR VPWR _6304_/X sky130_fd_sc_hd__or4_2
X_3516_ _3628_/A1 _3516_/A2 _3826_/A _3508_/A VGND VGND VPWR VPWR _3536_/A sky130_fd_sc_hd__a211o_4
XPHY_EDGE_ROW_4_Right_4 VGND VGND VPWR VPWR sky130_fd_sc_hd__decap_3
Xplace1355 _4133_/X VGND VGND VPWR VPWR _4134_/B sky130_fd_sc_hd__buf_2
Xplace1366 _4133_/B VGND VGND VPWR VPWR _4016_/B1 sky130_fd_sc_hd__buf_2
Xplace1377 _3797_/Y VGND VGND VPWR VPWR _4206_/B sky130_fd_sc_hd__buf_2
X_7284_ _7575_/CLK _7284_/D VGND VGND VPWR VPWR _7284_/Q sky130_fd_sc_hd__dfxtp_2
X_4496_ _4478_/B _4495_/X _4482_/B VGND VGND VPWR VPWR _4498_/C sky130_fd_sc_hd__a21o_2
Xplace1388 _6304_/X VGND VGND VPWR VPWR _6313_/B1 sky130_fd_sc_hd__buf_2
Xplace1399 _4151_/B VGND VGND VPWR VPWR _3974_/A2 sky130_fd_sc_hd__buf_2
Xrebuffer2367 _4728_/X VGND VGND VPWR VPWR _5715_/A1 sky130_fd_sc_hd__buf_2
X_6235_ _6235_/A _6247_/A VGND VGND VPWR VPWR _7325_/D sky130_fd_sc_hd__or2b_2
XFILLER_85_611 VGND VGND VPWR VPWR sky130_fd_sc_hd__fill_1
X_6166_ _7087_/Q _6397_/A1 _6173_/A1 _7115_/Q _6165_/X VGND VGND VPWR VPWR _6166_/X
+ sky130_fd_sc_hd__o221a_2
XFILLER_84_110 VGND VGND VPWR VPWR sky130_fd_sc_hd__decap_3
XFILLER_45_508 VGND VGND VPWR VPWR sky130_fd_sc_hd__fill_1
XFILLER_38_582 VGND VGND VPWR VPWR sky130_fd_sc_hd__decap_3
XFILLER_72_305 VGND VGND VPWR VPWR sky130_fd_sc_hd__decap_3
XTAP_TAPCELL_ROW_84_1100 VGND VPWR sky130_fd_sc_hd__tapvpwrvgnd_1
XFILLER_53_541 VGND VGND VPWR VPWR sky130_fd_sc_hd__decap_3
XFILLER_72_349 VGND VGND VPWR VPWR sky130_fd_sc_hd__decap_3
XFILLER_13_405 VGND VGND VPWR VPWR sky130_fd_sc_hd__decap_3
XFILLER_25_287 VGND VGND VPWR VPWR sky130_fd_sc_hd__fill_2
X_6999_ _7114_/CLK _6999_/D VGND VGND VPWR VPWR _6999_/Q sky130_fd_sc_hd__dfxtp_2
XFILLER_43_57 VGND VGND VPWR VPWR sky130_fd_sc_hd__fill_2
XTAP_TAPCELL_ROW_23_466 VGND VPWR sky130_fd_sc_hd__tapvpwrvgnd_1
XFILLER_4_103 VGND VGND VPWR VPWR sky130_fd_sc_hd__decap_3
XFILLER_4_147 VGND VGND VPWR VPWR sky130_fd_sc_hd__decap_3
XFILLER_48_324 VGND VGND VPWR VPWR sky130_fd_sc_hd__decap_3
Xhold2591 _7030_/Q VGND VGND VPWR VPWR _5133_/A0 sky130_fd_sc_hd__dlygate4sd3_1
Xhold2580 _7103_/Q VGND VGND VPWR VPWR _5321_/A0 sky130_fd_sc_hd__dlygate4sd3_1
XTAP_TAPCELL_ROW_59_842 VGND VPWR sky130_fd_sc_hd__tapvpwrvgnd_1
XFILLER_16_221 VGND VGND VPWR VPWR sky130_fd_sc_hd__decap_3
XFILLER_63_349 VGND VGND VPWR VPWR sky130_fd_sc_hd__decap_3
XFILLER_44_574 VGND VGND VPWR VPWR sky130_fd_sc_hd__decap_3
XFILLER_71_393 VGND VGND VPWR VPWR sky130_fd_sc_hd__fill_1
XFILLER_31_246 VGND VGND VPWR VPWR sky130_fd_sc_hd__decap_3
XTAP_TAPCELL_ROW_100_1277 VGND VPWR sky130_fd_sc_hd__tapvpwrvgnd_1
XFILLER_76_6 VGND VGND VPWR VPWR sky130_fd_sc_hd__fill_1
X_4350_ _4350_/A1 _5732_/S _4349_/X VGND VGND VPWR VPWR _7295_/D sky130_fd_sc_hd__a21o_2
X_4281_ _4283_/C _4281_/B _4281_/C VGND VGND VPWR VPWR _4281_/X sky130_fd_sc_hd__or3_2
Xclkbuf_leaf_3_clk clkbuf_leaf_3_clk/A VGND VGND VPWR VPWR clkload9/A sky130_fd_sc_hd__clkbuf_16
XFILLER_79_482 VGND VGND VPWR VPWR sky130_fd_sc_hd__fill_1
XFILLER_39_346 VGND VGND VPWR VPWR sky130_fd_sc_hd__decap_3
X_6922_ _7291_/CLK _6922_/D VGND VGND VPWR VPWR _6922_/Q sky130_fd_sc_hd__dfxtp_2
XFILLER_35_574 VGND VGND VPWR VPWR sky130_fd_sc_hd__decap_3
X_6853_ _7273_/CLK _6853_/D VGND VGND VPWR VPWR _6853_/Q sky130_fd_sc_hd__dfxtp_2
XFILLER_50_522 VGND VGND VPWR VPWR sky130_fd_sc_hd__fill_2
XFILLER_50_533 VGND VGND VPWR VPWR sky130_fd_sc_hd__decap_3
X_5804_ _6507_/A1 _7017_/Q _6933_/Q _5981_/B2 VGND VGND VPWR VPWR _5804_/X sky130_fd_sc_hd__o22a_2
X_3996_ _7426_/Q _4576_/B1 _3996_/B1 _7330_/Q VGND VGND VPWR VPWR _3998_/B sky130_fd_sc_hd__a22oi_2
XTAP_TAPCELL_ROW_20_436 VGND VPWR sky130_fd_sc_hd__tapvpwrvgnd_1
X_7405_ _7493_/CLK _7405_/D place2043/X VGND VGND VPWR VPWR _7405_/Q sky130_fd_sc_hd__dfrtp_2
X_4617_ _4617_/A0 _5317_/A1 _4672_/S VGND VGND VPWR VPWR _6849_/D sky130_fd_sc_hd__mux2_2
Xplace1130 _4670_/X VGND VGND VPWR VPWR _5698_/A1 sky130_fd_sc_hd__buf_2
Xplace1141 _4751_/Y VGND VGND VPWR VPWR _5661_/A1 sky130_fd_sc_hd__buf_2
Xplace1152 _4663_/X VGND VGND VPWR VPWR _5696_/A1 sky130_fd_sc_hd__buf_2
Xrebuffer2120 _3444_/A VGND VGND VPWR VPWR _3480_/A sky130_fd_sc_hd__buf_2
Xrebuffer2131 _3829_/Y VGND VGND VPWR VPWR _4563_/A3 sky130_fd_sc_hd__buf_2
X_7336_ _7565_/CLK _7336_/D place2015/X VGND VGND VPWR VPWR _7336_/Q sky130_fd_sc_hd__dfrtp_2
X_4548_ _4548_/A _4558_/D VGND VGND VPWR VPWR _4548_/X sky130_fd_sc_hd__xor2_2
XFILLER_1_139 VGND VGND VPWR VPWR sky130_fd_sc_hd__fill_1
XFILLER_8_9 VGND VGND VPWR VPWR sky130_fd_sc_hd__decap_3
Xplace1163 _5698_/S VGND VGND VPWR VPWR _5696_/S sky130_fd_sc_hd__buf_2
Xplace1174 _5028_/S VGND VGND VPWR VPWR _4998_/S sky130_fd_sc_hd__buf_2
Xplace1185 _5363_/S VGND VGND VPWR VPWR _5329_/S sky130_fd_sc_hd__buf_2
Xrebuffer2142 _3628_/X VGND VGND VPWR VPWR _3880_/B1 sky130_fd_sc_hd__buf_2
Xrebuffer2153 _3433_/A VGND VGND VPWR VPWR _4319_/A1 sky130_fd_sc_hd__buf_2
Xrebuffer2164 place1266/A VGND VGND VPWR VPWR _6504_/B2 sky130_fd_sc_hd__buf_2
X_7267_ _7272_/CLK _7267_/D VGND VGND VPWR VPWR _7267_/Q sky130_fd_sc_hd__dfxtp_2
X_4479_ _4478_/X _7597_/D _4559_/A VGND VGND VPWR VPWR _4479_/X sky130_fd_sc_hd__mux2_2
Xplace1196 _5089_/S VGND VGND VPWR VPWR _5057_/S sky130_fd_sc_hd__buf_2
Xrebuffer2175 place1324/X VGND VGND VPWR VPWR _6401_/A1 sky130_fd_sc_hd__buf_2
Xrebuffer2186 _7293_/Q VGND VGND VPWR VPWR _3435_/A2 sky130_fd_sc_hd__buf_2
X_6218_ _6219_/A1 _6220_/A2 _6560_/B _7607_/Q VGND VGND VPWR VPWR _6218_/X sky130_fd_sc_hd__o22a_2
XFILLER_38_24 VGND VGND VPWR VPWR sky130_fd_sc_hd__decap_3
XFILLER_57_110 VGND VGND VPWR VPWR sky130_fd_sc_hd__fill_2
XFILLER_58_611 VGND VGND VPWR VPWR sky130_fd_sc_hd__fill_1
X_7198_ _7407_/CLK _7198_/D VGND VGND VPWR VPWR _7198_/Q sky130_fd_sc_hd__dfxtp_2
XTAP_TAPCELL_ROW_90_1170 VGND VPWR sky130_fd_sc_hd__tapvpwrvgnd_1
XFILLER_18_508 VGND VGND VPWR VPWR sky130_fd_sc_hd__fill_1
XFILLER_57_132 VGND VGND VPWR VPWR sky130_fd_sc_hd__decap_3
X_6149_ _7225_/Q _6154_/A1 _6147_/X _6148_/X VGND VGND VPWR VPWR _6149_/X sky130_fd_sc_hd__o211a_2
XFILLER_57_187 VGND VGND VPWR VPWR sky130_fd_sc_hd__decap_3
XPHY_EDGE_ROW_79_Right_79 VGND VGND VPWR VPWR sky130_fd_sc_hd__decap_3
XTAP_TAPCELL_ROW_56_812 VGND VPWR sky130_fd_sc_hd__tapvpwrvgnd_1
XTAP_TAPCELL_ROW_28_514 VGND VPWR sky130_fd_sc_hd__tapvpwrvgnd_1
XFILLER_26_552 VGND VGND VPWR VPWR sky130_fd_sc_hd__decap_3
XFILLER_13_213 VGND VGND VPWR VPWR sky130_fd_sc_hd__decap_3
XFILLER_41_522 VGND VGND VPWR VPWR sky130_fd_sc_hd__decap_3
XFILLER_41_533 VGND VGND VPWR VPWR sky130_fd_sc_hd__fill_1
XFILLER_13_246 VGND VGND VPWR VPWR sky130_fd_sc_hd__decap_3
XFILLER_41_544 VGND VGND VPWR VPWR sky130_fd_sc_hd__fill_2
XFILLER_41_555 VGND VGND VPWR VPWR sky130_fd_sc_hd__decap_3
XFILLER_41_588 VGND VGND VPWR VPWR sky130_fd_sc_hd__decap_3
XFILLER_21_290 VGND VGND VPWR VPWR sky130_fd_sc_hd__decap_3
XFILLER_70_88 VGND VGND VPWR VPWR sky130_fd_sc_hd__decap_3
XPHY_EDGE_ROW_88_Right_88 VGND VGND VPWR VPWR sky130_fd_sc_hd__decap_3
XFILLER_0_172 VGND VGND VPWR VPWR sky130_fd_sc_hd__decap_3
XFILLER_0_194 VGND VGND VPWR VPWR sky130_fd_sc_hd__fill_2
XFILLER_48_121 VGND VGND VPWR VPWR sky130_fd_sc_hd__decap_3
XPHY_EDGE_ROW_97_Right_97 VGND VGND VPWR VPWR sky130_fd_sc_hd__decap_3
XFILLER_51_308 VGND VGND VPWR VPWR sky130_fd_sc_hd__fill_1
XFILLER_32_555 VGND VGND VPWR VPWR sky130_fd_sc_hd__decap_3
X_3850_ _3850_/A _3850_/B VGND VGND VPWR VPWR _3850_/Y sky130_fd_sc_hd__xnor2_2
X_3781_ _7440_/Q _3793_/A2 _3781_/B1 _7344_/Q _3780_/X VGND VGND VPWR VPWR _3781_/X
+ sky130_fd_sc_hd__a221o_2
X_5520_ _5520_/A0 _5703_/A1 _5532_/S VGND VGND VPWR VPWR _7194_/D sky130_fd_sc_hd__mux2_2
XFILLER_8_261 VGND VGND VPWR VPWR sky130_fd_sc_hd__decap_3
X_4402_ _4436_/A1 _4361_/B _4401_/X VGND VGND VPWR VPWR _4402_/Y sky130_fd_sc_hd__o21ai_2
XFILLER_5_50 VGND VGND VPWR VPWR sky130_fd_sc_hd__decap_3
X_7121_ _7290_/CLK _7121_/D VGND VGND VPWR VPWR _7121_/Q sky130_fd_sc_hd__dfxtp_2
XFILLER_101_505 VGND VGND VPWR VPWR sky130_fd_sc_hd__fill_2
X_7052_ _7276_/CLK _7052_/D VGND VGND VPWR VPWR _7052_/Q sky130_fd_sc_hd__dfxtp_2
XFILLER_39_110 VGND VGND VPWR VPWR sky130_fd_sc_hd__fill_2
X_6003_ _7123_/Q _6173_/A1 _6171_/B1 _7067_/Q VGND VGND VPWR VPWR _6005_/A sky130_fd_sc_hd__o22a_2
X_4195_ _3834_/B _4199_/A2 _4235_/A VGND VGND VPWR VPWR _4195_/Y sky130_fd_sc_hd__a21oi_2
XFILLER_27_305 VGND VGND VPWR VPWR sky130_fd_sc_hd__decap_3
XFILLER_67_485 VGND VGND VPWR VPWR sky130_fd_sc_hd__fill_2
XFILLER_39_187 VGND VGND VPWR VPWR sky130_fd_sc_hd__fill_1
X_6905_ _7241_/CLK _6905_/D VGND VGND VPWR VPWR _6905_/Q sky130_fd_sc_hd__dfxtp_2
XFILLER_24_26 VGND VGND VPWR VPWR sky130_fd_sc_hd__fill_2
XFILLER_35_393 VGND VGND VPWR VPWR sky130_fd_sc_hd__decap_3
XFILLER_50_352 VGND VGND VPWR VPWR sky130_fd_sc_hd__decap_3
X_6836_ _6840_/A _6836_/B VGND VGND VPWR VPWR _7576_/D sky130_fd_sc_hd__and2_2
X_6767_ _6218_/X _7543_/Q _6773_/S VGND VGND VPWR VPWR _7543_/D sky130_fd_sc_hd__mux2_2
XTAP_TAPCELL_ROW_33_572 VGND VPWR sky130_fd_sc_hd__tapvpwrvgnd_1
X_5718_ _5718_/A0 _5718_/A1 _5728_/S VGND VGND VPWR VPWR _7285_/D sky130_fd_sc_hd__mux2_2
X_3979_ _6308_/B2 _3567_/A _4312_/B _7550_/Q VGND VGND VPWR VPWR _3980_/C sky130_fd_sc_hd__a22oi_2
XFILLER_6_209 VGND VGND VPWR VPWR sky130_fd_sc_hd__decap_3
X_6698_ _6698_/A0 _6217_/X _6698_/S VGND VGND VPWR VPWR _7510_/D sky130_fd_sc_hd__mux2_2
XTAP_TAPCELL_ROW_79_1054 VGND VPWR sky130_fd_sc_hd__tapvpwrvgnd_1
X_7319_ _7608_/CLK _7319_/D place2049/X VGND VGND VPWR VPWR _7319_/Q sky130_fd_sc_hd__dfrtp_2
XFILLER_85_260 VGND VGND VPWR VPWR sky130_fd_sc_hd__decap_3
XTAP_TAPCELL_ROW_5_275 VGND VPWR sky130_fd_sc_hd__tapvpwrvgnd_1
XFILLER_45_113 VGND VGND VPWR VPWR sky130_fd_sc_hd__decap_3
XFILLER_26_371 VGND VGND VPWR VPWR sky130_fd_sc_hd__decap_3
XFILLER_45_179 VGND VGND VPWR VPWR sky130_fd_sc_hd__decap_3
XFILLER_14_533 VGND VGND VPWR VPWR sky130_fd_sc_hd__decap_3
XFILLER_41_363 VGND VGND VPWR VPWR sky130_fd_sc_hd__decap_3
XFILLER_30_91 VGND VGND VPWR VPWR sky130_fd_sc_hd__fill_2
XFILLER_5_275 VGND VGND VPWR VPWR sky130_fd_sc_hd__fill_1
XFILLER_39_6 VGND VGND VPWR VPWR sky130_fd_sc_hd__fill_2
XFILLER_96_536 VGND VGND VPWR VPWR sky130_fd_sc_hd__fill_1
XTAP_TAPCELL_ROW_67_929 VGND VPWR sky130_fd_sc_hd__tapvpwrvgnd_1
XFILLER_32_341 VGND VGND VPWR VPWR sky130_fd_sc_hd__decap_3
X_3902_ _7525_/Q _3909_/A2 _3986_/B2 _7461_/Q VGND VGND VPWR VPWR _3902_/X sky130_fd_sc_hd__a22o_2
XFILLER_32_363 VGND VGND VPWR VPWR sky130_fd_sc_hd__fill_1
XFILLER_32_374 VGND VGND VPWR VPWR sky130_fd_sc_hd__decap_3
X_3833_ _3833_/A _3833_/B VGND VGND VPWR VPWR _4197_/B sky130_fd_sc_hd__or2_4
XFILLER_20_536 VGND VGND VPWR VPWR sky130_fd_sc_hd__decap_3
XTAP_TAPCELL_ROW_30_542 VGND VPWR sky130_fd_sc_hd__tapvpwrvgnd_1
X_6483_ _6483_/A1 _7043_/Q _6847_/Q _6483_/B2 VGND VGND VPWR VPWR _6483_/X sky130_fd_sc_hd__o22a_2
X_5503_ _5503_/A0 _5564_/A1 _5513_/S VGND VGND VPWR VPWR _7186_/D sky130_fd_sc_hd__mux2_2
X_3695_ _3695_/A _3695_/B VGND VGND VPWR VPWR _3696_/B sky130_fd_sc_hd__nand2_2
XFILLER_99_330 VGND VGND VPWR VPWR sky130_fd_sc_hd__decap_3
X_7104_ _7247_/CLK _7104_/D VGND VGND VPWR VPWR _7104_/Q sky130_fd_sc_hd__dfxtp_2
X_5365_ _4904_/B _4904_/C _4778_/A VGND VGND VPWR VPWR _5549_/C sky130_fd_sc_hd__a21oi_2
X_5296_ _5296_/A0 _5296_/A1 _5299_/S VGND VGND VPWR VPWR _7093_/D sky130_fd_sc_hd__mux2_2
X_4316_ _4348_/C _5843_/B _4314_/Y _4315_/X VGND VGND VPWR VPWR _4317_/B sky130_fd_sc_hd__o22a_2
XFILLER_59_249 VGND VGND VPWR VPWR sky130_fd_sc_hd__fill_1
X_7035_ _7291_/CLK _7035_/D VGND VGND VPWR VPWR _7035_/Q sky130_fd_sc_hd__dfxtp_2
X_4247_ _4253_/A _4247_/B _4247_/C VGND VGND VPWR VPWR _4247_/Y sky130_fd_sc_hd__nor3_2
X_4178_ _3887_/C _4178_/A2 _4176_/X _4177_/Y VGND VGND VPWR VPWR _4178_/X sky130_fd_sc_hd__o211a_2
XFILLER_27_113 VGND VGND VPWR VPWR sky130_fd_sc_hd__fill_2
XTAP_TAPCELL_ROW_38_620 VGND VPWR sky130_fd_sc_hd__tapvpwrvgnd_1
XTAP_TAPCELL_ROW_2_245 VGND VPWR sky130_fd_sc_hd__tapvpwrvgnd_1
XFILLER_55_455 VGND VGND VPWR VPWR sky130_fd_sc_hd__decap_3
XFILLER_55_499 VGND VGND VPWR VPWR sky130_fd_sc_hd__decap_3
XFILLER_23_341 VGND VGND VPWR VPWR sky130_fd_sc_hd__fill_1
XFILLER_35_190 VGND VGND VPWR VPWR sky130_fd_sc_hd__decap_3
XFILLER_42_138 VGND VGND VPWR VPWR sky130_fd_sc_hd__fill_2
XFILLER_50_160 VGND VGND VPWR VPWR sky130_fd_sc_hd__decap_3
XFILLER_50_193 VGND VGND VPWR VPWR sky130_fd_sc_hd__decap_3
XFILLER_51_57 VGND VGND VPWR VPWR sky130_fd_sc_hd__fill_1
XFILLER_2_223 VGND VGND VPWR VPWR sky130_fd_sc_hd__decap_3
XFILLER_4_3 VGND VGND VPWR VPWR sky130_fd_sc_hd__decap_3
XFILLER_76_32 VGND VGND VPWR VPWR sky130_fd_sc_hd__fill_1
XFILLER_93_517 VGND VGND VPWR VPWR sky130_fd_sc_hd__fill_1
XFILLER_18_124 VGND VGND VPWR VPWR sky130_fd_sc_hd__decap_3
XFILLER_46_433 VGND VGND VPWR VPWR sky130_fd_sc_hd__fill_2
XFILLER_58_282 VGND VGND VPWR VPWR sky130_fd_sc_hd__fill_2
XFILLER_46_444 VGND VGND VPWR VPWR sky130_fd_sc_hd__decap_3
XFILLER_73_252 VGND VGND VPWR VPWR sky130_fd_sc_hd__fill_2
XFILLER_73_274 VGND VGND VPWR VPWR sky130_fd_sc_hd__decap_3
XFILLER_61_447 VGND VGND VPWR VPWR sky130_fd_sc_hd__fill_1
XFILLER_92_75 VGND VGND VPWR VPWR sky130_fd_sc_hd__fill_1
XTAP_TAPCELL_ROW_72_976 VGND VPWR sky130_fd_sc_hd__tapvpwrvgnd_1
XTAP_TAPCELL_ROW_44_689 VGND VPWR sky130_fd_sc_hd__tapvpwrvgnd_1
Xplace1707 _3544_/C VGND VGND VPWR VPWR _3984_/A3 sky130_fd_sc_hd__buf_2
Xplace1718 _3893_/A2 VGND VGND VPWR VPWR _3812_/A2 sky130_fd_sc_hd__buf_4
X_3480_ _3480_/A _3480_/B VGND VGND VPWR VPWR _3480_/Y sky130_fd_sc_hd__nor2_2
XFILLER_6_573 VGND VGND VPWR VPWR sky130_fd_sc_hd__decap_3
Xplace1729 _3920_/B VGND VGND VPWR VPWR _5850_/B sky130_fd_sc_hd__buf_4
XFILLER_69_514 VGND VGND VPWR VPWR sky130_fd_sc_hd__decap_3
Xhold2409 _7156_/Q VGND VGND VPWR VPWR _5437_/A0 sky130_fd_sc_hd__dlygate4sd3_1
X_5150_ _5150_/A0 _4769_/Y _5152_/S VGND VGND VPWR VPWR _7038_/D sky130_fd_sc_hd__mux2_2
X_5081_ _5081_/A0 _4745_/Y _5089_/S VGND VGND VPWR VPWR _7006_/D sky130_fd_sc_hd__mux2_2
X_4101_ _3957_/B _4101_/A2 _3956_/Y VGND VGND VPWR VPWR _4101_/X sky130_fd_sc_hd__o21a_2
XFILLER_84_517 VGND VGND VPWR VPWR sky130_fd_sc_hd__decap_3
XFILLER_84_528 VGND VGND VPWR VPWR sky130_fd_sc_hd__decap_3
X_4032_ _4361_/A _4028_/B _4028_/C _4036_/A VGND VGND VPWR VPWR _4033_/B sky130_fd_sc_hd__a31o_2
XFILLER_37_411 VGND VGND VPWR VPWR sky130_fd_sc_hd__decap_3
XFILLER_37_433 VGND VGND VPWR VPWR sky130_fd_sc_hd__decap_3
XFILLER_64_230 VGND VGND VPWR VPWR sky130_fd_sc_hd__fill_2
X_5983_ _5983_/A VGND VGND VPWR VPWR _6082_/B sky130_fd_sc_hd__inv_2
XFILLER_24_138 VGND VGND VPWR VPWR sky130_fd_sc_hd__fill_2
XANTENNA_12 rst VGND VGND VPWR VPWR sky130_fd_sc_hd__diode_2
XANTENNA_23 _7114_/Q VGND VGND VPWR VPWR sky130_fd_sc_hd__diode_2
XFILLER_20_333 VGND VGND VPWR VPWR sky130_fd_sc_hd__decap_3
XTAP_TAPCELL_ROW_15_380 VGND VPWR sky130_fd_sc_hd__tapvpwrvgnd_1
XANTENNA_34 _5127_/A0 VGND VGND VPWR VPWR sky130_fd_sc_hd__diode_2
XANTENNA_45 _6857_/Q VGND VGND VPWR VPWR sky130_fd_sc_hd__diode_2
XANTENNA_56 _5342_/A0 VGND VGND VPWR VPWR sky130_fd_sc_hd__diode_2
X_7584_ clkload2/A _7584_/D place2029/X VGND VGND VPWR VPWR _7584_/Q sky130_fd_sc_hd__dfrtp_2
X_4796_ _4796_/A0 _5686_/A1 _4806_/S VGND VGND VPWR VPWR _6878_/D sky130_fd_sc_hd__mux2_2
X_3816_ _7438_/Q _3913_/A2 _3816_/B1 _7342_/Q _3815_/X VGND VGND VPWR VPWR _3816_/X
+ sky130_fd_sc_hd__a221o_2
X_6535_ _7438_/Q _6128_/X _6541_/S VGND VGND VPWR VPWR _7438_/D sky130_fd_sc_hd__mux2_2
X_3747_ _3995_/A1 _3898_/A2 _7377_/Q _3936_/B1 _7569_/Q VGND VGND VPWR VPWR _3747_/X
+ sky130_fd_sc_hd__a32o_2
XFILLER_21_49 VGND VGND VPWR VPWR sky130_fd_sc_hd__decap_3
XTAP_TAPCELL_ROW_76_1024 VGND VPWR sky130_fd_sc_hd__tapvpwrvgnd_1
X_6466_ _6883_/Q _6502_/A2 _6464_/X _6465_/X VGND VGND VPWR VPWR _6466_/X sky130_fd_sc_hd__o211a_2
X_3678_ _7510_/Q _3725_/A2 _3769_/B1 _7478_/Q VGND VGND VPWR VPWR _3680_/B sky130_fd_sc_hd__a22oi_2
X_6397_ _6397_/A1 _7008_/Q _6980_/Q _6397_/B2 VGND VGND VPWR VPWR _6397_/X sky130_fd_sc_hd__o22a_2
X_5417_ _5417_/A0 _5600_/A1 _5423_/S VGND VGND VPWR VPWR _7147_/D sky130_fd_sc_hd__mux2_2
XFILLER_102_611 VGND VGND VPWR VPWR sky130_fd_sc_hd__fill_1
X_5348_ _5348_/A0 _5593_/A1 _5363_/S VGND VGND VPWR VPWR _7116_/D sky130_fd_sc_hd__mux2_2
Xhold2910 _7477_/Q VGND VGND VPWR VPWR _6628_/A0 sky130_fd_sc_hd__dlygate4sd3_1
Xhold2921 _7529_/Q VGND VGND VPWR VPWR _6737_/A1 sky130_fd_sc_hd__dlygate4sd3_1
Xhold2932 _7546_/Q VGND VGND VPWR VPWR _6773_/A1 sky130_fd_sc_hd__dlygate4sd3_1
XFILLER_87_366 VGND VGND VPWR VPWR sky130_fd_sc_hd__fill_1
Xhold2943 _6371_/X VGND VGND VPWR VPWR _7401_/D sky130_fd_sc_hd__dlygate4sd3_1
Xhold2954 _7364_/Q VGND VGND VPWR VPWR _6317_/B2 sky130_fd_sc_hd__dlygate4sd3_1
Xhold2965 _6386_/X VGND VGND VPWR VPWR _7412_/D sky130_fd_sc_hd__dlygate4sd3_1
X_7018_ _7243_/CLK _7018_/D VGND VGND VPWR VPWR _7018_/Q sky130_fd_sc_hd__dfxtp_2
XFILLER_28_433 VGND VGND VPWR VPWR sky130_fd_sc_hd__decap_3
Xhold2976 _7491_/Q VGND VGND VPWR VPWR _6658_/A0 sky130_fd_sc_hd__dlygate4sd3_1
Xhold2987 _7464_/Q VGND VGND VPWR VPWR _6600_/A0 sky130_fd_sc_hd__dlygate4sd3_1
Xhold2998 _7444_/Q VGND VGND VPWR VPWR _6551_/A0 sky130_fd_sc_hd__dlygate4sd3_1
XFILLER_28_466 VGND VGND VPWR VPWR sky130_fd_sc_hd__decap_3
XFILLER_15_116 VGND VGND VPWR VPWR sky130_fd_sc_hd__fill_2
XFILLER_28_477 VGND VGND VPWR VPWR sky130_fd_sc_hd__decap_3
XFILLER_102_41 VGND VGND VPWR VPWR sky130_fd_sc_hd__decap_3
XFILLER_43_447 VGND VGND VPWR VPWR sky130_fd_sc_hd__fill_1
XFILLER_23_182 VGND VGND VPWR VPWR sky130_fd_sc_hd__decap_3
XFILLER_70_288 VGND VGND VPWR VPWR sky130_fd_sc_hd__decap_3
XFILLER_23_193 VGND VGND VPWR VPWR sky130_fd_sc_hd__decap_3
XFILLER_11_60 VGND VGND VPWR VPWR sky130_fd_sc_hd__decap_3
XFILLER_98_609 VGND VGND VPWR VPWR sky130_fd_sc_hd__decap_3
XFILLER_78_344 VGND VGND VPWR VPWR sky130_fd_sc_hd__fill_2
XFILLER_23_9 VGND VGND VPWR VPWR sky130_fd_sc_hd__decap_3
XFILLER_78_355 VGND VGND VPWR VPWR sky130_fd_sc_hd__fill_1
XFILLER_78_388 VGND VGND VPWR VPWR sky130_fd_sc_hd__fill_2
XTAP_TAPCELL_ROW_49_737 VGND VPWR sky130_fd_sc_hd__tapvpwrvgnd_1
XFILLER_19_444 VGND VGND VPWR VPWR sky130_fd_sc_hd__decap_3
XFILLER_19_477 VGND VGND VPWR VPWR sky130_fd_sc_hd__decap_3
XFILLER_34_403 VGND VGND VPWR VPWR sky130_fd_sc_hd__decap_3
XFILLER_46_296 VGND VGND VPWR VPWR sky130_fd_sc_hd__decap_3
XFILLER_61_222 VGND VGND VPWR VPWR sky130_fd_sc_hd__fill_2
XFILLER_22_609 VGND VGND VPWR VPWR sky130_fd_sc_hd__decap_3
XFILLER_21_119 VGND VGND VPWR VPWR sky130_fd_sc_hd__fill_1
XFILLER_61_288 VGND VGND VPWR VPWR sky130_fd_sc_hd__decap_3
XFILLER_61_299 VGND VGND VPWR VPWR sky130_fd_sc_hd__decap_3
XFILLER_14_193 VGND VGND VPWR VPWR sky130_fd_sc_hd__decap_3
X_4650_ _6321_/B2 _6178_/A1 _6178_/A3 _4649_/X VGND VGND VPWR VPWR _4650_/X sky130_fd_sc_hd__a31o_2
XTAP_TAPCELL_ROW_12_350 VGND VPWR sky130_fd_sc_hd__tapvpwrvgnd_1
X_6320_ _7399_/Q _6324_/A2 _6322_/A3 _6324_/B1 _6320_/B2 VGND VGND VPWR VPWR _6320_/X
+ sky130_fd_sc_hd__a32o_2
Xplace1504 _3832_/B VGND VGND VPWR VPWR _4684_/A1 sky130_fd_sc_hd__buf_2
Xplace1515 _3767_/Y VGND VGND VPWR VPWR _4237_/B sky130_fd_sc_hd__buf_2
Xplace1526 _3667_/B1 VGND VGND VPWR VPWR _4568_/D sky130_fd_sc_hd__buf_2
X_3532_ _7484_/Q _6363_/A2 _6363_/A3 _3531_/Y VGND VGND VPWR VPWR _3538_/A sky130_fd_sc_hd__a31oi_2
XFILLER_6_392 VGND VGND VPWR VPWR sky130_fd_sc_hd__decap_3
Xplace1537 _6565_/B VGND VGND VPWR VPWR _6220_/B1 sky130_fd_sc_hd__buf_2
Xplace1548 _3987_/Y VGND VGND VPWR VPWR _4396_/B sky130_fd_sc_hd__buf_2
Xplace1559 _3951_/Y VGND VGND VPWR VPWR _3957_/A sky130_fd_sc_hd__buf_2
X_3463_ _3463_/A _3463_/B _3463_/C _3491_/B VGND VGND VPWR VPWR _3463_/X sky130_fd_sc_hd__and4_2
XFILLER_88_119 VGND VGND VPWR VPWR sky130_fd_sc_hd__fill_2
X_6182_ _6559_/A1 _6182_/A2 _6185_/B1 _7603_/Q VGND VGND VPWR VPWR _6182_/X sky130_fd_sc_hd__o22a_2
X_5133_ _5133_/A0 _5344_/A1 _5146_/S VGND VGND VPWR VPWR _7030_/D sky130_fd_sc_hd__mux2_2
XFILLER_29_208 VGND VGND VPWR VPWR sky130_fd_sc_hd__decap_3
XFILLER_96_141 VGND VGND VPWR VPWR sky130_fd_sc_hd__fill_1
X_5064_ _5064_/A0 _5336_/A1 _5085_/S VGND VGND VPWR VPWR _6998_/D sky130_fd_sc_hd__mux2_2
X_4015_ _4110_/A _4110_/B _4014_/X VGND VGND VPWR VPWR _4015_/X sky130_fd_sc_hd__a21o_2
XFILLER_25_425 VGND VGND VPWR VPWR sky130_fd_sc_hd__decap_3
XFILLER_52_244 VGND VGND VPWR VPWR sky130_fd_sc_hd__decap_3
XFILLER_80_531 VGND VGND VPWR VPWR sky130_fd_sc_hd__fill_1
XFILLER_25_469 VGND VGND VPWR VPWR sky130_fd_sc_hd__decap_3
XFILLER_33_491 VGND VGND VPWR VPWR sky130_fd_sc_hd__decap_3
X_5897_ _7226_/Q _6154_/A1 _5895_/X _5896_/X VGND VGND VPWR VPWR _5897_/X sky130_fd_sc_hd__o211a_2
XTAP_TAPCELL_ROW_82_1083 VGND VPWR sky130_fd_sc_hd__tapvpwrvgnd_1
XFILLER_20_141 VGND VGND VPWR VPWR sky130_fd_sc_hd__decap_3
XFILLER_20_163 VGND VGND VPWR VPWR sky130_fd_sc_hd__decap_3
XFILLER_32_48 VGND VGND VPWR VPWR sky130_fd_sc_hd__decap_3
XFILLER_4_307 VGND VGND VPWR VPWR sky130_fd_sc_hd__fill_1
X_7567_ _7579_/CLK _7567_/D place2012/X VGND VGND VPWR VPWR _7567_/Q sky130_fd_sc_hd__dfrtp_2
X_7498_ _7611_/CLK _7498_/D place2059/X VGND VGND VPWR VPWR _7498_/Q sky130_fd_sc_hd__dfrtp_2
X_6518_ _6518_/A0 _6040_/X _6518_/S VGND VGND VPWR VPWR _7430_/D sky130_fd_sc_hd__mux2_2
X_6449_ _7206_/Q _6449_/A2 _6449_/B1 _7234_/Q _6448_/X VGND VGND VPWR VPWR _6449_/X
+ sky130_fd_sc_hd__o221a_2
Xoutput2070 _4020_/Y VGND VGND VPWR VPWR result[0] sky130_fd_sc_hd__clkdlybuf4s25_1
Xoutput2081 _3585_/Y VGND VGND VPWR VPWR result[1] sky130_fd_sc_hd__clkdlybuf4s25_1
XFILLER_0_524 VGND VGND VPWR VPWR sky130_fd_sc_hd__decap_3
Xoutput2092 _4842_/A VGND VGND VPWR VPWR result[2] sky130_fd_sc_hd__clkdlybuf4s25_1
XFILLER_0_579 VGND VGND VPWR VPWR sky130_fd_sc_hd__fill_1
Xhold2740 _7208_/Q VGND VGND VPWR VPWR _5551_/A0 sky130_fd_sc_hd__dlygate4sd3_1
XFILLER_87_196 VGND VGND VPWR VPWR sky130_fd_sc_hd__fill_1
Xhold2751 _6890_/Q VGND VGND VPWR VPWR _4821_/A0 sky130_fd_sc_hd__dlygate4sd3_1
Xhold2762 _7081_/Q VGND VGND VPWR VPWR _5259_/A0 sky130_fd_sc_hd__dlygate4sd3_1
Xhold2773 _7197_/Q VGND VGND VPWR VPWR _5526_/A0 sky130_fd_sc_hd__dlygate4sd3_1
Xhold2784 _7263_/Q VGND VGND VPWR VPWR _5669_/A0 sky130_fd_sc_hd__dlygate4sd3_1
Xhold2795 _6976_/Q VGND VGND VPWR VPWR _5015_/A0 sky130_fd_sc_hd__dlygate4sd3_1
XTAP_TAPCELL_ROW_46_707 VGND VPWR sky130_fd_sc_hd__tapvpwrvgnd_1
XFILLER_28_274 VGND VGND VPWR VPWR sky130_fd_sc_hd__decap_3
XFILLER_90_306 VGND VGND VPWR VPWR sky130_fd_sc_hd__fill_2
XTAP_TAPCELL_ROW_18_409 VGND VPWR sky130_fd_sc_hd__tapvpwrvgnd_1
XFILLER_43_222 VGND VGND VPWR VPWR sky130_fd_sc_hd__fill_2
XFILLER_31_406 VGND VGND VPWR VPWR sky130_fd_sc_hd__decap_3
XFILLER_43_255 VGND VGND VPWR VPWR sky130_fd_sc_hd__decap_3
XFILLER_43_299 VGND VGND VPWR VPWR sky130_fd_sc_hd__fill_2
XTAP_TAPCELL_ROW_54_795 VGND VPWR sky130_fd_sc_hd__tapvpwrvgnd_1
XTAP_TAPCELL_ROW_26_497 VGND VPWR sky130_fd_sc_hd__tapvpwrvgnd_1
XFILLER_11_163 VGND VGND VPWR VPWR sky130_fd_sc_hd__decap_3
XFILLER_7_134 VGND VGND VPWR VPWR sky130_fd_sc_hd__decap_3
XFILLER_7_178 VGND VGND VPWR VPWR sky130_fd_sc_hd__decap_3
XFILLER_3_340 VGND VGND VPWR VPWR sky130_fd_sc_hd__decap_3
XFILLER_98_417 VGND VGND VPWR VPWR sky130_fd_sc_hd__decap_3
XFILLER_19_296 VGND VGND VPWR VPWR sky130_fd_sc_hd__fill_2
XFILLER_62_520 VGND VGND VPWR VPWR sky130_fd_sc_hd__decap_3
X_5820_ _5820_/A _5820_/B _5820_/C _5820_/D VGND VGND VPWR VPWR _5820_/X sky130_fd_sc_hd__or4_4
XFILLER_22_439 VGND VGND VPWR VPWR sky130_fd_sc_hd__decap_3
XFILLER_34_288 VGND VGND VPWR VPWR sky130_fd_sc_hd__decap_3
X_4702_ _4702_/A0 _5190_/A1 _4759_/S VGND VGND VPWR VPWR _6860_/D sky130_fd_sc_hd__mux2_2
XFILLER_30_461 VGND VGND VPWR VPWR sky130_fd_sc_hd__decap_3
XFILLER_30_483 VGND VGND VPWR VPWR sky130_fd_sc_hd__decap_3
X_7421_ clkload2/A _7421_/D place2028/X VGND VGND VPWR VPWR _7421_/Q sky130_fd_sc_hd__dfrtp_2
XFILLER_8_61 VGND VGND VPWR VPWR sky130_fd_sc_hd__fill_2
Xplace2002 _7292_/Q VGND VGND VPWR VPWR _3433_/A sky130_fd_sc_hd__buf_6
X_4633_ _4633_/A0 _5566_/A1 _4672_/S VGND VGND VPWR VPWR _6851_/D sky130_fd_sc_hd__mux2_2
Xplace1301 _4970_/D VGND VGND VPWR VPWR _6064_/C1 sky130_fd_sc_hd__buf_2
Xplace2046 place2069/A VGND VGND VPWR VPWR place2046/X sky130_fd_sc_hd__buf_2
Xplace2035 place2046/X VGND VGND VPWR VPWR place2035/X sky130_fd_sc_hd__buf_2
Xplace2024 place2025/X VGND VGND VPWR VPWR place2024/X sky130_fd_sc_hd__buf_2
Xplace2013 place2046/X VGND VGND VPWR VPWR place2013/X sky130_fd_sc_hd__buf_2
X_7352_ _7579_/CLK _7352_/D place2012/X VGND VGND VPWR VPWR _7352_/Q sky130_fd_sc_hd__dfrtp_2
X_4564_ _4564_/A _4564_/B VGND VGND VPWR VPWR _4564_/Y sky130_fd_sc_hd__nor2_2
Xplace1312 _4018_/B VGND VGND VPWR VPWR _4306_/B sky130_fd_sc_hd__buf_2
Xplace1323 place1324/X VGND VGND VPWR VPWR _6136_/A2 sky130_fd_sc_hd__buf_8
Xplace1334 _5797_/A1 VGND VGND VPWR VPWR _6448_/A1 sky130_fd_sc_hd__buf_2
Xplace2068 place2069/X VGND VGND VPWR VPWR place2068/X sky130_fd_sc_hd__buf_2
Xplace2057 place2066/X VGND VGND VPWR VPWR place2057/X sky130_fd_sc_hd__buf_2
X_7283_ _7577_/CLK _7283_/D VGND VGND VPWR VPWR _7283_/Q sky130_fd_sc_hd__dfxtp_2
X_3515_ _3509_/Y _3536_/D _3628_/B1 VGND VGND VPWR VPWR _3515_/Y sky130_fd_sc_hd__o21ai_4
Xplace1345 _5746_/X VGND VGND VPWR VPWR _6483_/A1 sky130_fd_sc_hd__buf_2
Xplace1356 _4122_/Y VGND VGND VPWR VPWR _4842_/B sky130_fd_sc_hd__buf_2
Xplace1367 _3944_/Y VGND VGND VPWR VPWR _4138_/A1 sky130_fd_sc_hd__buf_2
X_4495_ _4495_/A _7308_/Q _7309_/Q VGND VGND VPWR VPWR _4495_/X sky130_fd_sc_hd__and3_2
Xplace1378 _4236_/B VGND VGND VPWR VPWR _4238_/A sky130_fd_sc_hd__buf_2
Xplace1389 _4247_/Y VGND VGND VPWR VPWR _4248_/C1 sky130_fd_sc_hd__buf_2
X_3446_ _3446_/A _3446_/B _3508_/C VGND VGND VPWR VPWR _3508_/A sky130_fd_sc_hd__nand3_4
XFILLER_97_461 VGND VGND VPWR VPWR sky130_fd_sc_hd__fill_2
X_6165_ _6165_/A1 _7059_/Q _6863_/Q _6165_/B2 VGND VGND VPWR VPWR _6165_/X sky130_fd_sc_hd__o22a_2
X_5116_ _5116_/A0 _5694_/A1 _5118_/S VGND VGND VPWR VPWR _7022_/D sky130_fd_sc_hd__mux2_2
X_5047_ _5047_/A0 _5686_/A1 _5057_/S VGND VGND VPWR VPWR _6990_/D sky130_fd_sc_hd__mux2_2
XFILLER_27_37 VGND VGND VPWR VPWR sky130_fd_sc_hd__decap_3
XFILLER_72_317 VGND VGND VPWR VPWR sky130_fd_sc_hd__decap_3
XFILLER_84_177 VGND VGND VPWR VPWR sky130_fd_sc_hd__fill_2
XTAP_TAPCELL_ROW_84_1101 VGND VPWR sky130_fd_sc_hd__tapvpwrvgnd_1
XFILLER_25_211 VGND VGND VPWR VPWR sky130_fd_sc_hd__decap_3
XFILLER_72_339 VGND VGND VPWR VPWR sky130_fd_sc_hd__fill_1
X_6998_ _7279_/CLK _6998_/D VGND VGND VPWR VPWR _6998_/Q sky130_fd_sc_hd__dfxtp_2
XFILLER_25_277 VGND VGND VPWR VPWR sky130_fd_sc_hd__decap_3
X_5949_ _6904_/Q _6504_/B2 _5959_/A1 _7268_/Q VGND VGND VPWR VPWR _5949_/X sky130_fd_sc_hd__o22a_2
XFILLER_40_247 VGND VGND VPWR VPWR sky130_fd_sc_hd__fill_1
XTAP_TAPCELL_ROW_51_754 VGND VPWR sky130_fd_sc_hd__tapvpwrvgnd_1
XTAP_TAPCELL_ROW_23_467 VGND VPWR sky130_fd_sc_hd__tapvpwrvgnd_1
XFILLER_21_483 VGND VGND VPWR VPWR sky130_fd_sc_hd__fill_1
XFILLER_21_494 VGND VGND VPWR VPWR sky130_fd_sc_hd__decap_3
XFILLER_4_115 VGND VGND VPWR VPWR sky130_fd_sc_hd__decap_3
XFILLER_4_126 VGND VGND VPWR VPWR sky130_fd_sc_hd__decap_3
XFILLER_0_321 VGND VGND VPWR VPWR sky130_fd_sc_hd__decap_3
XFILLER_68_33 VGND VGND VPWR VPWR sky130_fd_sc_hd__fill_1
Xplace1890 _3475_/B VGND VGND VPWR VPWR _4022_/B sky130_fd_sc_hd__buf_2
XFILLER_0_343 VGND VGND VPWR VPWR sky130_fd_sc_hd__decap_3
XFILLER_0_365 VGND VGND VPWR VPWR sky130_fd_sc_hd__fill_1
XFILLER_0_387 VGND VGND VPWR VPWR sky130_fd_sc_hd__decap_3
XFILLER_75_100 VGND VGND VPWR VPWR sky130_fd_sc_hd__decap_3
XFILLER_48_336 VGND VGND VPWR VPWR sky130_fd_sc_hd__fill_2
Xhold2592 _7024_/Q VGND VGND VPWR VPWR _5120_/A0 sky130_fd_sc_hd__dlygate4sd3_1
Xhold2581 _7129_/Q VGND VGND VPWR VPWR _5379_/A0 sky130_fd_sc_hd__dlygate4sd3_1
Xhold2570 _7041_/Q VGND VGND VPWR VPWR _5158_/A0 sky130_fd_sc_hd__dlygate4sd3_1
XTAP_TAPCELL_ROW_59_843 VGND VPWR sky130_fd_sc_hd__tapvpwrvgnd_1
XFILLER_29_550 VGND VGND VPWR VPWR sky130_fd_sc_hd__decap_3
XFILLER_29_561 VGND VGND VPWR VPWR sky130_fd_sc_hd__fill_2
XFILLER_16_200 VGND VGND VPWR VPWR sky130_fd_sc_hd__decap_3
XFILLER_44_531 VGND VGND VPWR VPWR sky130_fd_sc_hd__fill_1
XFILLER_44_542 VGND VGND VPWR VPWR sky130_fd_sc_hd__decap_3
XFILLER_17_70 VGND VGND VPWR VPWR sky130_fd_sc_hd__decap_3
XFILLER_31_225 VGND VGND VPWR VPWR sky130_fd_sc_hd__decap_3
XFILLER_31_258 VGND VGND VPWR VPWR sky130_fd_sc_hd__decap_3
XFILLER_8_421 VGND VGND VPWR VPWR sky130_fd_sc_hd__fill_2
XTAP_TAPCELL_ROW_100_1278 VGND VPWR sky130_fd_sc_hd__tapvpwrvgnd_1
X_4280_ _4297_/A _4280_/A2 _4283_/D _4280_/B1 _4277_/Y VGND VGND VPWR VPWR _4285_/C
+ sky130_fd_sc_hd__o311ai_2
XFILLER_39_314 VGND VGND VPWR VPWR sky130_fd_sc_hd__fill_2
XFILLER_39_325 VGND VGND VPWR VPWR sky130_fd_sc_hd__decap_3
XFILLER_27_509 VGND VGND VPWR VPWR sky130_fd_sc_hd__decap_3
XFILLER_66_144 VGND VGND VPWR VPWR sky130_fd_sc_hd__fill_2
XFILLER_54_328 VGND VGND VPWR VPWR sky130_fd_sc_hd__fill_1
XFILLER_66_155 VGND VGND VPWR VPWR sky130_fd_sc_hd__decap_3
XFILLER_94_486 VGND VGND VPWR VPWR sky130_fd_sc_hd__fill_1
X_6921_ _7290_/CLK _6921_/D VGND VGND VPWR VPWR _6921_/Q sky130_fd_sc_hd__dfxtp_2
X_6852_ _7247_/CLK _6852_/D VGND VGND VPWR VPWR _6852_/Q sky130_fd_sc_hd__dfxtp_2
X_5803_ _6048_/A _5803_/B VGND VGND VPWR VPWR _5807_/C sky130_fd_sc_hd__nor2_2
XFILLER_50_545 VGND VGND VPWR VPWR sky130_fd_sc_hd__decap_3
X_6783_ _6789_/A _6783_/B VGND VGND VPWR VPWR _7550_/D sky130_fd_sc_hd__and2_2
X_3995_ _3995_/A1 _3842_/B _7362_/Q _4395_/A1 _7554_/Q VGND VGND VPWR VPWR _3995_/X
+ sky130_fd_sc_hd__a32o_2
XFILLER_50_578 VGND VGND VPWR VPWR sky130_fd_sc_hd__fill_1
X_5734_ _5734_/A _5843_/B VGND VGND VPWR VPWR _5734_/Y sky130_fd_sc_hd__nor2_2
XFILLER_30_280 VGND VGND VPWR VPWR sky130_fd_sc_hd__decap_3
X_5665_ _5665_/A0 _4763_/Y _5669_/S VGND VGND VPWR VPWR _7261_/D sky130_fd_sc_hd__mux2_2
XTAP_TAPCELL_ROW_20_437 VGND VPWR sky130_fd_sc_hd__tapvpwrvgnd_1
X_7404_ clkload3/A _7404_/D place2057/X VGND VGND VPWR VPWR _7404_/Q sky130_fd_sc_hd__dfrtp_2
X_7335_ _7493_/CLK _7335_/D place2014/X VGND VGND VPWR VPWR _7335_/Q sky130_fd_sc_hd__dfrtp_2
X_5596_ _5596_/A0 _5718_/A1 _5606_/S VGND VGND VPWR VPWR _7229_/D sky130_fd_sc_hd__mux2_2
Xplace1120 _4714_/X VGND VGND VPWR VPWR _5344_/A1 sky130_fd_sc_hd__buf_2
Xplace1131 _5572_/A1 VGND VGND VPWR VPWR _5694_/A1 sky130_fd_sc_hd__buf_2
Xplace1142 _5570_/A1 VGND VGND VPWR VPWR _5692_/A1 sky130_fd_sc_hd__buf_2
Xrebuffer2121 _5755_/C1 VGND VGND VPWR VPWR _4780_/C sky130_fd_sc_hd__buf_4
Xplace1153 _4663_/X VGND VGND VPWR VPWR _5635_/A1 sky130_fd_sc_hd__buf_2
Xplace1164 _5728_/S VGND VGND VPWR VPWR _5698_/S sky130_fd_sc_hd__buf_2
Xplace1175 _5030_/S VGND VGND VPWR VPWR _5028_/S sky130_fd_sc_hd__buf_2
Xplace1186 _5363_/S VGND VGND VPWR VPWR _5357_/S sky130_fd_sc_hd__buf_2
Xrebuffer2132 _4193_/Y VGND VGND VPWR VPWR _4194_/B sky130_fd_sc_hd__buf_2
Xrebuffer2143 rebuffer2362/X VGND VGND VPWR VPWR _3827_/B sky130_fd_sc_hd__buf_6
Xrebuffer2154 _3433_/A VGND VGND VPWR VPWR _3414_/A sky130_fd_sc_hd__buf_2
Xrebuffer2165 place1277/X VGND VGND VPWR VPWR place1266/A sky130_fd_sc_hd__buf_2
X_7266_ _7266_/CLK _7266_/D VGND VGND VPWR VPWR _7266_/Q sky130_fd_sc_hd__dfxtp_2
X_4478_ _4495_/A _4478_/B VGND VGND VPWR VPWR _4478_/X sky130_fd_sc_hd__xor2_2
Xplace1197 _5089_/S VGND VGND VPWR VPWR _5085_/S sky130_fd_sc_hd__buf_2
Xrebuffer2176 _3660_/Y VGND VGND VPWR VPWR _3669_/A3 sky130_fd_sc_hd__buf_2
Xrebuffer2187 _3587_/X VGND VGND VPWR VPWR _3945_/A1 sky130_fd_sc_hd__buf_2
X_7197_ _7407_/CLK _7197_/D VGND VGND VPWR VPWR _7197_/Q sky130_fd_sc_hd__dfxtp_2
X_6217_ _7606_/Q _6179_/B _6202_/X _6216_/X _6180_/X VGND VGND VPWR VPWR _6217_/X
+ sky130_fd_sc_hd__o221a_4
X_3429_ _3473_/A _3429_/B VGND VGND VPWR VPWR _3429_/Y sky130_fd_sc_hd__nand2_2
X_6148_ _6165_/A1 _7169_/Q _7141_/Q _6154_/B2 VGND VGND VPWR VPWR _6148_/X sky130_fd_sc_hd__o22a_2
XTAP_TAPCELL_ROW_90_1171 VGND VPWR sky130_fd_sc_hd__tapvpwrvgnd_1
XFILLER_57_144 VGND VGND VPWR VPWR sky130_fd_sc_hd__fill_1
XFILLER_45_306 VGND VGND VPWR VPWR sky130_fd_sc_hd__decap_3
X_6079_ _6079_/A1 _6161_/A2 _4508_/B _4550_/S VGND VGND VPWR VPWR _6079_/X sky130_fd_sc_hd__a211o_2
XTAP_TAPCELL_ROW_56_813 VGND VPWR sky130_fd_sc_hd__tapvpwrvgnd_1
XFILLER_26_531 VGND VGND VPWR VPWR sky130_fd_sc_hd__fill_1
XTAP_TAPCELL_ROW_28_515 VGND VPWR sky130_fd_sc_hd__tapvpwrvgnd_1
XFILLER_26_542 VGND VGND VPWR VPWR sky130_fd_sc_hd__decap_3
XFILLER_54_35 VGND VGND VPWR VPWR sky130_fd_sc_hd__fill_2
XFILLER_60_309 VGND VGND VPWR VPWR sky130_fd_sc_hd__decap_3
XFILLER_13_225 VGND VGND VPWR VPWR sky130_fd_sc_hd__decap_3
XFILLER_41_501 VGND VGND VPWR VPWR sky130_fd_sc_hd__decap_3
XTAP_TAPCELL_ROW_64_890 VGND VPWR sky130_fd_sc_hd__tapvpwrvgnd_1
XFILLER_41_567 VGND VGND VPWR VPWR sky130_fd_sc_hd__fill_2
XFILLER_9_229 VGND VGND VPWR VPWR sky130_fd_sc_hd__decap_3
XFILLER_79_65 VGND VGND VPWR VPWR sky130_fd_sc_hd__fill_1
XFILLER_36_306 VGND VGND VPWR VPWR sky130_fd_sc_hd__fill_2
XFILLER_17_553 VGND VGND VPWR VPWR sky130_fd_sc_hd__decap_3
XFILLER_17_564 VGND VGND VPWR VPWR sky130_fd_sc_hd__fill_2
XFILLER_17_575 VGND VGND VPWR VPWR sky130_fd_sc_hd__fill_1
XFILLER_17_597 VGND VGND VPWR VPWR sky130_fd_sc_hd__fill_1
XFILLER_32_512 VGND VGND VPWR VPWR sky130_fd_sc_hd__decap_3
XFILLER_44_361 VGND VGND VPWR VPWR sky130_fd_sc_hd__decap_3
XFILLER_32_578 VGND VGND VPWR VPWR sky130_fd_sc_hd__decap_3
XFILLER_32_589 VGND VGND VPWR VPWR sky130_fd_sc_hd__fill_2
X_3780_ _3780_/A1 _3815_/A2 _7376_/Q _3815_/B1 _7568_/Q VGND VGND VPWR VPWR _3780_/X
+ sky130_fd_sc_hd__a32o_2
XFILLER_8_251 VGND VGND VPWR VPWR sky130_fd_sc_hd__fill_1
X_5450_ _5450_/A0 _5572_/A1 _5452_/S VGND VGND VPWR VPWR _7162_/D sky130_fd_sc_hd__mux2_2
X_4401_ _4401_/A1 _4392_/X _4400_/X VGND VGND VPWR VPWR _4401_/X sky130_fd_sc_hd__o21a_2
X_5381_ _5381_/A0 _5564_/A1 _5391_/S VGND VGND VPWR VPWR _7130_/D sky130_fd_sc_hd__mux2_2
X_7120_ _7280_/CLK _7120_/D VGND VGND VPWR VPWR _7120_/Q sky130_fd_sc_hd__dfxtp_2
X_4332_ _7584_/D _5843_/B _4348_/C _3561_/B VGND VGND VPWR VPWR _4332_/X sky130_fd_sc_hd__o31a_2
X_7051_ _7243_/CLK _7051_/D VGND VGND VPWR VPWR _7051_/Q sky130_fd_sc_hd__dfxtp_2
X_4263_ _4237_/A _3738_/B _4263_/A3 _4272_/A3 _4263_/B1 VGND VGND VPWR VPWR _4263_/Y
+ sky130_fd_sc_hd__o41ai_2
X_6002_ _6002_/A VGND VGND VPWR VPWR _6010_/B sky130_fd_sc_hd__inv_2
X_4194_ _4194_/A _4194_/B VGND VGND VPWR VPWR _4194_/Y sky130_fd_sc_hd__nor2_2
XFILLER_27_317 VGND VGND VPWR VPWR sky130_fd_sc_hd__decap_3
XFILLER_39_166 VGND VGND VPWR VPWR sky130_fd_sc_hd__fill_2
XFILLER_94_250 VGND VGND VPWR VPWR sky130_fd_sc_hd__fill_2
XPHY_EDGE_ROW_19_Left_123 VGND VGND VPWR VPWR sky130_fd_sc_hd__decap_3
X_6904_ _7275_/CLK _6904_/D VGND VGND VPWR VPWR _6904_/Q sky130_fd_sc_hd__dfxtp_2
XFILLER_35_361 VGND VGND VPWR VPWR sky130_fd_sc_hd__decap_3
XFILLER_23_556 VGND VGND VPWR VPWR sky130_fd_sc_hd__decap_3
X_3978_ _7390_/Q _3978_/B VGND VGND VPWR VPWR _3980_/B sky130_fd_sc_hd__nand2_2
XTAP_TAPCELL_ROW_61_860 VGND VPWR sky130_fd_sc_hd__tapvpwrvgnd_1
XFILLER_10_217 VGND VGND VPWR VPWR sky130_fd_sc_hd__fill_1
XTAP_TAPCELL_ROW_33_573 VGND VPWR sky130_fd_sc_hd__tapvpwrvgnd_1
XPHY_EDGE_ROW_28_Left_132 VGND VGND VPWR VPWR sky130_fd_sc_hd__decap_3
X_5648_ _5648_/A0 _5709_/A1 _5654_/S VGND VGND VPWR VPWR _7253_/D sky130_fd_sc_hd__mux2_2
XTAP_TAPCELL_ROW_79_1055 VGND VPWR sky130_fd_sc_hd__tapvpwrvgnd_1
X_5579_ _5579_/A0 _4677_/X _5593_/S VGND VGND VPWR VPWR _7221_/D sky130_fd_sc_hd__mux2_2
X_7318_ _7608_/CLK _7318_/D place2050/X VGND VGND VPWR VPWR _7318_/Q sky130_fd_sc_hd__dfrtp_2
X_7249_ _7291_/CLK _7249_/D VGND VGND VPWR VPWR _7249_/Q sky130_fd_sc_hd__dfxtp_2
XFILLER_49_57 VGND VGND VPWR VPWR sky130_fd_sc_hd__decap_3
XPHY_EDGE_ROW_37_Left_141 VGND VGND VPWR VPWR sky130_fd_sc_hd__decap_3
XTAP_TAPCELL_ROW_5_276 VGND VPWR sky130_fd_sc_hd__tapvpwrvgnd_1
XFILLER_18_328 VGND VGND VPWR VPWR sky130_fd_sc_hd__decap_3
XFILLER_45_103 VGND VGND VPWR VPWR sky130_fd_sc_hd__decap_3
XFILLER_14_589 VGND VGND VPWR VPWR sky130_fd_sc_hd__fill_2
XFILLER_41_375 VGND VGND VPWR VPWR sky130_fd_sc_hd__decap_3
XFILLER_81_55 VGND VGND VPWR VPWR sky130_fd_sc_hd__fill_1
XPHY_EDGE_ROW_46_Left_150 VGND VGND VPWR VPWR sky130_fd_sc_hd__decap_3
XFILLER_14_93 VGND VGND VPWR VPWR sky130_fd_sc_hd__fill_2
XFILLER_5_221 VGND VGND VPWR VPWR sky130_fd_sc_hd__decap_3
XFILLER_5_298 VGND VGND VPWR VPWR sky130_fd_sc_hd__fill_1
XFILLER_68_217 VGND VGND VPWR VPWR sky130_fd_sc_hd__decap_3
XFILLER_49_442 VGND VGND VPWR VPWR sky130_fd_sc_hd__decap_3
XFILLER_36_103 VGND VGND VPWR VPWR sky130_fd_sc_hd__decap_3
XFILLER_24_309 VGND VGND VPWR VPWR sky130_fd_sc_hd__decap_3
XFILLER_36_158 VGND VGND VPWR VPWR sky130_fd_sc_hd__decap_3
XFILLER_17_350 VGND VGND VPWR VPWR sky130_fd_sc_hd__fill_1
XFILLER_32_320 VGND VGND VPWR VPWR sky130_fd_sc_hd__decap_3
X_4881_ _4881_/A0 _5709_/A1 _4896_/S VGND VGND VPWR VPWR _6917_/D sky130_fd_sc_hd__mux2_2
X_3901_ _7397_/Q _3901_/B _3901_/C VGND VGND VPWR VPWR _3901_/X sky130_fd_sc_hd__and3_2
XFILLER_20_515 VGND VGND VPWR VPWR sky130_fd_sc_hd__decap_3
X_3832_ _3832_/A _3832_/B _3832_/C VGND VGND VPWR VPWR _3833_/B sky130_fd_sc_hd__nor3_2
XFILLER_20_548 VGND VGND VPWR VPWR sky130_fd_sc_hd__decap_3
X_6551_ _6551_/A0 _6185_/X _6567_/S VGND VGND VPWR VPWR _7444_/D sky130_fd_sc_hd__mux2_2
X_3763_ _3698_/B _4237_/C _3756_/Y _3760_/Y _3762_/Y VGND VGND VPWR VPWR _4236_/B
+ sky130_fd_sc_hd__o41a_2
XTAP_TAPCELL_ROW_30_543 VGND VPWR sky130_fd_sc_hd__tapvpwrvgnd_1
XFILLER_9_582 VGND VGND VPWR VPWR sky130_fd_sc_hd__decap_3
X_6482_ _4904_/A _6482_/A2 _6475_/Y _6478_/Y _6481_/Y VGND VGND VPWR VPWR _6486_/A
+ sky130_fd_sc_hd__a311o_2
X_3694_ _7547_/Q _3893_/A2 _3865_/B _7515_/Q VGND VGND VPWR VPWR _3695_/B sky130_fd_sc_hd__a22oi_2
X_5433_ _5433_/A0 _5677_/A1 _5452_/S VGND VGND VPWR VPWR _7154_/D sky130_fd_sc_hd__mux2_2
X_7103_ _7273_/CLK _7103_/D VGND VGND VPWR VPWR _7103_/Q sky130_fd_sc_hd__dfxtp_2
X_4315_ _4315_/A _4473_/B _4337_/D _4315_/D VGND VGND VPWR VPWR _4315_/X sky130_fd_sc_hd__and4_2
XFILLER_59_206 VGND VGND VPWR VPWR sky130_fd_sc_hd__decap_3
XFILLER_19_27 VGND VGND VPWR VPWR sky130_fd_sc_hd__fill_2
X_7034_ _7291_/CLK _7034_/D VGND VGND VPWR VPWR _7034_/Q sky130_fd_sc_hd__dfxtp_2
X_4177_ _4174_/B _3887_/C _4178_/A2 _4250_/C1 VGND VGND VPWR VPWR _4177_/Y sky130_fd_sc_hd__a31oi_2
XFILLER_95_581 VGND VGND VPWR VPWR sky130_fd_sc_hd__decap_3
XTAP_TAPCELL_ROW_38_621 VGND VPWR sky130_fd_sc_hd__tapvpwrvgnd_1
XTAP_TAPCELL_ROW_2_246 VGND VPWR sky130_fd_sc_hd__tapvpwrvgnd_1
XFILLER_27_158 VGND VGND VPWR VPWR sky130_fd_sc_hd__decap_3
XFILLER_82_242 VGND VGND VPWR VPWR sky130_fd_sc_hd__fill_1
XFILLER_27_169 VGND VGND VPWR VPWR sky130_fd_sc_hd__decap_3
XFILLER_55_478 VGND VGND VPWR VPWR sky130_fd_sc_hd__decap_3
X_6818_ _6838_/A _6818_/B VGND VGND VPWR VPWR _7567_/D sky130_fd_sc_hd__and2_2
XFILLER_23_386 VGND VGND VPWR VPWR sky130_fd_sc_hd__decap_3
XFILLER_11_559 VGND VGND VPWR VPWR sky130_fd_sc_hd__fill_1
XFILLER_58_250 VGND VGND VPWR VPWR sky130_fd_sc_hd__fill_2
XFILLER_100_380 VGND VGND VPWR VPWR sky130_fd_sc_hd__fill_2
XFILLER_18_103 VGND VGND VPWR VPWR sky130_fd_sc_hd__decap_3
XFILLER_18_147 VGND VGND VPWR VPWR sky130_fd_sc_hd__fill_2
XFILLER_46_456 VGND VGND VPWR VPWR sky130_fd_sc_hd__decap_3
XFILLER_73_231 VGND VGND VPWR VPWR sky130_fd_sc_hd__fill_1
XFILLER_26_191 VGND VGND VPWR VPWR sky130_fd_sc_hd__decap_3
XFILLER_33_139 VGND VGND VPWR VPWR sky130_fd_sc_hd__decap_3
XFILLER_25_81 VGND VGND VPWR VPWR sky130_fd_sc_hd__decap_3
XFILLER_41_150 VGND VGND VPWR VPWR sky130_fd_sc_hd__decap_3
XTAP_TAPCELL_ROW_72_977 VGND VPWR sky130_fd_sc_hd__tapvpwrvgnd_1
XFILLER_41_194 VGND VGND VPWR VPWR sky130_fd_sc_hd__decap_3
XFILLER_10_570 VGND VGND VPWR VPWR sky130_fd_sc_hd__decap_3
XFILLER_6_530 VGND VGND VPWR VPWR sky130_fd_sc_hd__fill_2
Xplace1708 _3544_/C VGND VGND VPWR VPWR _3948_/C sky130_fd_sc_hd__buf_2
Xplace1719 _3984_/B1 VGND VGND VPWR VPWR _3893_/A2 sky130_fd_sc_hd__buf_4
XFILLER_96_334 VGND VGND VPWR VPWR sky130_fd_sc_hd__decap_3
X_4100_ _3931_/B _6804_/A1 _3956_/Y _4101_/A2 VGND VGND VPWR VPWR _4100_/Y sky130_fd_sc_hd__a211oi_2
XFILLER_2_41 VGND VGND VPWR VPWR sky130_fd_sc_hd__fill_2
X_4031_ _4036_/A _4036_/D VGND VGND VPWR VPWR _4035_/B sky130_fd_sc_hd__nand2_2
XFILLER_2_74 VGND VGND VPWR VPWR sky130_fd_sc_hd__fill_2
XFILLER_37_423 VGND VGND VPWR VPWR sky130_fd_sc_hd__fill_1
XFILLER_64_253 VGND VGND VPWR VPWR sky130_fd_sc_hd__decap_3
XFILLER_64_275 VGND VGND VPWR VPWR sky130_fd_sc_hd__decap_3
X_5982_ _5980_/X _5981_/X _5778_/X VGND VGND VPWR VPWR _5983_/A sky130_fd_sc_hd__a21oi_2
XFILLER_17_180 VGND VGND VPWR VPWR sky130_fd_sc_hd__fill_2
XANTENNA_13 _6861_/Q VGND VGND VPWR VPWR sky130_fd_sc_hd__diode_2
XFILLER_20_301 VGND VGND VPWR VPWR sky130_fd_sc_hd__decap_3
XFILLER_20_312 VGND VGND VPWR VPWR sky130_fd_sc_hd__decap_3
X_4864_ _4864_/A0 _5692_/A1 _4870_/S VGND VGND VPWR VPWR _6909_/D sky130_fd_sc_hd__mux2_2
XANTENNA_24 _5541_/A0 VGND VGND VPWR VPWR sky130_fd_sc_hd__diode_2
XANTENNA_35 _5293_/A0 VGND VGND VPWR VPWR sky130_fd_sc_hd__diode_2
XANTENNA_46 _6858_/Q VGND VGND VPWR VPWR sky130_fd_sc_hd__diode_2
X_7583_ clkload6/A _7583_/D place2030/X VGND VGND VPWR VPWR _7583_/Q sky130_fd_sc_hd__dfrtp_2
X_3815_ _3815_/A1 _3815_/A2 _7374_/Q _3815_/B1 _7566_/Q VGND VGND VPWR VPWR _3815_/X
+ sky130_fd_sc_hd__a32o_2
XTAP_TAPCELL_ROW_15_381 VGND VPWR sky130_fd_sc_hd__tapvpwrvgnd_1
XFILLER_21_28 VGND VGND VPWR VPWR sky130_fd_sc_hd__decap_3
X_3746_ _3746_/A _3746_/B _3746_/C VGND VGND VPWR VPWR _3746_/X sky130_fd_sc_hd__or3_4
XFILLER_9_390 VGND VGND VPWR VPWR sky130_fd_sc_hd__fill_2
X_6465_ _7275_/Q _6465_/B _6465_/C _6465_/D VGND VGND VPWR VPWR _6465_/X sky130_fd_sc_hd__or4_2
XTAP_TAPCELL_ROW_76_1025 VGND VPWR sky130_fd_sc_hd__tapvpwrvgnd_1
X_6396_ _6396_/A1 _7036_/Q _6952_/Q _6455_/B2 VGND VGND VPWR VPWR _6396_/X sky130_fd_sc_hd__o22a_2
Xhold2900 _7330_/Q VGND VGND VPWR VPWR _6245_/B sky130_fd_sc_hd__dlygate4sd3_1
Xhold2911 _7494_/Q VGND VGND VPWR VPWR _6664_/A0 sky130_fd_sc_hd__dlygate4sd3_1
Xhold2922 _7326_/Q VGND VGND VPWR VPWR _6237_/B sky130_fd_sc_hd__dlygate4sd3_1
Xhold2933 _7324_/Q VGND VGND VPWR VPWR _6233_/B sky130_fd_sc_hd__dlygate4sd3_1
Xhold2944 _7453_/Q VGND VGND VPWR VPWR _6577_/A0 sky130_fd_sc_hd__dlygate4sd3_1
Xhold2955 _7380_/Q VGND VGND VPWR VPWR _6339_/B2 sky130_fd_sc_hd__dlygate4sd3_1
Xhold2966 _7466_/Q VGND VGND VPWR VPWR _6605_/A0 sky130_fd_sc_hd__dlygate4sd3_1
X_7017_ _7243_/CLK _7017_/D VGND VGND VPWR VPWR _7017_/Q sky130_fd_sc_hd__dfxtp_2
X_4229_ _4228_/D _4227_/X _4221_/X _4228_/A VGND VGND VPWR VPWR _4233_/A sky130_fd_sc_hd__a22o_2
Xhold2977 _6362_/X VGND VGND VPWR VPWR _7395_/D sky130_fd_sc_hd__dlygate4sd3_1
Xhold2988 _7530_/Q VGND VGND VPWR VPWR _6739_/A1 sky130_fd_sc_hd__dlygate4sd3_1
Xhold2999 _7419_/Q VGND VGND VPWR VPWR _6412_/B2 sky130_fd_sc_hd__dlygate4sd3_1
XFILLER_28_445 VGND VGND VPWR VPWR sky130_fd_sc_hd__fill_2
XFILLER_46_58 VGND VGND VPWR VPWR sky130_fd_sc_hd__decap_3
XTAP_TAPCELL_ROW_87_1132 VGND VPWR sky130_fd_sc_hd__tapvpwrvgnd_1
XFILLER_28_489 VGND VGND VPWR VPWR sky130_fd_sc_hd__decap_3
XFILLER_70_234 VGND VGND VPWR VPWR sky130_fd_sc_hd__fill_1
XFILLER_11_301 VGND VGND VPWR VPWR sky130_fd_sc_hd__fill_2
XFILLER_11_312 VGND VGND VPWR VPWR sky130_fd_sc_hd__decap_3
XTAP_TAPCELL_ROW_41_649 VGND VPWR sky130_fd_sc_hd__tapvpwrvgnd_1
XFILLER_7_327 VGND VGND VPWR VPWR sky130_fd_sc_hd__decap_3
XTAP_TAPCELL_ROW_98_1250 VGND VPWR sky130_fd_sc_hd__tapvpwrvgnd_1
XFILLER_3_511 VGND VGND VPWR VPWR sky130_fd_sc_hd__fill_2
XFILLER_3_588 VGND VGND VPWR VPWR sky130_fd_sc_hd__decap_3
XTAP_TAPCELL_ROW_49_738 VGND VPWR sky130_fd_sc_hd__tapvpwrvgnd_1
XFILLER_46_220 VGND VGND VPWR VPWR sky130_fd_sc_hd__decap_3
XFILLER_34_437 VGND VGND VPWR VPWR sky130_fd_sc_hd__decap_3
XFILLER_36_80 VGND VGND VPWR VPWR sky130_fd_sc_hd__decap_3
XFILLER_61_234 VGND VGND VPWR VPWR sky130_fd_sc_hd__decap_3
XFILLER_21_109 VGND VGND VPWR VPWR sky130_fd_sc_hd__decap_3
XFILLER_14_161 VGND VGND VPWR VPWR sky130_fd_sc_hd__decap_3
XFILLER_99_6 VGND VGND VPWR VPWR sky130_fd_sc_hd__fill_1
XTAP_TAPCELL_ROW_12_351 VGND VPWR sky130_fd_sc_hd__tapvpwrvgnd_1
X_3531_ _3528_/Y _3557_/B _3534_/A2 _3530_/Y VGND VGND VPWR VPWR _3531_/Y sky130_fd_sc_hd__o31ai_4
XFILLER_6_360 VGND VGND VPWR VPWR sky130_fd_sc_hd__decap_3
Xplace1505 _3818_/C VGND VGND VPWR VPWR _4691_/A1 sky130_fd_sc_hd__buf_2
Xplace1516 _3755_/X VGND VGND VPWR VPWR _4718_/B1 sky130_fd_sc_hd__buf_2
Xplace1527 _3660_/Y VGND VGND VPWR VPWR _3667_/B1 sky130_fd_sc_hd__buf_2
Xplace1538 _6560_/B VGND VGND VPWR VPWR _6565_/B sky130_fd_sc_hd__buf_2
Xplace1549 _3987_/Y VGND VGND VPWR VPWR _3988_/B sky130_fd_sc_hd__buf_6
X_6250_ _6254_/A _6250_/B VGND VGND VPWR VPWR _7332_/D sky130_fd_sc_hd__and2_2
X_3462_ _3462_/A _3462_/B VGND VGND VPWR VPWR _3462_/Y sky130_fd_sc_hd__nand2_2
XFILLER_103_409 VGND VGND VPWR VPWR sky130_fd_sc_hd__decap_3
X_6181_ _7602_/Q _6179_/B _6179_/Y _6163_/X _6180_/X VGND VGND VPWR VPWR _6181_/X
+ sky130_fd_sc_hd__o221a_4
X_5201_ _5201_/A0 _5351_/A1 _5211_/S VGND VGND VPWR VPWR _7061_/D sky130_fd_sc_hd__mux2_2
X_4014_ _6231_/A2 _4014_/A2 _4025_/B1 _4014_/B1 _3581_/Y VGND VGND VPWR VPWR _4014_/X
+ sky130_fd_sc_hd__a311o_2
XFILLER_37_275 VGND VGND VPWR VPWR sky130_fd_sc_hd__decap_3
XFILLER_52_201 VGND VGND VPWR VPWR sky130_fd_sc_hd__decap_3
XFILLER_25_437 VGND VGND VPWR VPWR sky130_fd_sc_hd__decap_3
XFILLER_12_109 VGND VGND VPWR VPWR sky130_fd_sc_hd__decap_3
X_5965_ _6213_/A1 _7200_/Q _7172_/Q _6213_/B2 VGND VGND VPWR VPWR _5965_/Y sky130_fd_sc_hd__o22ai_4
X_5896_ _7170_/Q _6436_/A _6465_/C _6465_/D VGND VGND VPWR VPWR _5896_/X sky130_fd_sc_hd__or4_2
X_4847_ _4847_/A0 _5614_/A1 _4868_/S VGND VGND VPWR VPWR _6901_/D sky130_fd_sc_hd__mux2_2
XTAP_TAPCELL_ROW_82_1084 VGND VPWR sky130_fd_sc_hd__tapvpwrvgnd_1
XFILLER_20_175 VGND VGND VPWR VPWR sky130_fd_sc_hd__decap_3
XFILLER_20_197 VGND VGND VPWR VPWR sky130_fd_sc_hd__decap_3
X_7566_ _7579_/CLK _7566_/D place2035/X VGND VGND VPWR VPWR _7566_/Q sky130_fd_sc_hd__dfrtp_2
X_4778_ _4778_/A _4904_/B _4904_/C VGND VGND VPWR VPWR _5671_/B sky130_fd_sc_hd__and3_2
X_7497_ _7611_/CLK _7497_/D place2065/X VGND VGND VPWR VPWR _7497_/Q sky130_fd_sc_hd__dfrtp_2
X_3729_ _4763_/A2 _4297_/A _3728_/X _3727_/Y VGND VGND VPWR VPWR _3729_/Y sky130_fd_sc_hd__o22ai_2
X_6448_ _6448_/A1 _7178_/Q _7150_/Q _6448_/B2 VGND VGND VPWR VPWR _6448_/X sky130_fd_sc_hd__o22a_2
Xoutput2071 _4163_/X VGND VGND VPWR VPWR result[10] sky130_fd_sc_hd__clkdlybuf4s25_1
Xoutput2082 _4218_/X VGND VGND VPWR VPWR result[20] sky130_fd_sc_hd__dlymetal6s4s_1
XFILLER_0_536 VGND VGND VPWR VPWR sky130_fd_sc_hd__decap_3
XFILLER_0_547 VGND VGND VPWR VPWR sky130_fd_sc_hd__decap_3
Xoutput2093 _4293_/X VGND VGND VPWR VPWR result[30] sky130_fd_sc_hd__buf_8
Xhold2730 _7095_/Q VGND VGND VPWR VPWR _5302_/A0 sky130_fd_sc_hd__dlygate4sd3_1
Xhold2741 _6868_/Q VGND VGND VPWR VPWR _4759_/A0 sky130_fd_sc_hd__dlygate4sd3_1
XFILLER_75_337 VGND VGND VPWR VPWR sky130_fd_sc_hd__decap_3
XFILLER_87_186 VGND VGND VPWR VPWR sky130_fd_sc_hd__fill_1
Xhold2752 _7027_/Q VGND VGND VPWR VPWR _5127_/A0 sky130_fd_sc_hd__dlygate4sd3_1
Xhold2763 _7104_/Q VGND VGND VPWR VPWR _5323_/A0 sky130_fd_sc_hd__dlygate4sd3_1
Xhold2774 _7264_/Q VGND VGND VPWR VPWR _5673_/A0 sky130_fd_sc_hd__dlygate4sd3_1
XFILLER_28_220 VGND VGND VPWR VPWR sky130_fd_sc_hd__decap_3
XFILLER_57_79 VGND VGND VPWR VPWR sky130_fd_sc_hd__fill_2
Xhold2785 _7237_/Q VGND VGND VPWR VPWR _5614_/A0 sky130_fd_sc_hd__dlygate4sd3_1
Xhold2796 _7141_/Q VGND VGND VPWR VPWR _5404_/A0 sky130_fd_sc_hd__dlygate4sd3_1
XFILLER_28_253 VGND VGND VPWR VPWR sky130_fd_sc_hd__decap_3
XTAP_TAPCELL_ROW_46_708 VGND VPWR sky130_fd_sc_hd__tapvpwrvgnd_1
XFILLER_43_234 VGND VGND VPWR VPWR sky130_fd_sc_hd__fill_2
XFILLER_43_245 VGND VGND VPWR VPWR sky130_fd_sc_hd__decap_3
XFILLER_71_554 VGND VGND VPWR VPWR sky130_fd_sc_hd__fill_2
XFILLER_24_470 VGND VGND VPWR VPWR sky130_fd_sc_hd__decap_3
XFILLER_31_418 VGND VGND VPWR VPWR sky130_fd_sc_hd__decap_3
XTAP_TAPCELL_ROW_54_785 VGND VPWR sky130_fd_sc_hd__tapvpwrvgnd_1
XTAP_TAPCELL_ROW_26_498 VGND VPWR sky130_fd_sc_hd__tapvpwrvgnd_1
XFILLER_24_492 VGND VGND VPWR VPWR sky130_fd_sc_hd__decap_3
XFILLER_7_113 VGND VGND VPWR VPWR sky130_fd_sc_hd__decap_3
XFILLER_11_175 VGND VGND VPWR VPWR sky130_fd_sc_hd__decap_3
XFILLER_11_197 VGND VGND VPWR VPWR sky130_fd_sc_hd__decap_3
XFILLER_22_60 VGND VGND VPWR VPWR sky130_fd_sc_hd__decap_3
XFILLER_3_330 VGND VGND VPWR VPWR sky130_fd_sc_hd__fill_1
XFILLER_14_6 VGND VGND VPWR VPWR sky130_fd_sc_hd__fill_1
XFILLER_66_348 VGND VGND VPWR VPWR sky130_fd_sc_hd__decap_3
XFILLER_19_264 VGND VGND VPWR VPWR sky130_fd_sc_hd__decap_3
XFILLER_19_275 VGND VGND VPWR VPWR sky130_fd_sc_hd__decap_3
XFILLER_34_201 VGND VGND VPWR VPWR sky130_fd_sc_hd__fill_1
XFILLER_22_407 VGND VGND VPWR VPWR sky130_fd_sc_hd__decap_3
XFILLER_34_245 VGND VGND VPWR VPWR sky130_fd_sc_hd__decap_3
XFILLER_34_267 VGND VGND VPWR VPWR sky130_fd_sc_hd__decap_3
X_5750_ _5750_/A1 _5759_/D1 _4842_/C _4119_/Y VGND VGND VPWR VPWR _5750_/X sky130_fd_sc_hd__a31o_4
X_5681_ _5681_/A0 _5681_/A1 _5696_/S VGND VGND VPWR VPWR _7268_/D sky130_fd_sc_hd__mux2_2
XFILLER_30_473 VGND VGND VPWR VPWR sky130_fd_sc_hd__decap_3
X_7420_ clkload7/A _7420_/D place2020/X VGND VGND VPWR VPWR _7420_/Q sky130_fd_sc_hd__dfrtp_2
XFILLER_8_73 VGND VGND VPWR VPWR sky130_fd_sc_hd__fill_1
Xplace2003 _3468_/A VGND VGND VPWR VPWR _3961_/A sky130_fd_sc_hd__buf_2
Xplace2036 place2045/X VGND VGND VPWR VPWR place2036/X sky130_fd_sc_hd__buf_2
Xplace2025 place2032/X VGND VGND VPWR VPWR place2025/X sky130_fd_sc_hd__buf_2
Xplace2014 place2015/X VGND VGND VPWR VPWR place2014/X sky130_fd_sc_hd__buf_2
X_7351_ _7577_/CLK _7351_/D place2046/X VGND VGND VPWR VPWR _7351_/Q sky130_fd_sc_hd__dfrtp_2
X_4563_ _4563_/A1 _4563_/A2 _4563_/A3 _4464_/B VGND VGND VPWR VPWR _4563_/X sky130_fd_sc_hd__a31o_2
Xplace1302 _4970_/D VGND VGND VPWR VPWR _6186_/C1 sky130_fd_sc_hd__buf_2
Xplace1313 place1313/A VGND VGND VPWR VPWR _4306_/A sky130_fd_sc_hd__buf_2
Xplace1324 place1325/X VGND VGND VPWR VPWR place1324/X sky130_fd_sc_hd__buf_8
Xplace1335 _6456_/B2 VGND VGND VPWR VPWR _6213_/B2 sky130_fd_sc_hd__buf_8
Xplace2069 place2069/A VGND VGND VPWR VPWR place2069/X sky130_fd_sc_hd__buf_2
Xplace2058 place2066/X VGND VGND VPWR VPWR place2058/X sky130_fd_sc_hd__buf_2
Xplace2047 place2048/X VGND VGND VPWR VPWR place2047/X sky130_fd_sc_hd__buf_2
X_7282_ _7282_/CLK _7282_/D VGND VGND VPWR VPWR _7282_/Q sky130_fd_sc_hd__dfxtp_2
X_6302_ _6302_/A _6302_/B _6302_/C VGND VGND VPWR VPWR _6347_/C sky130_fd_sc_hd__or3_2
X_4494_ _4561_/A1 _4379_/B _4448_/B _7310_/Q VGND VGND VPWR VPWR _4498_/B sky130_fd_sc_hd__a31o_2
X_3514_ _3514_/A _3529_/C VGND VGND VPWR VPWR _3536_/C sky130_fd_sc_hd__nor2_4
Xplace1346 _4283_/X VGND VGND VPWR VPWR _4284_/B1 sky130_fd_sc_hd__buf_2
Xplace1357 _4103_/Y VGND VGND VPWR VPWR _5862_/A3 sky130_fd_sc_hd__buf_2
Xplace1368 _3930_/Y VGND VGND VPWR VPWR _3945_/C1 sky130_fd_sc_hd__buf_2
X_6233_ _6247_/A _6233_/B VGND VGND VPWR VPWR _7324_/D sky130_fd_sc_hd__and2_2
X_3445_ _3445_/A _3445_/B _3445_/C VGND VGND VPWR VPWR _3446_/B sky130_fd_sc_hd__nand3_4
XFILLER_103_228 VGND VGND VPWR VPWR sky130_fd_sc_hd__decap_3
Xplace1379 _4283_/C VGND VGND VPWR VPWR _4280_/B1 sky130_fd_sc_hd__buf_2
X_6095_ _7166_/Q _6165_/A1 _6093_/X _6094_/X VGND VGND VPWR VPWR _6095_/X sky130_fd_sc_hd__o211a_2
XFILLER_57_337 VGND VGND VPWR VPWR sky130_fd_sc_hd__decap_3
XFILLER_38_573 VGND VGND VPWR VPWR sky130_fd_sc_hd__decap_3
XFILLER_25_201 VGND VGND VPWR VPWR sky130_fd_sc_hd__fill_2
XFILLER_53_521 VGND VGND VPWR VPWR sky130_fd_sc_hd__fill_1
XFILLER_53_532 VGND VGND VPWR VPWR sky130_fd_sc_hd__decap_3
XFILLER_65_381 VGND VGND VPWR VPWR sky130_fd_sc_hd__fill_2
XTAP_TAPCELL_ROW_84_1102 VGND VPWR sky130_fd_sc_hd__tapvpwrvgnd_1
XFILLER_25_234 VGND VGND VPWR VPWR sky130_fd_sc_hd__fill_1
X_6997_ _7280_/CLK _6997_/D VGND VGND VPWR VPWR _6997_/Q sky130_fd_sc_hd__dfxtp_2
X_5948_ _6064_/A1 _4582_/A _4582_/B _6876_/Q _6064_/C1 VGND VGND VPWR VPWR _5948_/X
+ sky130_fd_sc_hd__a311o_2
XFILLER_40_259 VGND VGND VPWR VPWR sky130_fd_sc_hd__fill_1
XTAP_TAPCELL_ROW_51_755 VGND VPWR sky130_fd_sc_hd__tapvpwrvgnd_1
XTAP_TAPCELL_ROW_23_468 VGND VPWR sky130_fd_sc_hd__tapvpwrvgnd_1
XFILLER_5_606 VGND VGND VPWR VPWR sky130_fd_sc_hd__decap_3
X_7549_ clkload7/A _7549_/D place2021/X VGND VGND VPWR VPWR _7549_/Q sky130_fd_sc_hd__dfrtp_2
XTAP_TAPCELL_ROW_95_1220 VGND VPWR sky130_fd_sc_hd__tapvpwrvgnd_1
XFILLER_4_138 VGND VGND VPWR VPWR sky130_fd_sc_hd__fill_2
Xplace1880 _3446_/B VGND VGND VPWR VPWR _4392_/B1 sky130_fd_sc_hd__buf_2
XFILLER_0_333 VGND VGND VPWR VPWR sky130_fd_sc_hd__decap_3
Xplace1891 _4473_/D VGND VGND VPWR VPWR _3536_/D sky130_fd_sc_hd__buf_4
XFILLER_88_473 VGND VGND VPWR VPWR sky130_fd_sc_hd__decap_3
XFILLER_0_399 VGND VGND VPWR VPWR sky130_fd_sc_hd__decap_3
Xhold2582 _7176_/Q VGND VGND VPWR VPWR _5480_/A0 sky130_fd_sc_hd__dlygate4sd3_1
Xhold2571 _6967_/Q VGND VGND VPWR VPWR _4996_/A0 sky130_fd_sc_hd__dlygate4sd3_1
Xhold2560 _7248_/Q VGND VGND VPWR VPWR _5637_/A0 sky130_fd_sc_hd__dlygate4sd3_1
XTAP_TAPCELL_ROW_59_844 VGND VPWR sky130_fd_sc_hd__tapvpwrvgnd_1
Xhold2593 _7213_/Q VGND VGND VPWR VPWR _5562_/A0 sky130_fd_sc_hd__dlygate4sd3_1
XFILLER_16_212 VGND VGND VPWR VPWR sky130_fd_sc_hd__decap_3
XFILLER_84_66 VGND VGND VPWR VPWR sky130_fd_sc_hd__fill_2
XFILLER_17_82 VGND VGND VPWR VPWR sky130_fd_sc_hd__fill_2
XFILLER_44_554 VGND VGND VPWR VPWR sky130_fd_sc_hd__decap_3
XFILLER_31_237 VGND VGND VPWR VPWR sky130_fd_sc_hd__decap_3
XFILLER_12_473 VGND VGND VPWR VPWR sky130_fd_sc_hd__decap_3
XTAP_TAPCELL_ROW_100_1268 VGND VPWR sky130_fd_sc_hd__tapvpwrvgnd_1
XFILLER_3_160 VGND VGND VPWR VPWR sky130_fd_sc_hd__fill_2
XFILLER_12_3 VGND VGND VPWR VPWR sky130_fd_sc_hd__decap_3
XFILLER_66_134 VGND VGND VPWR VPWR sky130_fd_sc_hd__decap_3
XFILLER_94_421 VGND VGND VPWR VPWR sky130_fd_sc_hd__fill_2
XFILLER_94_432 VGND VGND VPWR VPWR sky130_fd_sc_hd__fill_2
X_6920_ _7575_/CLK _6920_/D VGND VGND VPWR VPWR _6920_/Q sky130_fd_sc_hd__dfxtp_2
X_6851_ _7273_/CLK _6851_/D VGND VGND VPWR VPWR _6851_/Q sky130_fd_sc_hd__dfxtp_2
XFILLER_35_598 VGND VGND VPWR VPWR sky130_fd_sc_hd__fill_1
XFILLER_62_384 VGND VGND VPWR VPWR sky130_fd_sc_hd__fill_2
X_5802_ _7073_/Q _6502_/A2 _6502_/B1 _7101_/Q _5801_/X VGND VGND VPWR VPWR _5803_/B
+ sky130_fd_sc_hd__o221a_2
X_3994_ _3994_/A _3994_/B VGND VGND VPWR VPWR _4001_/A sky130_fd_sc_hd__nand2_2
XTAP_TAPCELL_ROW_20_438 VGND VPWR sky130_fd_sc_hd__tapvpwrvgnd_1
X_7403_ _7493_/CLK _7403_/D place2043/X VGND VGND VPWR VPWR _7403_/Q sky130_fd_sc_hd__dfrtp_2
X_7334_ clkload8/A _7334_/D place2017/X VGND VGND VPWR VPWR _7334_/Q sky130_fd_sc_hd__dfrtp_2
X_4546_ _4545_/X _7543_/Q _4550_/S VGND VGND VPWR VPWR _7317_/D sky130_fd_sc_hd__mux2_2
XFILLER_2_609 VGND VGND VPWR VPWR sky130_fd_sc_hd__decap_3
Xplace1110 _4757_/Y VGND VGND VPWR VPWR _5724_/A1 sky130_fd_sc_hd__buf_2
Xplace1121 _5709_/A1 VGND VGND VPWR VPWR _5342_/A1 sky130_fd_sc_hd__buf_2
Xplace1132 _4656_/X VGND VGND VPWR VPWR _5572_/A1 sky130_fd_sc_hd__buf_2
Xplace1143 _4650_/X VGND VGND VPWR VPWR _5570_/A1 sky130_fd_sc_hd__buf_2
Xrebuffer2111 _7294_/Q VGND VGND VPWR VPWR place1984/A sky130_fd_sc_hd__buf_2
Xrebuffer2122 place1671/X VGND VGND VPWR VPWR _3576_/C sky130_fd_sc_hd__buf_8
XFILLER_1_108 VGND VGND VPWR VPWR sky130_fd_sc_hd__decap_3
Xplace1154 _5688_/A1 VGND VGND VPWR VPWR _5566_/A1 sky130_fd_sc_hd__buf_2
Xplace1165 _5454_/S VGND VGND VPWR VPWR _5471_/S sky130_fd_sc_hd__buf_2
Xplace1176 _4735_/X VGND VGND VPWR VPWR _4773_/B2 sky130_fd_sc_hd__buf_2
Xrebuffer2133 _3987_/Y VGND VGND VPWR VPWR _4094_/C sky130_fd_sc_hd__buf_4
Xrebuffer2144 _3538_/Y VGND VGND VPWR VPWR _3539_/B2 sky130_fd_sc_hd__buf_2
Xrebuffer2155 _5979_/B VGND VGND VPWR VPWR _6547_/A2 sky130_fd_sc_hd__buf_2
X_7265_ _7393_/CLK _7265_/D VGND VGND VPWR VPWR _7265_/Q sky130_fd_sc_hd__dfxtp_2
X_4477_ _7306_/Q _4481_/B _4477_/C VGND VGND VPWR VPWR _4478_/B sky130_fd_sc_hd__and3_2
Xplace1187 _5230_/S VGND VGND VPWR VPWR _5255_/S sky130_fd_sc_hd__buf_2
Xplace1198 _5091_/S VGND VGND VPWR VPWR _5089_/S sky130_fd_sc_hd__buf_2
Xrebuffer2166 _3653_/X VGND VGND VPWR VPWR _3862_/A2 sky130_fd_sc_hd__buf_2
Xrebuffer2177 _3668_/Y VGND VGND VPWR VPWR _4263_/B1 sky130_fd_sc_hd__buf_2
Xrebuffer2188 _3534_/A2 VGND VGND VPWR VPWR _3557_/C sky130_fd_sc_hd__buf_2
X_7196_ _7407_/CLK _7196_/D VGND VGND VPWR VPWR _7196_/Q sky130_fd_sc_hd__dfxtp_2
X_6216_ _6089_/X _6215_/X _5734_/A _6514_/B1 VGND VGND VPWR VPWR _6216_/X sky130_fd_sc_hd__a211o_4
X_3428_ _3473_/A VGND VGND VPWR VPWR _3459_/B sky130_fd_sc_hd__inv_2
X_6147_ _6559_/B1 _4970_/B _4970_/C _7197_/Q _6186_/C1 VGND VGND VPWR VPWR _6147_/X
+ sky130_fd_sc_hd__a311o_2
XTAP_TAPCELL_ROW_90_1172 VGND VPWR sky130_fd_sc_hd__tapvpwrvgnd_1
XFILLER_45_318 VGND VGND VPWR VPWR sky130_fd_sc_hd__decap_3
XFILLER_57_167 VGND VGND VPWR VPWR sky130_fd_sc_hd__fill_1
XFILLER_57_178 VGND VGND VPWR VPWR sky130_fd_sc_hd__decap_3
X_6078_ _6220_/A1 _6182_/A2 _6220_/B1 _7593_/Q _6077_/X VGND VGND VPWR VPWR _6078_/X
+ sky130_fd_sc_hd__o221a_2
XTAP_TAPCELL_ROW_56_814 VGND VPWR sky130_fd_sc_hd__tapvpwrvgnd_1
XTAP_TAPCELL_ROW_28_516 VGND VPWR sky130_fd_sc_hd__tapvpwrvgnd_1
XFILLER_13_204 VGND VGND VPWR VPWR sky130_fd_sc_hd__decap_3
XFILLER_54_69 VGND VGND VPWR VPWR sky130_fd_sc_hd__fill_2
XFILLER_13_237 VGND VGND VPWR VPWR sky130_fd_sc_hd__decap_3
XTAP_TAPCELL_ROW_64_891 VGND VPWR sky130_fd_sc_hd__tapvpwrvgnd_1
XFILLER_41_579 VGND VGND VPWR VPWR sky130_fd_sc_hd__decap_3
XFILLER_9_208 VGND VGND VPWR VPWR sky130_fd_sc_hd__decap_3
XFILLER_21_281 VGND VGND VPWR VPWR sky130_fd_sc_hd__decap_3
XFILLER_5_403 VGND VGND VPWR VPWR sky130_fd_sc_hd__fill_1
XFILLER_5_458 VGND VGND VPWR VPWR sky130_fd_sc_hd__decap_3
XFILLER_0_141 VGND VGND VPWR VPWR sky130_fd_sc_hd__fill_2
XFILLER_0_152 VGND VGND VPWR VPWR sky130_fd_sc_hd__decap_3
XFILLER_0_163 VGND VGND VPWR VPWR sky130_fd_sc_hd__decap_3
XFILLER_48_112 VGND VGND VPWR VPWR sky130_fd_sc_hd__decap_3
XFILLER_76_421 VGND VGND VPWR VPWR sky130_fd_sc_hd__decap_3
XFILLER_88_292 VGND VGND VPWR VPWR sky130_fd_sc_hd__fill_1
XFILLER_36_318 VGND VGND VPWR VPWR sky130_fd_sc_hd__decap_3
XFILLER_76_454 VGND VGND VPWR VPWR sky130_fd_sc_hd__fill_2
Xhold2390 _6898_/Q VGND VGND VPWR VPWR _4838_/A0 sky130_fd_sc_hd__dlygate4sd3_1
XFILLER_28_92 VGND VGND VPWR VPWR sky130_fd_sc_hd__decap_3
XFILLER_29_381 VGND VGND VPWR VPWR sky130_fd_sc_hd__fill_1
XFILLER_48_178 VGND VGND VPWR VPWR sky130_fd_sc_hd__decap_3
XFILLER_44_340 VGND VGND VPWR VPWR sky130_fd_sc_hd__decap_3
XFILLER_63_148 VGND VGND VPWR VPWR sky130_fd_sc_hd__decap_3
XFILLER_63_159 VGND VGND VPWR VPWR sky130_fd_sc_hd__decap_3
XFILLER_32_546 VGND VGND VPWR VPWR sky130_fd_sc_hd__decap_3
XFILLER_44_395 VGND VGND VPWR VPWR sky130_fd_sc_hd__decap_3
XFILLER_32_568 VGND VGND VPWR VPWR sky130_fd_sc_hd__fill_1
XFILLER_44_91 VGND VGND VPWR VPWR sky130_fd_sc_hd__decap_3
X_4400_ _4401_/A1 _4392_/X _4397_/Y _4399_/X VGND VGND VPWR VPWR _4400_/X sky130_fd_sc_hd__a22o_2
XFILLER_4_480 VGND VGND VPWR VPWR sky130_fd_sc_hd__fill_2
XFILLER_4_491 VGND VGND VPWR VPWR sky130_fd_sc_hd__fill_2
X_7050_ _7274_/CLK _7050_/D VGND VGND VPWR VPWR _7050_/Q sky130_fd_sc_hd__dfxtp_2
X_6001_ _5999_/X _6000_/X _6398_/B1 VGND VGND VPWR VPWR _6002_/A sky130_fd_sc_hd__a21oi_2
XFILLER_79_281 VGND VGND VPWR VPWR sky130_fd_sc_hd__fill_1
X_4193_ _4168_/Y _4170_/X _4192_/X VGND VGND VPWR VPWR _4193_/Y sky130_fd_sc_hd__a21oi_4
XFILLER_39_178 VGND VGND VPWR VPWR sky130_fd_sc_hd__decap_3
XFILLER_54_104 VGND VGND VPWR VPWR sky130_fd_sc_hd__decap_3
X_6903_ _7272_/CLK _6903_/D VGND VGND VPWR VPWR _6903_/Q sky130_fd_sc_hd__dfxtp_2
XFILLER_35_351 VGND VGND VPWR VPWR sky130_fd_sc_hd__decap_3
XFILLER_35_373 VGND VGND VPWR VPWR sky130_fd_sc_hd__decap_3
XFILLER_62_170 VGND VGND VPWR VPWR sky130_fd_sc_hd__decap_3
X_6834_ _6838_/A _6834_/B VGND VGND VPWR VPWR _7575_/D sky130_fd_sc_hd__and2_2
XFILLER_50_365 VGND VGND VPWR VPWR sky130_fd_sc_hd__decap_3
X_6765_ _6217_/X _6765_/A1 _6765_/S VGND VGND VPWR VPWR _7542_/D sky130_fd_sc_hd__mux2_2
X_3977_ _7422_/Q _4004_/A2 _3996_/B1 _7326_/Q VGND VGND VPWR VPWR _3980_/A sky130_fd_sc_hd__a22oi_2
XTAP_TAPCELL_ROW_61_861 VGND VPWR sky130_fd_sc_hd__tapvpwrvgnd_1
XTAP_TAPCELL_ROW_33_574 VGND VPWR sky130_fd_sc_hd__tapvpwrvgnd_1
XFILLER_40_27 VGND VGND VPWR VPWR sky130_fd_sc_hd__fill_1
X_6696_ _6696_/A0 _6201_/X _6704_/S VGND VGND VPWR VPWR _7509_/D sky130_fd_sc_hd__mux2_2
XFILLER_40_38 VGND VGND VPWR VPWR sky130_fd_sc_hd__fill_1
XTAP_TAPCELL_ROW_79_1056 VGND VPWR sky130_fd_sc_hd__tapvpwrvgnd_1
XFILLER_2_406 VGND VGND VPWR VPWR sky130_fd_sc_hd__decap_3
XFILLER_2_417 VGND VGND VPWR VPWR sky130_fd_sc_hd__decap_3
XFILLER_2_428 VGND VGND VPWR VPWR sky130_fd_sc_hd__fill_2
X_7317_ _7608_/CLK _7317_/D place2050/X VGND VGND VPWR VPWR _7317_/Q sky130_fd_sc_hd__dfrtp_2
X_4529_ _4528_/X _6761_/A1 _4539_/S VGND VGND VPWR VPWR _7314_/D sky130_fd_sc_hd__mux2_2
X_7248_ _7264_/CLK _7248_/D VGND VGND VPWR VPWR _7248_/Q sky130_fd_sc_hd__dfxtp_2
XFILLER_58_421 VGND VGND VPWR VPWR sky130_fd_sc_hd__decap_3
XFILLER_58_432 VGND VGND VPWR VPWR sky130_fd_sc_hd__decap_3
X_7179_ _7235_/CLK _7179_/D VGND VGND VPWR VPWR _7179_/Q sky130_fd_sc_hd__dfxtp_2
XFILLER_100_562 VGND VGND VPWR VPWR sky130_fd_sc_hd__decap_3
XFILLER_18_307 VGND VGND VPWR VPWR sky130_fd_sc_hd__fill_1
XTAP_TAPCELL_ROW_69_950 VGND VPWR sky130_fd_sc_hd__tapvpwrvgnd_1
XTAP_TAPCELL_ROW_5_277 VGND VPWR sky130_fd_sc_hd__tapvpwrvgnd_1
XFILLER_18_318 VGND VGND VPWR VPWR sky130_fd_sc_hd__decap_3
XFILLER_58_498 VGND VGND VPWR VPWR sky130_fd_sc_hd__fill_1
XFILLER_14_502 VGND VGND VPWR VPWR sky130_fd_sc_hd__decap_3
XFILLER_26_351 VGND VGND VPWR VPWR sky130_fd_sc_hd__decap_3
XFILLER_14_83 VGND VGND VPWR VPWR sky130_fd_sc_hd__fill_1
XFILLER_30_60 VGND VGND VPWR VPWR sky130_fd_sc_hd__decap_3
XFILLER_39_80 VGND VGND VPWR VPWR sky130_fd_sc_hd__decap_3
XFILLER_49_476 VGND VGND VPWR VPWR sky130_fd_sc_hd__decap_3
XFILLER_76_273 VGND VGND VPWR VPWR sky130_fd_sc_hd__decap_3
XFILLER_17_340 VGND VGND VPWR VPWR sky130_fd_sc_hd__fill_1
XFILLER_32_332 VGND VGND VPWR VPWR sky130_fd_sc_hd__decap_3
X_3900_ _6367_/B2 _6662_/S _3899_/X VGND VGND VPWR VPWR _3900_/Y sky130_fd_sc_hd__a21oi_2
XFILLER_32_354 VGND VGND VPWR VPWR sky130_fd_sc_hd__decap_3
XFILLER_32_365 VGND VGND VPWR VPWR sky130_fd_sc_hd__decap_3
X_3831_ _3860_/A2 _3862_/A2 _3832_/B _3832_/C VGND VGND VPWR VPWR _3833_/A sky130_fd_sc_hd__o31a_2
XFILLER_20_527 VGND VGND VPWR VPWR sky130_fd_sc_hd__decap_3
XFILLER_32_387 VGND VGND VPWR VPWR sky130_fd_sc_hd__decap_3
X_3762_ _3756_/Y _4225_/A1 _4227_/B _4227_/D VGND VGND VPWR VPWR _3762_/Y sky130_fd_sc_hd__o22ai_2
X_5501_ _5501_/A0 _5684_/A1 _5513_/S VGND VGND VPWR VPWR _7185_/D sky130_fd_sc_hd__mux2_2
XTAP_TAPCELL_ROW_30_533 VGND VPWR sky130_fd_sc_hd__tapvpwrvgnd_1
X_6481_ _6479_/X _6480_/X _5765_/X VGND VGND VPWR VPWR _6481_/Y sky130_fd_sc_hd__a21oi_2
X_5363_ _5363_/A0 _5730_/A1 _5363_/S VGND VGND VPWR VPWR _7123_/D sky130_fd_sc_hd__mux2_2
XFILLER_99_354 VGND VGND VPWR VPWR sky130_fd_sc_hd__fill_1
X_7102_ _7243_/CLK _7102_/D VGND VGND VPWR VPWR _7102_/Q sky130_fd_sc_hd__dfxtp_2
X_4314_ _7582_/D _7581_/D _4399_/A1 _4396_/A _4315_/D VGND VGND VPWR VPWR _4314_/Y
+ sky130_fd_sc_hd__a311oi_2
X_7033_ _7290_/CLK _7033_/D VGND VGND VPWR VPWR _7033_/Q sky130_fd_sc_hd__dfxtp_2
X_4245_ _4245_/A _4245_/B VGND VGND VPWR VPWR _4245_/Y sky130_fd_sc_hd__nand2_2
X_4176_ _4176_/A1 _4176_/A2 _3887_/C _3887_/D VGND VGND VPWR VPWR _4176_/X sky130_fd_sc_hd__a211o_2
XFILLER_55_402 VGND VGND VPWR VPWR sky130_fd_sc_hd__fill_1
XFILLER_67_284 VGND VGND VPWR VPWR sky130_fd_sc_hd__fill_2
XTAP_TAPCELL_ROW_66_920 VGND VPWR sky130_fd_sc_hd__tapvpwrvgnd_1
XTAP_TAPCELL_ROW_38_622 VGND VPWR sky130_fd_sc_hd__tapvpwrvgnd_1
XTAP_TAPCELL_ROW_2_247 VGND VPWR sky130_fd_sc_hd__tapvpwrvgnd_1
XFILLER_23_321 VGND VGND VPWR VPWR sky130_fd_sc_hd__decap_3
XFILLER_35_181 VGND VGND VPWR VPWR sky130_fd_sc_hd__decap_3
XFILLER_82_298 VGND VGND VPWR VPWR sky130_fd_sc_hd__fill_1
XFILLER_50_151 VGND VGND VPWR VPWR sky130_fd_sc_hd__decap_3
XFILLER_50_173 VGND VGND VPWR VPWR sky130_fd_sc_hd__decap_3
XFILLER_51_48 VGND VGND VPWR VPWR sky130_fd_sc_hd__decap_3
X_6748_ _6128_/X _6748_/A1 _6765_/S VGND VGND VPWR VPWR _7534_/D sky130_fd_sc_hd__mux2_2
X_6679_ _6679_/A0 _6113_/X _6687_/S VGND VGND VPWR VPWR _7501_/D sky130_fd_sc_hd__mux2_2
XFILLER_76_45 VGND VGND VPWR VPWR sky130_fd_sc_hd__fill_1
XFILLER_18_115 VGND VGND VPWR VPWR sky130_fd_sc_hd__decap_3
XFILLER_58_262 VGND VGND VPWR VPWR sky130_fd_sc_hd__fill_2
XFILLER_58_273 VGND VGND VPWR VPWR sky130_fd_sc_hd__decap_3
XFILLER_86_593 VGND VGND VPWR VPWR sky130_fd_sc_hd__fill_2
XFILLER_18_159 VGND VGND VPWR VPWR sky130_fd_sc_hd__fill_1
XFILLER_73_298 VGND VGND VPWR VPWR sky130_fd_sc_hd__decap_3
XPHY_EDGE_ROW_1_Left_105 VGND VGND VPWR VPWR sky130_fd_sc_hd__decap_3
XFILLER_14_365 VGND VGND VPWR VPWR sky130_fd_sc_hd__decap_3
XTAP_TAPCELL_ROW_72_978 VGND VPWR sky130_fd_sc_hd__tapvpwrvgnd_1
XFILLER_25_93 VGND VGND VPWR VPWR sky130_fd_sc_hd__decap_3
XFILLER_41_162 VGND VGND VPWR VPWR sky130_fd_sc_hd__decap_3
Xplace1709 _4550_/S VGND VGND VPWR VPWR _4452_/S sky130_fd_sc_hd__buf_2
XFILLER_96_368 VGND VGND VPWR VPWR sky130_fd_sc_hd__decap_3
XPHY_EDGE_ROW_10_Right_10 VGND VGND VPWR VPWR sky130_fd_sc_hd__decap_3
X_4030_ _4036_/D _4030_/B VGND VGND VPWR VPWR _7587_/D sky130_fd_sc_hd__nor2_2
XFILLER_49_284 VGND VGND VPWR VPWR sky130_fd_sc_hd__decap_3
XFILLER_64_210 VGND VGND VPWR VPWR sky130_fd_sc_hd__fill_1
XFILLER_37_457 VGND VGND VPWR VPWR sky130_fd_sc_hd__decap_3
X_5981_ _6504_/B2 _7024_/Q _6940_/Q _5981_/B2 VGND VGND VPWR VPWR _5981_/X sky130_fd_sc_hd__o22a_2
Xclkbuf_leaf_44_clk clkbuf_leaf_0_clk/A VGND VGND VPWR VPWR clkload5/A sky130_fd_sc_hd__clkbuf_16
X_4932_ _4932_/A0 _5637_/A1 _4952_/S VGND VGND VPWR VPWR _6940_/D sky130_fd_sc_hd__mux2_2
XFILLER_17_192 VGND VGND VPWR VPWR sky130_fd_sc_hd__decap_3
XANTENNA_14 _7002_/Q VGND VGND VPWR VPWR sky130_fd_sc_hd__diode_2
XFILLER_20_324 VGND VGND VPWR VPWR sky130_fd_sc_hd__decap_3
XFILLER_32_162 VGND VGND VPWR VPWR sky130_fd_sc_hd__decap_3
X_6602_ _6602_/A0 _6078_/X _6607_/S VGND VGND VPWR VPWR _7465_/D sky130_fd_sc_hd__mux2_2
XANTENNA_25 _4815_/A0 VGND VGND VPWR VPWR sky130_fd_sc_hd__diode_2
XANTENNA_36 _5066_/A0 VGND VGND VPWR VPWR sky130_fd_sc_hd__diode_2
XANTENNA_47 _6862_/Q VGND VGND VPWR VPWR sky130_fd_sc_hd__diode_2
XFILLER_20_357 VGND VGND VPWR VPWR sky130_fd_sc_hd__decap_3
XFILLER_32_195 VGND VGND VPWR VPWR sky130_fd_sc_hd__fill_1
X_7582_ clkload2/A _7582_/D place2029/X VGND VGND VPWR VPWR _7582_/Q sky130_fd_sc_hd__dfrtp_2
X_4794_ _4794_/A0 _5684_/A1 _4808_/S VGND VGND VPWR VPWR _6877_/D sky130_fd_sc_hd__mux2_2
XTAP_TAPCELL_ROW_15_382 VGND VPWR sky130_fd_sc_hd__tapvpwrvgnd_1
X_6533_ _6533_/A0 _6113_/X _6541_/S VGND VGND VPWR VPWR _7437_/D sky130_fd_sc_hd__mux2_2
X_3745_ _7409_/Q _3576_/B _3576_/C _3909_/A2 _7537_/Q VGND VGND VPWR VPWR _3746_/C
+ sky130_fd_sc_hd__a32o_2
X_6464_ _6510_/A1 _6911_/Q _7247_/Q _6510_/B2 VGND VGND VPWR VPWR _6464_/X sky130_fd_sc_hd__o22a_2
XPHY_EDGE_ROW_65_Left_169 VGND VGND VPWR VPWR sky130_fd_sc_hd__decap_3
X_5415_ _5415_/A0 _5720_/A1 _5423_/S VGND VGND VPWR VPWR _7146_/D sky130_fd_sc_hd__mux2_2
X_3676_ _7542_/Q _3812_/A2 _3810_/B1 _7446_/Q VGND VGND VPWR VPWR _3676_/X sky130_fd_sc_hd__a22o_2
XTAP_TAPCELL_ROW_76_1026 VGND VPWR sky130_fd_sc_hd__tapvpwrvgnd_1
X_6395_ _6393_/X _6394_/X _6395_/B1 VGND VGND VPWR VPWR _6403_/B sky130_fd_sc_hd__a21oi_2
X_5346_ _5346_/A0 _5713_/A1 _5363_/S VGND VGND VPWR VPWR _7115_/D sky130_fd_sc_hd__mux2_2
Xhold2901 _7406_/Q VGND VGND VPWR VPWR _6380_/B2 sky130_fd_sc_hd__dlygate4sd3_1
Xhold2912 _6368_/X VGND VGND VPWR VPWR _7398_/D sky130_fd_sc_hd__dlygate4sd3_1
Xhold2923 _7475_/Q VGND VGND VPWR VPWR _6624_/A0 sky130_fd_sc_hd__dlygate4sd3_1
X_5277_ _5277_/A0 _5713_/A1 _5302_/S VGND VGND VPWR VPWR _7087_/D sky130_fd_sc_hd__mux2_2
Xhold2934 _7489_/Q VGND VGND VPWR VPWR _6653_/A0 sky130_fd_sc_hd__dlygate4sd3_1
Xhold2945 _7463_/Q VGND VGND VPWR VPWR _6598_/A0 sky130_fd_sc_hd__dlygate4sd3_1
Xhold2956 _6339_/X VGND VGND VPWR VPWR _7380_/D sky130_fd_sc_hd__dlygate4sd3_1
X_7016_ _7266_/CLK _7016_/D VGND VGND VPWR VPWR _7016_/Q sky130_fd_sc_hd__dfxtp_2
X_4228_ _4228_/A _4228_/B _4228_/C _4228_/D VGND VGND VPWR VPWR _6163_/B sky130_fd_sc_hd__nand4_2
XFILLER_101_167 VGND VGND VPWR VPWR sky130_fd_sc_hd__fill_1
XFILLER_28_424 VGND VGND VPWR VPWR sky130_fd_sc_hd__decap_3
Xhold2967 _7485_/Q VGND VGND VPWR VPWR _6356_/A1 sky130_fd_sc_hd__dlygate4sd3_1
Xhold2978 _7450_/Q VGND VGND VPWR VPWR _6569_/A0 sky130_fd_sc_hd__dlygate4sd3_1
Xhold2989 _7486_/Q VGND VGND VPWR VPWR _6357_/A1 sky130_fd_sc_hd__dlygate4sd3_1
XFILLER_28_457 VGND VGND VPWR VPWR sky130_fd_sc_hd__decap_3
XFILLER_46_26 VGND VGND VPWR VPWR sky130_fd_sc_hd__fill_2
XFILLER_55_210 VGND VGND VPWR VPWR sky130_fd_sc_hd__decap_3
XPHY_EDGE_ROW_74_Left_178 VGND VGND VPWR VPWR sky130_fd_sc_hd__decap_3
XTAP_TAPCELL_ROW_87_1133 VGND VPWR sky130_fd_sc_hd__tapvpwrvgnd_1
XFILLER_102_21 VGND VGND VPWR VPWR sky130_fd_sc_hd__decap_3
XFILLER_15_107 VGND VGND VPWR VPWR sky130_fd_sc_hd__decap_3
XFILLER_55_287 VGND VGND VPWR VPWR sky130_fd_sc_hd__decap_3
XFILLER_55_298 VGND VGND VPWR VPWR sky130_fd_sc_hd__decap_3
Xclkbuf_leaf_35_clk clkbuf_3_2__f_clk/X VGND VGND VPWR VPWR _7507_/CLK sky130_fd_sc_hd__clkbuf_16
XFILLER_23_151 VGND VGND VPWR VPWR sky130_fd_sc_hd__fill_2
XFILLER_23_162 VGND VGND VPWR VPWR sky130_fd_sc_hd__decap_3
XFILLER_70_279 VGND VGND VPWR VPWR sky130_fd_sc_hd__decap_3
XFILLER_11_324 VGND VGND VPWR VPWR sky130_fd_sc_hd__fill_2
XFILLER_11_335 VGND VGND VPWR VPWR sky130_fd_sc_hd__fill_1
XPHY_EDGE_ROW_83_Left_187 VGND VGND VPWR VPWR sky130_fd_sc_hd__decap_3
XTAP_TAPCELL_ROW_98_1251 VGND VPWR sky130_fd_sc_hd__tapvpwrvgnd_1
XFILLER_11_40 VGND VGND VPWR VPWR sky130_fd_sc_hd__decap_3
XFILLER_11_51 VGND VGND VPWR VPWR sky130_fd_sc_hd__decap_3
XFILLER_11_84 VGND VGND VPWR VPWR sky130_fd_sc_hd__decap_3
XFILLER_3_523 VGND VGND VPWR VPWR sky130_fd_sc_hd__fill_2
XFILLER_3_534 VGND VGND VPWR VPWR sky130_fd_sc_hd__fill_2
XFILLER_59_582 VGND VGND VPWR VPWR sky130_fd_sc_hd__fill_1
XTAP_TAPCELL_ROW_49_739 VGND VPWR sky130_fd_sc_hd__tapvpwrvgnd_1
XPHY_EDGE_ROW_92_Left_196 VGND VGND VPWR VPWR sky130_fd_sc_hd__decap_3
XFILLER_19_457 VGND VGND VPWR VPWR sky130_fd_sc_hd__decap_3
XFILLER_46_232 VGND VGND VPWR VPWR sky130_fd_sc_hd__decap_3
XFILLER_19_468 VGND VGND VPWR VPWR sky130_fd_sc_hd__decap_3
XFILLER_34_416 VGND VGND VPWR VPWR sky130_fd_sc_hd__decap_3
XFILLER_74_585 VGND VGND VPWR VPWR sky130_fd_sc_hd__decap_3
XFILLER_36_92 VGND VGND VPWR VPWR sky130_fd_sc_hd__decap_3
XFILLER_61_246 VGND VGND VPWR VPWR sky130_fd_sc_hd__decap_3
Xclkbuf_leaf_26_clk clkload1/A VGND VGND VPWR VPWR _7114_/CLK sky130_fd_sc_hd__clkbuf_16
XFILLER_14_151 VGND VGND VPWR VPWR sky130_fd_sc_hd__decap_3
XFILLER_42_460 VGND VGND VPWR VPWR sky130_fd_sc_hd__decap_3
XTAP_TAPCELL_ROW_12_352 VGND VPWR sky130_fd_sc_hd__tapvpwrvgnd_1
X_3530_ _3530_/A _3978_/B VGND VGND VPWR VPWR _3530_/Y sky130_fd_sc_hd__nand2_2
XFILLER_10_390 VGND VGND VPWR VPWR sky130_fd_sc_hd__decap_3
Xplace1506 _3818_/B VGND VGND VPWR VPWR _4563_/A2 sky130_fd_sc_hd__buf_2
Xplace1517 _3751_/Y VGND VGND VPWR VPWR _4711_/B1 sky130_fd_sc_hd__buf_2
Xplace1528 place1528/A VGND VGND VPWR VPWR _4263_/A3 sky130_fd_sc_hd__buf_2
Xplace1539 _6560_/B VGND VGND VPWR VPWR _6185_/B1 sky130_fd_sc_hd__buf_2
X_3461_ _3500_/B _3480_/B VGND VGND VPWR VPWR _3463_/A sky130_fd_sc_hd__or2_4
XFILLER_42_3 VGND VGND VPWR VPWR sky130_fd_sc_hd__fill_2
X_6180_ _6180_/A1 _6180_/A2 _3761_/C VGND VGND VPWR VPWR _6180_/X sky130_fd_sc_hd__a21o_2
X_5131_ _5131_/A0 _5709_/A1 _5146_/S VGND VGND VPWR VPWR _7029_/D sky130_fd_sc_hd__mux2_2
XFILLER_69_346 VGND VGND VPWR VPWR sky130_fd_sc_hd__fill_1
X_5062_ _5062_/A0 _5334_/A1 _5085_/S VGND VGND VPWR VPWR _6997_/D sky130_fd_sc_hd__mux2_2
XFILLER_25_405 VGND VGND VPWR VPWR sky130_fd_sc_hd__decap_3
XFILLER_16_29 VGND VGND VPWR VPWR sky130_fd_sc_hd__fill_1
XFILLER_25_449 VGND VGND VPWR VPWR sky130_fd_sc_hd__fill_1
XFILLER_80_533 VGND VGND VPWR VPWR sky130_fd_sc_hd__fill_2
XFILLER_18_490 VGND VGND VPWR VPWR sky130_fd_sc_hd__decap_3
Xclkbuf_leaf_17_clk clkbuf_3_6__f_clk/X VGND VGND VPWR VPWR _7264_/CLK sky130_fd_sc_hd__clkbuf_16
X_5895_ _6175_/A2 _7198_/Q _7142_/Q _6173_/B2 VGND VGND VPWR VPWR _5895_/X sky130_fd_sc_hd__o22a_2
X_4915_ _4915_/A0 _5376_/A1 _4952_/S VGND VGND VPWR VPWR _6932_/D sky130_fd_sc_hd__mux2_2
XFILLER_20_132 VGND VGND VPWR VPWR sky130_fd_sc_hd__decap_3
XTAP_TAPCELL_ROW_82_1085 VGND VPWR sky130_fd_sc_hd__tapvpwrvgnd_1
X_7565_ _7565_/CLK _7565_/D place2035/X VGND VGND VPWR VPWR _7565_/Q sky130_fd_sc_hd__dfrtp_2
XFILLER_20_187 VGND VGND VPWR VPWR sky130_fd_sc_hd__fill_1
X_6516_ _6516_/A0 _6515_/X _6569_/S VGND VGND VPWR VPWR _7429_/D sky130_fd_sc_hd__mux2_2
X_7496_ _7611_/CLK _7496_/D place2060/X VGND VGND VPWR VPWR _7496_/Q sky130_fd_sc_hd__dfrtp_2
X_3728_ _7319_/Q _3761_/B _3761_/C VGND VGND VPWR VPWR _3728_/X sky130_fd_sc_hd__and3_2
X_3659_ _7543_/Q _3893_/A2 _3907_/B1 _7415_/Q _3658_/X VGND VGND VPWR VPWR _3660_/A
+ sky130_fd_sc_hd__a221oi_4
Xoutput2072 place174/X VGND VGND VPWR VPWR result[11] sky130_fd_sc_hd__clkdlybuf4s25_1
XFILLER_0_515 VGND VGND VPWR VPWR sky130_fd_sc_hd__decap_3
Xoutput2083 _4223_/X VGND VGND VPWR VPWR result[21] sky130_fd_sc_hd__dlymetal6s2s_1
Xoutput2094 _4300_/X VGND VGND VPWR VPWR result[31] sky130_fd_sc_hd__buf_6
X_5329_ _5329_/A0 _5696_/A1 _5329_/S VGND VGND VPWR VPWR _7107_/D sky130_fd_sc_hd__mux2_2
XFILLER_0_559 VGND VGND VPWR VPWR sky130_fd_sc_hd__fill_1
XFILLER_87_121 VGND VGND VPWR VPWR sky130_fd_sc_hd__fill_2
Xhold2720 _7164_/Q VGND VGND VPWR VPWR _5454_/A0 sky130_fd_sc_hd__dlygate4sd3_1
Xhold2731 _7037_/Q VGND VGND VPWR VPWR _5148_/A0 sky130_fd_sc_hd__dlygate4sd3_1
XFILLER_75_316 VGND VGND VPWR VPWR sky130_fd_sc_hd__decap_3
Xhold2742 _7276_/Q VGND VGND VPWR VPWR _5698_/A0 sky130_fd_sc_hd__dlygate4sd3_1
Xhold2753 _7047_/Q VGND VGND VPWR VPWR _5171_/A0 sky130_fd_sc_hd__dlygate4sd3_1
Xhold2764 _7165_/Q VGND VGND VPWR VPWR _5457_/A0 sky130_fd_sc_hd__dlygate4sd3_1
XFILLER_75_349 VGND VGND VPWR VPWR sky130_fd_sc_hd__decap_3
Xhold2775 _7202_/Q VGND VGND VPWR VPWR _5537_/A0 sky130_fd_sc_hd__dlygate4sd3_1
Xhold2786 _7169_/Q VGND VGND VPWR VPWR _5465_/A0 sky130_fd_sc_hd__dlygate4sd3_1
Xhold2797 _7116_/Q VGND VGND VPWR VPWR _5348_/A0 sky130_fd_sc_hd__dlygate4sd3_1
XFILLER_28_265 VGND VGND VPWR VPWR sky130_fd_sc_hd__decap_3
XFILLER_71_500 VGND VGND VPWR VPWR sky130_fd_sc_hd__decap_3
XTAP_TAPCELL_ROW_46_709 VGND VPWR sky130_fd_sc_hd__tapvpwrvgnd_1
XFILLER_16_449 VGND VGND VPWR VPWR sky130_fd_sc_hd__decap_3
XFILLER_28_298 VGND VGND VPWR VPWR sky130_fd_sc_hd__fill_2
XFILLER_43_213 VGND VGND VPWR VPWR sky130_fd_sc_hd__decap_3
XFILLER_43_279 VGND VGND VPWR VPWR sky130_fd_sc_hd__fill_1
XTAP_TAPCELL_ROW_54_786 VGND VPWR sky130_fd_sc_hd__tapvpwrvgnd_1
XFILLER_11_110 VGND VGND VPWR VPWR sky130_fd_sc_hd__fill_2
XFILLER_11_132 VGND VGND VPWR VPWR sky130_fd_sc_hd__fill_2
XFILLER_51_290 VGND VGND VPWR VPWR sky130_fd_sc_hd__decap_3
XTAP_TAPCELL_ROW_26_499 VGND VPWR sky130_fd_sc_hd__tapvpwrvgnd_1
XFILLER_22_72 VGND VGND VPWR VPWR sky130_fd_sc_hd__fill_1
XFILLER_22_83 VGND VGND VPWR VPWR sky130_fd_sc_hd__fill_1
XFILLER_7_169 VGND VGND VPWR VPWR sky130_fd_sc_hd__decap_3
XFILLER_3_364 VGND VGND VPWR VPWR sky130_fd_sc_hd__decap_3
XFILLER_3_386 VGND VGND VPWR VPWR sky130_fd_sc_hd__decap_3
XFILLER_98_98 VGND VGND VPWR VPWR sky130_fd_sc_hd__fill_2
XFILLER_39_508 VGND VGND VPWR VPWR sky130_fd_sc_hd__fill_2
XFILLER_66_316 VGND VGND VPWR VPWR sky130_fd_sc_hd__decap_3
XFILLER_93_113 VGND VGND VPWR VPWR sky130_fd_sc_hd__decap_3
XFILLER_19_232 VGND VGND VPWR VPWR sky130_fd_sc_hd__fill_2
XFILLER_59_390 VGND VGND VPWR VPWR sky130_fd_sc_hd__fill_2
XFILLER_47_552 VGND VGND VPWR VPWR sky130_fd_sc_hd__decap_3
XFILLER_74_360 VGND VGND VPWR VPWR sky130_fd_sc_hd__decap_3
XFILLER_19_287 VGND VGND VPWR VPWR sky130_fd_sc_hd__decap_3
XFILLER_34_213 VGND VGND VPWR VPWR sky130_fd_sc_hd__decap_3
XTAP_TAPCELL_ROW_17_400 VGND VPWR sky130_fd_sc_hd__tapvpwrvgnd_1
XFILLER_42_290 VGND VGND VPWR VPWR sky130_fd_sc_hd__decap_3
X_4700_ _6331_/B2 _4707_/A2 _4707_/A3 _4699_/X VGND VGND VPWR VPWR _4700_/X sky130_fd_sc_hd__a31o_2
X_4631_ _4629_/X _6319_/B2 _4905_/A VGND VGND VPWR VPWR _4631_/X sky130_fd_sc_hd__mux2_2
XFILLER_8_85 VGND VGND VPWR VPWR sky130_fd_sc_hd__fill_2
Xplace2037 place2038/X VGND VGND VPWR VPWR place2037/X sky130_fd_sc_hd__buf_2
Xplace2026 place2031/X VGND VGND VPWR VPWR place2026/X sky130_fd_sc_hd__buf_2
Xplace2015 place2016/X VGND VGND VPWR VPWR place2015/X sky130_fd_sc_hd__buf_2
Xplace2004 _7292_/Q VGND VGND VPWR VPWR _3468_/A sky130_fd_sc_hd__buf_6
X_7350_ _7577_/CLK _7350_/D place2046/X VGND VGND VPWR VPWR _7350_/Q sky130_fd_sc_hd__dfrtp_2
X_4562_ _4562_/A1 _4477_/C _4561_/Y _4237_/D _4562_/D1 VGND VGND VPWR VPWR _4562_/X
+ sky130_fd_sc_hd__a2111o_2
XFILLER_6_180 VGND VGND VPWR VPWR sky130_fd_sc_hd__decap_3
Xplace1303 _4125_/A VGND VGND VPWR VPWR _4970_/D sky130_fd_sc_hd__buf_2
Xplace1314 _3742_/Y VGND VGND VPWR VPWR _4018_/D sky130_fd_sc_hd__buf_6
Xplace1325 place1326/X VGND VGND VPWR VPWR place1325/X sky130_fd_sc_hd__buf_8
Xplace2059 place2066/X VGND VGND VPWR VPWR place2059/X sky130_fd_sc_hd__buf_2
Xplace2048 place2069/X VGND VGND VPWR VPWR place2048/X sky130_fd_sc_hd__buf_2
X_7281_ _7407_/CLK _7281_/D VGND VGND VPWR VPWR _7281_/Q sky130_fd_sc_hd__dfxtp_2
X_4493_ _4503_/A _4503_/B _4503_/C _7310_/Q VGND VGND VPWR VPWR _4498_/A sky130_fd_sc_hd__or4b_2
X_3513_ _3826_/A _3524_/B _6302_/A _3513_/B1 VGND VGND VPWR VPWR _3514_/A sky130_fd_sc_hd__o31a_2
Xplace1336 _5984_/B1 VGND VGND VPWR VPWR _6456_/B2 sky130_fd_sc_hd__buf_6
Xplace1347 _4261_/X VGND VGND VPWR VPWR _6389_/B sky130_fd_sc_hd__buf_2
Xplace1358 _4098_/Y VGND VGND VPWR VPWR _5862_/A2 sky130_fd_sc_hd__buf_2
Xclkbuf_leaf_6_clk clkbuf_leaf_8_clk/A VGND VGND VPWR VPWR _7393_/CLK sky130_fd_sc_hd__clkbuf_16
X_3444_ _3444_/A _3480_/B _3444_/C VGND VGND VPWR VPWR _3445_/B sky130_fd_sc_hd__nand3_4
Xplace1369 _3916_/Y VGND VGND VPWR VPWR _4166_/A1 sky130_fd_sc_hd__buf_2
X_6163_ _6163_/A _6163_/B _6163_/C _6564_/D VGND VGND VPWR VPWR _6163_/X sky130_fd_sc_hd__and4_2
X_6094_ _6154_/A1 _7222_/Q _7138_/Q _6154_/B2 VGND VGND VPWR VPWR _6094_/X sky130_fd_sc_hd__o22a_2
X_5114_ _5114_/A0 _5692_/A1 _5118_/S VGND VGND VPWR VPWR _7021_/D sky130_fd_sc_hd__mux2_2
XFILLER_38_530 VGND VGND VPWR VPWR sky130_fd_sc_hd__fill_2
X_5045_ _5045_/A0 _5317_/A1 _5057_/S VGND VGND VPWR VPWR _6989_/D sky130_fd_sc_hd__mux2_2
XFILLER_53_500 VGND VGND VPWR VPWR sky130_fd_sc_hd__decap_3
XFILLER_38_585 VGND VGND VPWR VPWR sky130_fd_sc_hd__decap_3
XFILLER_65_393 VGND VGND VPWR VPWR sky130_fd_sc_hd__fill_1
XTAP_TAPCELL_ROW_84_1103 VGND VPWR sky130_fd_sc_hd__tapvpwrvgnd_1
XFILLER_25_257 VGND VGND VPWR VPWR sky130_fd_sc_hd__decap_3
XFILLER_53_544 VGND VGND VPWR VPWR sky130_fd_sc_hd__decap_3
X_6996_ _7241_/CLK _6996_/D VGND VGND VPWR VPWR _6996_/Q sky130_fd_sc_hd__dfxtp_2
XFILLER_25_268 VGND VGND VPWR VPWR sky130_fd_sc_hd__decap_3
XFILLER_33_290 VGND VGND VPWR VPWR sky130_fd_sc_hd__decap_3
XTAP_TAPCELL_ROW_51_756 VGND VPWR sky130_fd_sc_hd__tapvpwrvgnd_1
X_5878_ _6559_/B1 _4970_/B _4970_/C _7009_/Q _6186_/C1 VGND VGND VPWR VPWR _5878_/X
+ sky130_fd_sc_hd__a311o_2
XTAP_TAPCELL_ROW_23_469 VGND VPWR sky130_fd_sc_hd__tapvpwrvgnd_1
XFILLER_4_106 VGND VGND VPWR VPWR sky130_fd_sc_hd__decap_3
X_7548_ _7581_/CLK _7548_/D place2021/X VGND VGND VPWR VPWR _7548_/Q sky130_fd_sc_hd__dfrtp_2
XTAP_TAPCELL_ROW_95_1221 VGND VPWR sky130_fd_sc_hd__tapvpwrvgnd_1
X_7479_ _7514_/CLK _7479_/D place2041/X VGND VGND VPWR VPWR _7479_/Q sky130_fd_sc_hd__dfrtp_2
Xplace1881 _3446_/A VGND VGND VPWR VPWR _3571_/A1 sky130_fd_sc_hd__buf_2
Xplace1870 _6769_/S VGND VGND VPWR VPWR _6775_/S sky130_fd_sc_hd__buf_2
Xplace1892 _4473_/D VGND VGND VPWR VPWR _4022_/A sky130_fd_sc_hd__buf_2
XFILLER_48_327 VGND VGND VPWR VPWR sky130_fd_sc_hd__decap_3
XFILLER_75_113 VGND VGND VPWR VPWR sky130_fd_sc_hd__fill_1
Xhold2583 _7244_/Q VGND VGND VPWR VPWR _5629_/A0 sky130_fd_sc_hd__dlygate4sd3_1
Xhold2572 _6959_/Q VGND VGND VPWR VPWR _4979_/A0 sky130_fd_sc_hd__dlygate4sd3_1
Xhold2561 _6961_/Q VGND VGND VPWR VPWR _4984_/A0 sky130_fd_sc_hd__dlygate4sd3_1
Xhold2550 _6996_/Q VGND VGND VPWR VPWR _5059_/A0 sky130_fd_sc_hd__dlygate4sd3_1
XTAP_TAPCELL_ROW_59_845 VGND VPWR sky130_fd_sc_hd__tapvpwrvgnd_1
XFILLER_29_541 VGND VGND VPWR VPWR sky130_fd_sc_hd__decap_3
Xhold2594 _6872_/Q VGND VGND VPWR VPWR _4783_/A0 sky130_fd_sc_hd__dlygate4sd3_1
XFILLER_16_224 VGND VGND VPWR VPWR sky130_fd_sc_hd__decap_3
XFILLER_17_50 VGND VGND VPWR VPWR sky130_fd_sc_hd__decap_3
XFILLER_44_533 VGND VGND VPWR VPWR sky130_fd_sc_hd__decap_3
XFILLER_8_401 VGND VGND VPWR VPWR sky130_fd_sc_hd__fill_2
XFILLER_33_82 VGND VGND VPWR VPWR sky130_fd_sc_hd__decap_3
XTAP_TAPCELL_ROW_100_1269 VGND VPWR sky130_fd_sc_hd__tapvpwrvgnd_1
XFILLER_3_172 VGND VGND VPWR VPWR sky130_fd_sc_hd__fill_1
XFILLER_66_102 VGND VGND VPWR VPWR sky130_fd_sc_hd__decap_3
XFILLER_39_349 VGND VGND VPWR VPWR sky130_fd_sc_hd__fill_2
XFILLER_35_522 VGND VGND VPWR VPWR sky130_fd_sc_hd__decap_3
XFILLER_66_179 VGND VGND VPWR VPWR sky130_fd_sc_hd__decap_3
X_6850_ _7241_/CLK _6850_/D VGND VGND VPWR VPWR _6850_/Q sky130_fd_sc_hd__dfxtp_2
XFILLER_35_577 VGND VGND VPWR VPWR sky130_fd_sc_hd__decap_3
XPHY_EDGE_ROW_8_Right_8 VGND VGND VPWR VPWR sky130_fd_sc_hd__decap_3
X_6781_ _6789_/A _6781_/B VGND VGND VPWR VPWR _7549_/D sky130_fd_sc_hd__and2_2
X_5801_ _6483_/A1 _7045_/Q _6849_/Q _5981_/B2 VGND VGND VPWR VPWR _5801_/X sky130_fd_sc_hd__o22a_2
XFILLER_50_536 VGND VGND VPWR VPWR sky130_fd_sc_hd__decap_3
X_5732_ _7322_/Q _6710_/A1 _5732_/S VGND VGND VPWR VPWR _7322_/D sky130_fd_sc_hd__mux2_2
X_3993_ _7426_/Q _4009_/B1 _3993_/B1 _7394_/Q _3992_/X VGND VGND VPWR VPWR _3994_/B
+ sky130_fd_sc_hd__a221oi_2
X_5663_ _5663_/A0 _4757_/Y _5669_/S VGND VGND VPWR VPWR _7260_/D sky130_fd_sc_hd__mux2_2
XTAP_TAPCELL_ROW_20_428 VGND VPWR sky130_fd_sc_hd__tapvpwrvgnd_1
X_7402_ _7493_/CLK _7402_/D place2043/X VGND VGND VPWR VPWR _7402_/Q sky130_fd_sc_hd__dfrtp_2
X_4614_ _7364_/Q _6178_/A1 _5839_/B1 _4612_/X _4613_/X VGND VGND VPWR VPWR _4614_/X
+ sky130_fd_sc_hd__a32o_2
Xplace1100 _4235_/C VGND VGND VPWR VPWR _6546_/A3 sky130_fd_sc_hd__buf_2
X_7333_ _7565_/CLK _7333_/D place2015/X VGND VGND VPWR VPWR _7333_/Q sky130_fd_sc_hd__dfrtp_2
X_4545_ _4533_/A _7607_/D _4533_/D _4544_/Y VGND VGND VPWR VPWR _4545_/X sky130_fd_sc_hd__o31a_2
Xplace1111 _5353_/A1 VGND VGND VPWR VPWR _5720_/A1 sky130_fd_sc_hd__buf_2
Xplace1122 _4707_/X VGND VGND VPWR VPWR _5709_/A1 sky130_fd_sc_hd__buf_2
Xplace1133 _4644_/X VGND VGND VPWR VPWR _5446_/A1 sky130_fd_sc_hd__buf_2
Xrebuffer2112 _3444_/C VGND VGND VPWR VPWR _3409_/A sky130_fd_sc_hd__buf_8
Xplace1144 _4625_/X VGND VGND VPWR VPWR _5564_/A1 sky130_fd_sc_hd__buf_2
Xplace1155 _4631_/X VGND VGND VPWR VPWR _5688_/A1 sky130_fd_sc_hd__buf_2
Xplace1166 _5486_/S VGND VGND VPWR VPWR _5452_/S sky130_fd_sc_hd__buf_2
Xplace1177 _4639_/Y VGND VGND VPWR VPWR _4667_/A sky130_fd_sc_hd__buf_6
Xrebuffer2123 _5759_/B1 VGND VGND VPWR VPWR _4842_/A sky130_fd_sc_hd__buf_2
Xrebuffer2134 _4018_/D VGND VGND VPWR VPWR place1313/A sky130_fd_sc_hd__buf_2
Xrebuffer2145 _3628_/X VGND VGND VPWR VPWR _3857_/B1 sky130_fd_sc_hd__buf_6
Xrebuffer2156 _3563_/B VGND VGND VPWR VPWR _4394_/A sky130_fd_sc_hd__buf_2
X_7264_ _7264_/CLK _7264_/D VGND VGND VPWR VPWR _7264_/Q sky130_fd_sc_hd__dfxtp_2
X_4476_ _4571_/B1 _4475_/X _3805_/B VGND VGND VPWR VPWR _7306_/D sky130_fd_sc_hd__a21bo_2
XPHY_EDGE_ROW_39_Right_39 VGND VGND VPWR VPWR sky130_fd_sc_hd__decap_3
Xplace1188 _5302_/S VGND VGND VPWR VPWR _5230_/S sky130_fd_sc_hd__buf_2
Xplace1199 _4952_/S VGND VGND VPWR VPWR _4930_/S sky130_fd_sc_hd__buf_2
Xrebuffer2167 _3652_/B VGND VGND VPWR VPWR _3577_/A3 sky130_fd_sc_hd__buf_2
Xrebuffer2178 _3739_/Y VGND VGND VPWR VPWR place1460/A sky130_fd_sc_hd__buf_2
Xrebuffer2189 _4117_/A2 VGND VGND VPWR VPWR _4609_/A sky130_fd_sc_hd__buf_2
X_7195_ _7407_/CLK _7195_/D VGND VGND VPWR VPWR _7195_/Q sky130_fd_sc_hd__dfxtp_2
X_6215_ _6208_/X _6211_/X _6214_/X _6547_/A1 VGND VGND VPWR VPWR _6215_/X sky130_fd_sc_hd__a31o_2
XFILLER_38_27 VGND VGND VPWR VPWR sky130_fd_sc_hd__fill_1
X_6146_ _7085_/Q _6146_/A2 _6146_/B1 _7113_/Q _6145_/X VGND VGND VPWR VPWR _6146_/X
+ sky130_fd_sc_hd__o221a_2
XTAP_TAPCELL_ROW_90_1173 VGND VPWR sky130_fd_sc_hd__tapvpwrvgnd_1
XFILLER_57_113 VGND VGND VPWR VPWR sky130_fd_sc_hd__decap_3
XFILLER_57_135 VGND VGND VPWR VPWR sky130_fd_sc_hd__decap_3
XFILLER_57_157 VGND VGND VPWR VPWR sky130_fd_sc_hd__fill_1
X_6077_ _6077_/A1 _6161_/A2 _6515_/A1 _6076_/Y _5843_/X VGND VGND VPWR VPWR _6077_/X
+ sky130_fd_sc_hd__a221o_2
X_5028_ _5028_/A0 _5728_/A1 _5028_/S VGND VGND VPWR VPWR _6982_/D sky130_fd_sc_hd__mux2_2
XTAP_TAPCELL_ROW_56_815 VGND VPWR sky130_fd_sc_hd__tapvpwrvgnd_1
XTAP_TAPCELL_ROW_28_517 VGND VPWR sky130_fd_sc_hd__tapvpwrvgnd_1
XFILLER_26_533 VGND VGND VPWR VPWR sky130_fd_sc_hd__decap_3
XFILLER_26_555 VGND VGND VPWR VPWR sky130_fd_sc_hd__fill_2
XFILLER_13_216 VGND VGND VPWR VPWR sky130_fd_sc_hd__decap_3
XFILLER_13_249 VGND VGND VPWR VPWR sky130_fd_sc_hd__decap_3
XFILLER_41_558 VGND VGND VPWR VPWR sky130_fd_sc_hd__fill_2
XPHY_EDGE_ROW_48_Right_48 VGND VGND VPWR VPWR sky130_fd_sc_hd__decap_3
X_6979_ _7287_/CLK _6979_/D VGND VGND VPWR VPWR _6979_/Q sky130_fd_sc_hd__dfxtp_2
XTAP_TAPCELL_ROW_64_892 VGND VPWR sky130_fd_sc_hd__tapvpwrvgnd_1
XFILLER_21_260 VGND VGND VPWR VPWR sky130_fd_sc_hd__decap_3
XPHY_EDGE_ROW_57_Right_57 VGND VGND VPWR VPWR sky130_fd_sc_hd__decap_3
XFILLER_76_400 VGND VGND VPWR VPWR sky130_fd_sc_hd__fill_2
XFILLER_0_197 VGND VGND VPWR VPWR sky130_fd_sc_hd__fill_1
XFILLER_48_124 VGND VGND VPWR VPWR sky130_fd_sc_hd__decap_3
XFILLER_95_44 VGND VGND VPWR VPWR sky130_fd_sc_hd__fill_2
XFILLER_95_55 VGND VGND VPWR VPWR sky130_fd_sc_hd__fill_1
XFILLER_95_66 VGND VGND VPWR VPWR sky130_fd_sc_hd__fill_1
XFILLER_76_477 VGND VGND VPWR VPWR sky130_fd_sc_hd__decap_3
Xhold2391 _7173_/Q VGND VGND VPWR VPWR _5474_/A0 sky130_fd_sc_hd__dlygate4sd3_1
Xhold2380 _7283_/Q VGND VGND VPWR VPWR _5713_/A0 sky130_fd_sc_hd__dlygate4sd3_1
XFILLER_17_500 VGND VGND VPWR VPWR sky130_fd_sc_hd__decap_3
XFILLER_28_82 VGND VGND VPWR VPWR sky130_fd_sc_hd__fill_2
XFILLER_44_330 VGND VGND VPWR VPWR sky130_fd_sc_hd__decap_3
XPHY_EDGE_ROW_66_Right_66 VGND VGND VPWR VPWR sky130_fd_sc_hd__decap_3
XFILLER_32_558 VGND VGND VPWR VPWR sky130_fd_sc_hd__decap_3
XFILLER_44_70 VGND VGND VPWR VPWR sky130_fd_sc_hd__decap_3
XFILLER_40_580 VGND VGND VPWR VPWR sky130_fd_sc_hd__decap_3
XFILLER_8_253 VGND VGND VPWR VPWR sky130_fd_sc_hd__decap_3
XFILLER_8_264 VGND VGND VPWR VPWR sky130_fd_sc_hd__decap_3
XPHY_EDGE_ROW_75_Right_75 VGND VGND VPWR VPWR sky130_fd_sc_hd__decap_3
XFILLER_5_53 VGND VGND VPWR VPWR sky130_fd_sc_hd__decap_3
X_4261_ _4261_/A _4274_/A _4261_/C _3682_/X VGND VGND VPWR VPWR _4261_/X sky130_fd_sc_hd__or4b_4
X_6000_ _6168_/B2 _7039_/Q _6955_/Q _6171_/A2 VGND VGND VPWR VPWR _6000_/X sky130_fd_sc_hd__o22a_2
XFILLER_39_113 VGND VGND VPWR VPWR sky130_fd_sc_hd__fill_1
X_4192_ _4192_/A _4192_/B _4192_/C VGND VGND VPWR VPWR _4192_/X sky130_fd_sc_hd__or3_4
XFILLER_27_308 VGND VGND VPWR VPWR sky130_fd_sc_hd__decap_3
XFILLER_54_127 VGND VGND VPWR VPWR sky130_fd_sc_hd__fill_2
XPHY_EDGE_ROW_84_Right_84 VGND VGND VPWR VPWR sky130_fd_sc_hd__decap_3
XFILLER_47_190 VGND VGND VPWR VPWR sky130_fd_sc_hd__decap_3
XFILLER_70_609 VGND VGND VPWR VPWR sky130_fd_sc_hd__decap_3
X_6902_ _7393_/CLK _6902_/D VGND VGND VPWR VPWR _6902_/Q sky130_fd_sc_hd__dfxtp_2
XFILLER_23_536 VGND VGND VPWR VPWR sky130_fd_sc_hd__decap_3
XFILLER_24_29 VGND VGND VPWR VPWR sky130_fd_sc_hd__fill_1
XFILLER_35_396 VGND VGND VPWR VPWR sky130_fd_sc_hd__decap_3
XFILLER_50_355 VGND VGND VPWR VPWR sky130_fd_sc_hd__decap_3
X_3976_ _4144_/A _4144_/B _4396_/A VGND VGND VPWR VPWR _4094_/A sky130_fd_sc_hd__a21oi_4
XTAP_TAPCELL_ROW_61_862 VGND VPWR sky130_fd_sc_hd__tapvpwrvgnd_1
XFILLER_10_208 VGND VGND VPWR VPWR sky130_fd_sc_hd__decap_3
X_5715_ _5715_/A0 _5715_/A1 _5730_/S VGND VGND VPWR VPWR _7284_/D sky130_fd_sc_hd__mux2_2
X_5646_ _5646_/A0 _4700_/X _5654_/S VGND VGND VPWR VPWR _7252_/D sky130_fd_sc_hd__mux2_2
XTAP_TAPCELL_ROW_79_1057 VGND VPWR sky130_fd_sc_hd__tapvpwrvgnd_1
XPHY_EDGE_ROW_93_Right_93 VGND VGND VPWR VPWR sky130_fd_sc_hd__decap_3
X_7316_ _7606_/CLK _7316_/D place2051/X VGND VGND VPWR VPWR _7316_/Q sky130_fd_sc_hd__dfrtp_2
X_4528_ _4071_/A _4071_/B _4538_/S _4527_/Y VGND VGND VPWR VPWR _4528_/X sky130_fd_sc_hd__a31o_2
X_7247_ _7247_/CLK _7247_/D VGND VGND VPWR VPWR _7247_/Q sky130_fd_sc_hd__dfxtp_2
X_4459_ _4561_/A1 _4448_/X _4461_/A VGND VGND VPWR VPWR _4564_/A sky130_fd_sc_hd__a21oi_2
XFILLER_58_411 VGND VGND VPWR VPWR sky130_fd_sc_hd__fill_2
X_7178_ _7289_/CLK _7178_/D VGND VGND VPWR VPWR _7178_/Q sky130_fd_sc_hd__dfxtp_2
X_6129_ _6390_/A1 _7056_/Q _6860_/Q _6390_/B2 VGND VGND VPWR VPWR _6129_/X sky130_fd_sc_hd__o22a_2
XTAP_TAPCELL_ROW_69_951 VGND VPWR sky130_fd_sc_hd__tapvpwrvgnd_1
XTAP_TAPCELL_ROW_5_278 VGND VPWR sky130_fd_sc_hd__tapvpwrvgnd_1
XFILLER_45_116 VGND VGND VPWR VPWR sky130_fd_sc_hd__decap_3
XFILLER_38_190 VGND VGND VPWR VPWR sky130_fd_sc_hd__fill_2
XFILLER_26_374 VGND VGND VPWR VPWR sky130_fd_sc_hd__fill_2
XFILLER_14_536 VGND VGND VPWR VPWR sky130_fd_sc_hd__decap_3
XFILLER_41_366 VGND VGND VPWR VPWR sky130_fd_sc_hd__decap_3
XFILLER_14_62 VGND VGND VPWR VPWR sky130_fd_sc_hd__decap_3
XFILLER_49_400 VGND VGND VPWR VPWR sky130_fd_sc_hd__decap_3
XFILLER_68_208 VGND VGND VPWR VPWR sky130_fd_sc_hd__decap_3
XFILLER_39_92 VGND VGND VPWR VPWR sky130_fd_sc_hd__fill_1
XFILLER_91_211 VGND VGND VPWR VPWR sky130_fd_sc_hd__fill_1
XFILLER_29_190 VGND VGND VPWR VPWR sky130_fd_sc_hd__decap_3
XFILLER_32_300 VGND VGND VPWR VPWR sky130_fd_sc_hd__decap_3
X_3830_ _7307_/Q _3860_/A2 _3829_/Y VGND VGND VPWR VPWR _3832_/C sky130_fd_sc_hd__a21oi_4
XFILLER_20_539 VGND VGND VPWR VPWR sky130_fd_sc_hd__decap_3
X_3761_ _7312_/Q _3761_/B _3761_/C VGND VGND VPWR VPWR _4227_/B sky130_fd_sc_hd__and3_2
XTAP_TAPCELL_ROW_30_534 VGND VPWR sky130_fd_sc_hd__tapvpwrvgnd_1
XFILLER_72_3 VGND VGND VPWR VPWR sky130_fd_sc_hd__fill_1
X_6480_ _6484_/A2 _6875_/Q _7267_/Q _6480_/B2 VGND VGND VPWR VPWR _6480_/X sky130_fd_sc_hd__o22a_2
X_3692_ _7483_/Q _3769_/B1 _3907_/B1 _7419_/Q VGND VGND VPWR VPWR _3695_/A sky130_fd_sc_hd__a22oi_2
X_5431_ _5431_/A0 _5614_/A1 _5454_/S VGND VGND VPWR VPWR _7153_/D sky130_fd_sc_hd__mux2_2
XFILLER_99_333 VGND VGND VPWR VPWR sky130_fd_sc_hd__decap_3
X_7101_ _7243_/CLK _7101_/D VGND VGND VPWR VPWR _7101_/Q sky130_fd_sc_hd__dfxtp_2
X_4313_ _7322_/Q _4313_/B _4313_/C VGND VGND VPWR VPWR _4315_/D sky130_fd_sc_hd__and3_2
X_7032_ _7235_/CLK _7032_/D VGND VGND VPWR VPWR _7032_/Q sky130_fd_sc_hd__dfxtp_2
X_5293_ _5293_/A0 _5357_/A1 _5293_/S VGND VGND VPWR VPWR _7092_/D sky130_fd_sc_hd__mux2_2
X_4244_ _4745_/A2 _4253_/A _4244_/B1 _4567_/B VGND VGND VPWR VPWR _4245_/B sky130_fd_sc_hd__o22ai_2
XFILLER_28_606 VGND VGND VPWR VPWR sky130_fd_sc_hd__decap_3
XFILLER_67_274 VGND VGND VPWR VPWR sky130_fd_sc_hd__fill_2
XTAP_TAPCELL_ROW_66_921 VGND VPWR sky130_fd_sc_hd__tapvpwrvgnd_1
XFILLER_55_458 VGND VGND VPWR VPWR sky130_fd_sc_hd__fill_1
XTAP_TAPCELL_ROW_38_623 VGND VPWR sky130_fd_sc_hd__tapvpwrvgnd_1
XTAP_TAPCELL_ROW_2_248 VGND VPWR sky130_fd_sc_hd__tapvpwrvgnd_1
XFILLER_43_609 VGND VGND VPWR VPWR sky130_fd_sc_hd__decap_3
XFILLER_70_439 VGND VGND VPWR VPWR sky130_fd_sc_hd__fill_2
XFILLER_23_366 VGND VGND VPWR VPWR sky130_fd_sc_hd__decap_3
XFILLER_35_193 VGND VGND VPWR VPWR sky130_fd_sc_hd__decap_3
X_6816_ _6842_/A _6816_/B VGND VGND VPWR VPWR _7566_/D sky130_fd_sc_hd__and2_2
XFILLER_50_163 VGND VGND VPWR VPWR sky130_fd_sc_hd__fill_2
X_3959_ _3959_/A1 _3999_/B1 _4395_/A1 _4098_/A2 VGND VGND VPWR VPWR _4579_/B sky130_fd_sc_hd__a211o_4
X_5629_ _5629_/A0 _5690_/A1 _5635_/S VGND VGND VPWR VPWR _7244_/D sky130_fd_sc_hd__mux2_2
XFILLER_2_226 VGND VGND VPWR VPWR sky130_fd_sc_hd__decap_3
XFILLER_4_6 VGND VGND VPWR VPWR sky130_fd_sc_hd__decap_3
XFILLER_100_371 VGND VGND VPWR VPWR sky130_fd_sc_hd__fill_1
XFILLER_18_127 VGND VGND VPWR VPWR sky130_fd_sc_hd__fill_2
XFILLER_46_447 VGND VGND VPWR VPWR sky130_fd_sc_hd__decap_3
XFILLER_58_296 VGND VGND VPWR VPWR sky130_fd_sc_hd__decap_3
XFILLER_73_222 VGND VGND VPWR VPWR sky130_fd_sc_hd__fill_2
XFILLER_34_609 VGND VGND VPWR VPWR sky130_fd_sc_hd__decap_3
XFILLER_73_277 VGND VGND VPWR VPWR sky130_fd_sc_hd__decap_3
XFILLER_26_182 VGND VGND VPWR VPWR sky130_fd_sc_hd__decap_3
XFILLER_25_72 VGND VGND VPWR VPWR sky130_fd_sc_hd__decap_3
XTAP_TAPCELL_ROW_72_979 VGND VPWR sky130_fd_sc_hd__tapvpwrvgnd_1
XFILLER_41_185 VGND VGND VPWR VPWR sky130_fd_sc_hd__decap_3
XFILLER_6_576 VGND VGND VPWR VPWR sky130_fd_sc_hd__decap_3
XFILLER_69_517 VGND VGND VPWR VPWR sky130_fd_sc_hd__fill_1
XPHY_EDGE_ROW_102_Left_206 VGND VGND VPWR VPWR sky130_fd_sc_hd__decap_3
XFILLER_2_32 VGND VGND VPWR VPWR sky130_fd_sc_hd__fill_1
XFILLER_49_274 VGND VGND VPWR VPWR sky130_fd_sc_hd__decap_3
XFILLER_37_436 VGND VGND VPWR VPWR sky130_fd_sc_hd__decap_3
XFILLER_37_447 VGND VGND VPWR VPWR sky130_fd_sc_hd__fill_1
XFILLER_92_531 VGND VGND VPWR VPWR sky130_fd_sc_hd__fill_1
XFILLER_92_542 VGND VGND VPWR VPWR sky130_fd_sc_hd__decap_3
X_5980_ _5980_/A1 _6996_/Q _6968_/Q _6483_/A1 VGND VGND VPWR VPWR _5980_/X sky130_fd_sc_hd__o22a_2
XFILLER_32_141 VGND VGND VPWR VPWR sky130_fd_sc_hd__decap_3
X_4862_ _4862_/A0 _5690_/A1 _4868_/S VGND VGND VPWR VPWR _6908_/D sky130_fd_sc_hd__mux2_2
X_3813_ _3813_/A _3813_/B _3813_/C VGND VGND VPWR VPWR _3818_/B sky130_fd_sc_hd__nand3_2
XTAP_TAPCELL_ROW_43_670 VGND VPWR sky130_fd_sc_hd__tapvpwrvgnd_1
XANTENNA_15 _7054_/Q VGND VGND VPWR VPWR sky130_fd_sc_hd__diode_2
XANTENNA_26 _5274_/A0 VGND VGND VPWR VPWR sky130_fd_sc_hd__diode_2
XANTENNA_37 clk VGND VGND VPWR VPWR sky130_fd_sc_hd__diode_2
XANTENNA_48 _6970_/Q VGND VGND VPWR VPWR sky130_fd_sc_hd__diode_2
XFILLER_20_336 VGND VGND VPWR VPWR sky130_fd_sc_hd__decap_3
X_7581_ _7581_/CLK _7581_/D place2024/X VGND VGND VPWR VPWR _7581_/Q sky130_fd_sc_hd__dfrtp_2
XTAP_TAPCELL_ROW_15_383 VGND VPWR sky130_fd_sc_hd__tapvpwrvgnd_1
X_3744_ _3836_/A1 _3903_/A2 _7505_/Q _3855_/A2 _7377_/Q VGND VGND VPWR VPWR _3746_/B
+ sky130_fd_sc_hd__a32o_2
X_6463_ _7191_/Q _6468_/A2 _6510_/A1 _7219_/Q _6462_/X VGND VGND VPWR VPWR _6463_/X
+ sky130_fd_sc_hd__o221a_2
X_3675_ _7414_/Q _6704_/S _3674_/X VGND VGND VPWR VPWR _4261_/C sky130_fd_sc_hd__a21oi_2
XTAP_TAPCELL_ROW_76_1016 VGND VPWR sky130_fd_sc_hd__tapvpwrvgnd_1
X_6394_ _6394_/A1 _7204_/Q _7176_/Q _6401_/B2 VGND VGND VPWR VPWR _6394_/X sky130_fd_sc_hd__o22a_2
XFILLER_99_130 VGND VGND VPWR VPWR sky130_fd_sc_hd__decap_3
XFILLER_101_113 VGND VGND VPWR VPWR sky130_fd_sc_hd__decap_3
XFILLER_99_185 VGND VGND VPWR VPWR sky130_fd_sc_hd__decap_3
Xhold2902 _7478_/Q VGND VGND VPWR VPWR _6630_/A0 sky130_fd_sc_hd__dlygate4sd3_1
Xhold2913 _7471_/Q VGND VGND VPWR VPWR _6615_/A0 sky130_fd_sc_hd__dlygate4sd3_1
XFILLER_68_550 VGND VGND VPWR VPWR sky130_fd_sc_hd__fill_2
Xhold2924 _7473_/Q VGND VGND VPWR VPWR _6619_/A0 sky130_fd_sc_hd__dlygate4sd3_1
Xhold2935 _6360_/X VGND VGND VPWR VPWR _7393_/D sky130_fd_sc_hd__dlygate4sd3_1
Xhold2946 _7495_/Q VGND VGND VPWR VPWR _6369_/A1 sky130_fd_sc_hd__dlygate4sd3_1
Xhold2957 _7452_/Q VGND VGND VPWR VPWR _6575_/A0 sky130_fd_sc_hd__dlygate4sd3_1
X_7015_ _7266_/CLK _7015_/D VGND VGND VPWR VPWR _7015_/Q sky130_fd_sc_hd__dfxtp_2
X_4227_ _4261_/A _4227_/B _4232_/B _4227_/D VGND VGND VPWR VPWR _4227_/X sky130_fd_sc_hd__or4_2
Xhold2968 _7460_/Q VGND VGND VPWR VPWR _6592_/A0 sky130_fd_sc_hd__dlygate4sd3_1
Xhold2979 _7377_/Q VGND VGND VPWR VPWR _6333_/B2 sky130_fd_sc_hd__dlygate4sd3_1
XFILLER_28_436 VGND VGND VPWR VPWR sky130_fd_sc_hd__fill_2
X_4158_ _3920_/B _3946_/B _4403_/B1 _3905_/C _4154_/Y VGND VGND VPWR VPWR _4158_/Y
+ sky130_fd_sc_hd__o41ai_2
XTAP_TAPCELL_ROW_87_1134 VGND VPWR sky130_fd_sc_hd__tapvpwrvgnd_1
XFILLER_28_469 VGND VGND VPWR VPWR sky130_fd_sc_hd__fill_2
X_4089_ _4089_/A _4091_/B VGND VGND VPWR VPWR _7610_/D sky130_fd_sc_hd__and2_2
XFILLER_102_44 VGND VGND VPWR VPWR sky130_fd_sc_hd__fill_1
XFILLER_36_480 VGND VGND VPWR VPWR sky130_fd_sc_hd__decap_3
XFILLER_43_428 VGND VGND VPWR VPWR sky130_fd_sc_hd__decap_3
XFILLER_36_491 VGND VGND VPWR VPWR sky130_fd_sc_hd__decap_3
XFILLER_51_461 VGND VGND VPWR VPWR sky130_fd_sc_hd__fill_1
XFILLER_51_483 VGND VGND VPWR VPWR sky130_fd_sc_hd__decap_3
XFILLER_23_196 VGND VGND VPWR VPWR sky130_fd_sc_hd__decap_3
XFILLER_7_318 VGND VGND VPWR VPWR sky130_fd_sc_hd__decap_3
XTAP_TAPCELL_ROW_98_1252 VGND VPWR sky130_fd_sc_hd__tapvpwrvgnd_1
XFILLER_11_63 VGND VGND VPWR VPWR sky130_fd_sc_hd__decap_3
XFILLER_19_447 VGND VGND VPWR VPWR sky130_fd_sc_hd__fill_1
XFILLER_74_531 VGND VGND VPWR VPWR sky130_fd_sc_hd__fill_1
XFILLER_34_406 VGND VGND VPWR VPWR sky130_fd_sc_hd__fill_1
XFILLER_36_71 VGND VGND VPWR VPWR sky130_fd_sc_hd__decap_3
XFILLER_46_299 VGND VGND VPWR VPWR sky130_fd_sc_hd__decap_3
XFILLER_61_225 VGND VGND VPWR VPWR sky130_fd_sc_hd__decap_3
XFILLER_14_130 VGND VGND VPWR VPWR sky130_fd_sc_hd__decap_3
XFILLER_42_472 VGND VGND VPWR VPWR sky130_fd_sc_hd__decap_3
XTAP_TAPCELL_ROW_40_640 VGND VPWR sky130_fd_sc_hd__tapvpwrvgnd_1
XTAP_TAPCELL_ROW_12_353 VGND VPWR sky130_fd_sc_hd__tapvpwrvgnd_1
XFILLER_6_351 VGND VGND VPWR VPWR sky130_fd_sc_hd__decap_3
Xplace1507 _3805_/Y VGND VGND VPWR VPWR _4566_/A2 sky130_fd_sc_hd__buf_2
XFILLER_6_395 VGND VGND VPWR VPWR sky130_fd_sc_hd__decap_3
Xplace1518 _3746_/X VGND VGND VPWR VPWR _4561_/B1 sky130_fd_sc_hd__buf_2
Xplace1529 _4253_/C VGND VGND VPWR VPWR _4738_/A2 sky130_fd_sc_hd__buf_2
X_3460_ _3460_/A _3508_/C VGND VGND VPWR VPWR _3460_/Y sky130_fd_sc_hd__nand2_2
XFILLER_35_3 VGND VGND VPWR VPWR sky130_fd_sc_hd__fill_1
XFILLER_96_177 VGND VGND VPWR VPWR sky130_fd_sc_hd__fill_1
X_4012_ _4012_/A1 _4005_/X _4011_/Y _4012_/C1 VGND VGND VPWR VPWR _4012_/Y sky130_fd_sc_hd__o211ai_2
XFILLER_65_531 VGND VGND VPWR VPWR sky130_fd_sc_hd__decap_3
XFILLER_37_266 VGND VGND VPWR VPWR sky130_fd_sc_hd__decap_3
XFILLER_18_480 VGND VGND VPWR VPWR sky130_fd_sc_hd__decap_3
XFILLER_25_428 VGND VGND VPWR VPWR sky130_fd_sc_hd__decap_3
XFILLER_52_214 VGND VGND VPWR VPWR sky130_fd_sc_hd__fill_2
XFILLER_21_601 VGND VGND VPWR VPWR sky130_fd_sc_hd__decap_3
XFILLER_33_461 VGND VGND VPWR VPWR sky130_fd_sc_hd__decap_3
XFILLER_80_578 VGND VGND VPWR VPWR sky130_fd_sc_hd__fill_1
XFILLER_80_589 VGND VGND VPWR VPWR sky130_fd_sc_hd__decap_3
X_5894_ _7086_/Q _6136_/A2 _6146_/B1 _7114_/Q _5893_/X VGND VGND VPWR VPWR _5894_/X
+ sky130_fd_sc_hd__o221a_2
XFILLER_33_494 VGND VGND VPWR VPWR sky130_fd_sc_hd__fill_1
X_4845_ _4845_/A0 _5673_/A1 _4870_/S VGND VGND VPWR VPWR _6900_/D sky130_fd_sc_hd__mux2_2
XTAP_TAPCELL_ROW_82_1086 VGND VPWR sky130_fd_sc_hd__tapvpwrvgnd_1
XFILLER_20_166 VGND VGND VPWR VPWR sky130_fd_sc_hd__decap_3
X_7564_ _7579_/CLK _7564_/D place2014/X VGND VGND VPWR VPWR _7564_/Q sky130_fd_sc_hd__dfrtp_2
X_4776_ _4776_/A0 _5730_/A1 _4776_/S VGND VGND VPWR VPWR _6871_/D sky130_fd_sc_hd__mux2_2
X_6515_ _6515_/A1 _6513_/X _6515_/A3 _6514_/X VGND VGND VPWR VPWR _6515_/X sky130_fd_sc_hd__a31o_2
X_3727_ _4287_/A _4287_/B _4287_/C VGND VGND VPWR VPWR _3727_/Y sky130_fd_sc_hd__nand3_2
X_7495_ clkload4/A _7495_/D place2060/X VGND VGND VPWR VPWR _7495_/Q sky130_fd_sc_hd__dfrtp_2
X_6446_ _6446_/A0 _5942_/Y _6497_/S VGND VGND VPWR VPWR _7425_/D sky130_fd_sc_hd__mux2_2
X_3658_ _6376_/A2 _3817_/A3 _7383_/Q _3769_/B1 _7479_/Q VGND VGND VPWR VPWR _3658_/X
+ sky130_fd_sc_hd__a32o_2
Xoutput2073 _4174_/X VGND VGND VPWR VPWR result[12] sky130_fd_sc_hd__clkdlybuf4s25_1
XFILLER_0_527 VGND VGND VPWR VPWR sky130_fd_sc_hd__decap_3
Xoutput2084 _4230_/X VGND VGND VPWR VPWR result[22] sky130_fd_sc_hd__dlymetal6s4s_1
Xoutput2095 _4125_/Y VGND VGND VPWR VPWR result[3] sky130_fd_sc_hd__clkdlybuf4s25_1
Xhold2710 _7055_/Q VGND VGND VPWR VPWR _5188_/A0 sky130_fd_sc_hd__dlygate4sd3_1
Xhold2721 _7196_/Q VGND VGND VPWR VPWR _5524_/A0 sky130_fd_sc_hd__dlygate4sd3_1
Xhold2732 _6958_/Q VGND VGND VPWR VPWR _4977_/A0 sky130_fd_sc_hd__dlygate4sd3_1
XFILLER_102_477 VGND VGND VPWR VPWR sky130_fd_sc_hd__fill_2
Xhold2743 _7191_/Q VGND VGND VPWR VPWR _5513_/A0 sky130_fd_sc_hd__dlygate4sd3_1
Xhold2754 _7230_/Q VGND VGND VPWR VPWR _5598_/A0 sky130_fd_sc_hd__dlygate4sd3_1
Xhold2765 _7160_/Q VGND VGND VPWR VPWR _5446_/A0 sky130_fd_sc_hd__dlygate4sd3_1
X_5259_ _5259_/A0 _5334_/A1 _5293_/S VGND VGND VPWR VPWR _7081_/D sky130_fd_sc_hd__mux2_2
XFILLER_28_200 VGND VGND VPWR VPWR sky130_fd_sc_hd__decap_3
Xhold2776 _7221_/Q VGND VGND VPWR VPWR _5579_/A0 sky130_fd_sc_hd__dlygate4sd3_1
Xhold2787 _6987_/Q VGND VGND VPWR VPWR _5040_/A0 sky130_fd_sc_hd__dlygate4sd3_1
Xhold2798 _6864_/Q VGND VGND VPWR VPWR _4730_/A0 sky130_fd_sc_hd__dlygate4sd3_1
XFILLER_90_309 VGND VGND VPWR VPWR sky130_fd_sc_hd__fill_2
XFILLER_28_277 VGND VGND VPWR VPWR sky130_fd_sc_hd__decap_3
XFILLER_43_225 VGND VGND VPWR VPWR sky130_fd_sc_hd__decap_3
XFILLER_56_586 VGND VGND VPWR VPWR sky130_fd_sc_hd__fill_2
XFILLER_31_409 VGND VGND VPWR VPWR sky130_fd_sc_hd__fill_2
XTAP_TAPCELL_ROW_54_787 VGND VPWR sky130_fd_sc_hd__tapvpwrvgnd_1
XFILLER_11_144 VGND VGND VPWR VPWR sky130_fd_sc_hd__decap_3
XFILLER_11_166 VGND VGND VPWR VPWR sky130_fd_sc_hd__fill_2
XFILLER_22_51 VGND VGND VPWR VPWR sky130_fd_sc_hd__fill_2
XFILLER_7_137 VGND VGND VPWR VPWR sky130_fd_sc_hd__decap_3
XFILLER_3_321 VGND VGND VPWR VPWR sky130_fd_sc_hd__decap_3
XFILLER_3_343 VGND VGND VPWR VPWR sky130_fd_sc_hd__fill_2
XFILLER_66_339 VGND VGND VPWR VPWR sky130_fd_sc_hd__decap_3
XTAP_TAPCELL_ROW_17_401 VGND VPWR sky130_fd_sc_hd__tapvpwrvgnd_1
XFILLER_30_431 VGND VGND VPWR VPWR sky130_fd_sc_hd__decap_3
XFILLER_30_464 VGND VGND VPWR VPWR sky130_fd_sc_hd__decap_3
XFILLER_30_486 VGND VGND VPWR VPWR sky130_fd_sc_hd__fill_1
XFILLER_30_497 VGND VGND VPWR VPWR sky130_fd_sc_hd__decap_3
XFILLER_8_97 VGND VGND VPWR VPWR sky130_fd_sc_hd__decap_3
Xplace2027 place2031/X VGND VGND VPWR VPWR place2027/X sky130_fd_sc_hd__buf_2
Xplace2016 place2035/X VGND VGND VPWR VPWR place2016/X sky130_fd_sc_hd__buf_2
Xplace2005 _3422_/Y VGND VGND VPWR VPWR _6302_/A sky130_fd_sc_hd__buf_2
X_4561_ _4561_/A1 _4448_/X _4561_/B1 VGND VGND VPWR VPWR _4561_/Y sky130_fd_sc_hd__a21oi_2
Xplace1304 _4112_/X VGND VGND VPWR VPWR _5941_/A3 sky130_fd_sc_hd__buf_2
Xplace1315 _6477_/A2 VGND VGND VPWR VPWR _6484_/A2 sky130_fd_sc_hd__buf_2
Xplace1326 _5987_/A1 VGND VGND VPWR VPWR place1326/X sky130_fd_sc_hd__buf_8
Xplace2049 place2052/X VGND VGND VPWR VPWR place2049/X sky130_fd_sc_hd__buf_2
Xplace2038 place2039/X VGND VGND VPWR VPWR place2038/X sky130_fd_sc_hd__buf_2
X_7280_ _7280_/CLK _7280_/D VGND VGND VPWR VPWR _7280_/Q sky130_fd_sc_hd__dfxtp_2
X_3512_ _3511_/Y _3573_/A2 _3481_/B VGND VGND VPWR VPWR _3529_/C sky130_fd_sc_hd__a21oi_2
Xplace1337 _6390_/A1 VGND VGND VPWR VPWR _6401_/B2 sky130_fd_sc_hd__buf_6
Xplace1348 _4236_/X VGND VGND VPWR VPWR _4240_/A1 sky130_fd_sc_hd__buf_2
Xplace1359 _4276_/A VGND VGND VPWR VPWR _4277_/B1 sky130_fd_sc_hd__buf_2
X_6231_ _6231_/A1 _6231_/A2 _5847_/X _5850_/X _6347_/B VGND VGND VPWR VPWR _6254_/A
+ sky130_fd_sc_hd__a311o_2
X_3443_ _3480_/B _3444_/C _3443_/C VGND VGND VPWR VPWR _3445_/C sky130_fd_sc_hd__nand3_2
X_6162_ _6559_/A1 _6182_/A2 _6185_/B1 _7601_/Q _6161_/X VGND VGND VPWR VPWR _6162_/X
+ sky130_fd_sc_hd__o221a_4
XFILLER_69_111 VGND VGND VPWR VPWR sky130_fd_sc_hd__fill_1
XFILLER_69_177 VGND VGND VPWR VPWR sky130_fd_sc_hd__decap_3
X_6093_ _6559_/B1 _4970_/B _4970_/C _7194_/Q _6186_/C1 VGND VGND VPWR VPWR _6093_/X
+ sky130_fd_sc_hd__a311o_2
XFILLER_38_542 VGND VGND VPWR VPWR sky130_fd_sc_hd__decap_3
XFILLER_25_214 VGND VGND VPWR VPWR sky130_fd_sc_hd__decap_3
XFILLER_65_361 VGND VGND VPWR VPWR sky130_fd_sc_hd__decap_3
XTAP_TAPCELL_ROW_84_1104 VGND VPWR sky130_fd_sc_hd__tapvpwrvgnd_1
XFILLER_25_225 VGND VGND VPWR VPWR sky130_fd_sc_hd__decap_3
X_6995_ _7275_/CLK _6995_/D VGND VGND VPWR VPWR _6995_/Q sky130_fd_sc_hd__dfxtp_2
XFILLER_80_386 VGND VGND VPWR VPWR sky130_fd_sc_hd__fill_1
X_5877_ _7205_/Q _6204_/A2 _6455_/A1 _7233_/Q _5876_/X VGND VGND VPWR VPWR _5877_/X
+ sky130_fd_sc_hd__o221a_2
XFILLER_21_442 VGND VGND VPWR VPWR sky130_fd_sc_hd__fill_2
X_4828_ _4828_/A0 _5351_/A1 _4838_/S VGND VGND VPWR VPWR _6893_/D sky130_fd_sc_hd__mux2_2
XTAP_TAPCELL_ROW_51_757 VGND VPWR sky130_fd_sc_hd__tapvpwrvgnd_1
XFILLER_21_497 VGND VGND VPWR VPWR sky130_fd_sc_hd__fill_1
X_7547_ _7611_/CLK _7547_/D place2060/X VGND VGND VPWR VPWR _7547_/Q sky130_fd_sc_hd__dfrtp_2
X_4759_ _4759_/A0 _5357_/A1 _4759_/S VGND VGND VPWR VPWR _6868_/D sky130_fd_sc_hd__mux2_2
XFILLER_4_129 VGND VGND VPWR VPWR sky130_fd_sc_hd__decap_3
X_7478_ _7542_/CLK _7478_/D place2047/X VGND VGND VPWR VPWR _7478_/Q sky130_fd_sc_hd__dfrtp_2
XTAP_TAPCELL_ROW_95_1222 VGND VPWR sky130_fd_sc_hd__tapvpwrvgnd_1
X_6429_ _6476_/A1 _7153_/Q _7125_/Q _6476_/B2 VGND VGND VPWR VPWR _6429_/X sky130_fd_sc_hd__o22a_2
Xplace1871 _6769_/S VGND VGND VPWR VPWR _6773_/S sky130_fd_sc_hd__buf_2
Xplace1860 _3652_/B VGND VGND VPWR VPWR _3455_/A sky130_fd_sc_hd__buf_2
XFILLER_0_324 VGND VGND VPWR VPWR sky130_fd_sc_hd__decap_3
XFILLER_0_346 VGND VGND VPWR VPWR sky130_fd_sc_hd__fill_1
Xplace1893 _3472_/Y VGND VGND VPWR VPWR _4473_/D sky130_fd_sc_hd__buf_2
Xplace1882 _3435_/Y VGND VGND VPWR VPWR _3505_/A1 sky130_fd_sc_hd__buf_6
Xhold2540 _6849_/Q VGND VGND VPWR VPWR _4617_/A0 sky130_fd_sc_hd__dlygate4sd3_1
XFILLER_29_520 VGND VGND VPWR VPWR sky130_fd_sc_hd__fill_1
Xhold2573 _7080_/Q VGND VGND VPWR VPWR _5255_/A0 sky130_fd_sc_hd__dlygate4sd3_1
Xhold2562 _7192_/Q VGND VGND VPWR VPWR _5515_/A0 sky130_fd_sc_hd__dlygate4sd3_1
Xhold2551 _7152_/Q VGND VGND VPWR VPWR _5429_/A0 sky130_fd_sc_hd__dlygate4sd3_1
XTAP_TAPCELL_ROW_59_846 VGND VPWR sky130_fd_sc_hd__tapvpwrvgnd_1
XFILLER_29_553 VGND VGND VPWR VPWR sky130_fd_sc_hd__fill_1
XFILLER_75_169 VGND VGND VPWR VPWR sky130_fd_sc_hd__fill_2
Xhold2595 _7214_/Q VGND VGND VPWR VPWR _5564_/A0 sky130_fd_sc_hd__dlygate4sd3_1
Xhold2584 _7217_/Q VGND VGND VPWR VPWR _5570_/A0 sky130_fd_sc_hd__dlygate4sd3_1
XFILLER_16_203 VGND VGND VPWR VPWR sky130_fd_sc_hd__decap_3
XFILLER_56_361 VGND VGND VPWR VPWR sky130_fd_sc_hd__decap_3
XFILLER_17_73 VGND VGND VPWR VPWR sky130_fd_sc_hd__decap_3
XFILLER_44_545 VGND VGND VPWR VPWR sky130_fd_sc_hd__decap_3
XFILLER_56_394 VGND VGND VPWR VPWR sky130_fd_sc_hd__decap_3
XFILLER_31_206 VGND VGND VPWR VPWR sky130_fd_sc_hd__decap_3
XFILLER_44_589 VGND VGND VPWR VPWR sky130_fd_sc_hd__decap_3
XFILLER_24_280 VGND VGND VPWR VPWR sky130_fd_sc_hd__decap_3
XFILLER_31_228 VGND VGND VPWR VPWR sky130_fd_sc_hd__decap_3
XFILLER_3_195 VGND VGND VPWR VPWR sky130_fd_sc_hd__fill_1
XFILLER_39_328 VGND VGND VPWR VPWR sky130_fd_sc_hd__decap_3
XFILLER_58_80 VGND VGND VPWR VPWR sky130_fd_sc_hd__decap_3
XFILLER_66_114 VGND VGND VPWR VPWR sky130_fd_sc_hd__decap_3
XFILLER_54_309 VGND VGND VPWR VPWR sky130_fd_sc_hd__fill_1
XFILLER_66_158 VGND VGND VPWR VPWR sky130_fd_sc_hd__decap_3
XFILLER_47_361 VGND VGND VPWR VPWR sky130_fd_sc_hd__decap_3
X_5800_ _5797_/X _5799_/X _6478_/B1 VGND VGND VPWR VPWR _5807_/B sky130_fd_sc_hd__a21oi_2
X_3992_ _7522_/Q _5843_/A VGND VGND VPWR VPWR _3992_/X sky130_fd_sc_hd__and2_2
XFILLER_30_250 VGND VGND VPWR VPWR sky130_fd_sc_hd__fill_2
XTAP_TAPCELL_ROW_20_429 VGND VPWR sky130_fd_sc_hd__tapvpwrvgnd_1
XFILLER_30_283 VGND VGND VPWR VPWR sky130_fd_sc_hd__decap_3
X_7401_ _7493_/CLK _7401_/D place2042/X VGND VGND VPWR VPWR _7401_/Q sky130_fd_sc_hd__dfrtp_2
X_5593_ _5593_/A0 _5593_/A1 _5593_/S VGND VGND VPWR VPWR _7228_/D sky130_fd_sc_hd__mux2_2
X_4613_ _4428_/B _4613_/A2 _4613_/A3 _4613_/B1 VGND VGND VPWR VPWR _4613_/X sky130_fd_sc_hd__a31o_2
X_7332_ clkload8/A _7332_/D place2018/X VGND VGND VPWR VPWR _7332_/Q sky130_fd_sc_hd__dfrtp_2
X_4544_ _4533_/A _4533_/D _4541_/Y _4558_/D VGND VGND VPWR VPWR _4544_/Y sky130_fd_sc_hd__o22ai_2
Xplace1101 _4235_/B VGND VGND VPWR VPWR _6546_/A2 sky130_fd_sc_hd__buf_2
Xplace1112 _4745_/Y VGND VGND VPWR VPWR _5353_/A1 sky130_fd_sc_hd__buf_2
Xplace1123 _5707_/A1 VGND VGND VPWR VPWR _5190_/A1 sky130_fd_sc_hd__buf_2
Xplace1134 _4644_/X VGND VGND VPWR VPWR _5690_/A1 sky130_fd_sc_hd__buf_2
Xrebuffer2113 _3527_/Y VGND VGND VPWR VPWR _3825_/A2 sky130_fd_sc_hd__buf_2
X_7263_ _7291_/CLK _7263_/D VGND VGND VPWR VPWR _7263_/Q sky130_fd_sc_hd__dfxtp_2
Xplace1145 _4625_/X VGND VGND VPWR VPWR _5686_/A1 sky130_fd_sc_hd__buf_2
Xplace1156 _4614_/X VGND VGND VPWR VPWR _5684_/A1 sky130_fd_sc_hd__buf_2
Xplace1167 _5454_/S VGND VGND VPWR VPWR _5486_/S sky130_fd_sc_hd__buf_2
Xrebuffer2124 _4119_/Y VGND VGND VPWR VPWR _5759_/B1 sky130_fd_sc_hd__buf_2
Xrebuffer2135 _5759_/Y VGND VGND VPWR VPWR _5960_/B2 sky130_fd_sc_hd__buf_2
Xrebuffer2146 place1841/A VGND VGND VPWR VPWR _3548_/A1 sky130_fd_sc_hd__buf_2
X_6214_ _6212_/X _6213_/X _6457_/B1 _6457_/C1 VGND VGND VPWR VPWR _6214_/X sky130_fd_sc_hd__a211o_2
X_4475_ _4474_/X _7596_/D _4475_/S VGND VGND VPWR VPWR _4475_/X sky130_fd_sc_hd__mux2_2
Xplace1178 _4164_/B VGND VGND VPWR VPWR _4163_/C1 sky130_fd_sc_hd__buf_2
Xplace1189 _5302_/S VGND VGND VPWR VPWR _5299_/S sky130_fd_sc_hd__buf_2
Xrebuffer2157 _3919_/A VGND VGND VPWR VPWR _4608_/A1 sky130_fd_sc_hd__buf_2
Xrebuffer2168 _3504_/Y VGND VGND VPWR VPWR _3539_/A2 sky130_fd_sc_hd__buf_2
Xrebuffer2179 place1325/X VGND VGND VPWR VPWR _6456_/A1 sky130_fd_sc_hd__buf_2
X_7194_ _7407_/CLK _7194_/D VGND VGND VPWR VPWR _7194_/Q sky130_fd_sc_hd__dfxtp_2
X_6145_ _6390_/A1 _7057_/Q _6861_/Q _6390_/B2 VGND VGND VPWR VPWR _6145_/X sky130_fd_sc_hd__o22a_2
XTAP_TAPCELL_ROW_90_1163 VGND VPWR sky130_fd_sc_hd__tapvpwrvgnd_1
X_6076_ _5922_/Y _6404_/A2 _6404_/B1 VGND VGND VPWR VPWR _6076_/Y sky130_fd_sc_hd__a21oi_2
XFILLER_57_169 VGND VGND VPWR VPWR sky130_fd_sc_hd__decap_3
XFILLER_26_501 VGND VGND VPWR VPWR sky130_fd_sc_hd__decap_3
XFILLER_38_361 VGND VGND VPWR VPWR sky130_fd_sc_hd__decap_3
XFILLER_38_372 VGND VGND VPWR VPWR sky130_fd_sc_hd__fill_1
XTAP_TAPCELL_ROW_56_816 VGND VPWR sky130_fd_sc_hd__tapvpwrvgnd_1
XTAP_TAPCELL_ROW_28_518 VGND VPWR sky130_fd_sc_hd__tapvpwrvgnd_1
XFILLER_26_545 VGND VGND VPWR VPWR sky130_fd_sc_hd__decap_3
XFILLER_13_228 VGND VGND VPWR VPWR sky130_fd_sc_hd__decap_3
XFILLER_80_194 VGND VGND VPWR VPWR sky130_fd_sc_hd__fill_2
X_6978_ _7291_/CLK _6978_/D VGND VGND VPWR VPWR _6978_/Q sky130_fd_sc_hd__dfxtp_2
XTAP_TAPCELL_ROW_64_893 VGND VPWR sky130_fd_sc_hd__tapvpwrvgnd_1
X_5929_ _6484_/B2 _7098_/Q _6846_/Q _6476_/B2 VGND VGND VPWR VPWR _5929_/X sky130_fd_sc_hd__o22a_2
XFILLER_21_272 VGND VGND VPWR VPWR sky130_fd_sc_hd__decap_3
XFILLER_102_3 VGND VGND VPWR VPWR sky130_fd_sc_hd__fill_1
Xplace1690 _4325_/B VGND VGND VPWR VPWR _4508_/B sky130_fd_sc_hd__buf_2
XFILLER_0_132 VGND VGND VPWR VPWR sky130_fd_sc_hd__decap_3
XFILLER_76_434 VGND VGND VPWR VPWR sky130_fd_sc_hd__decap_3
XFILLER_28_50 VGND VGND VPWR VPWR sky130_fd_sc_hd__decap_3
XFILLER_48_136 VGND VGND VPWR VPWR sky130_fd_sc_hd__decap_3
Xhold2381 _7258_/Q VGND VGND VPWR VPWR _5659_/A0 sky130_fd_sc_hd__dlygate4sd3_1
Xhold2370 _7168_/Q VGND VGND VPWR VPWR _5463_/A0 sky130_fd_sc_hd__dlygate4sd3_1
Xhold2392 _7181_/Q VGND VGND VPWR VPWR _5492_/A0 sky130_fd_sc_hd__dlygate4sd3_1
XFILLER_17_556 VGND VGND VPWR VPWR sky130_fd_sc_hd__decap_3
XFILLER_56_180 VGND VGND VPWR VPWR sky130_fd_sc_hd__decap_3
XFILLER_63_139 VGND VGND VPWR VPWR sky130_fd_sc_hd__fill_1
XFILLER_32_515 VGND VGND VPWR VPWR sky130_fd_sc_hd__decap_3
XFILLER_44_82 VGND VGND VPWR VPWR sky130_fd_sc_hd__fill_2
XFILLER_60_81 VGND VGND VPWR VPWR sky130_fd_sc_hd__decap_3
XFILLER_4_471 VGND VGND VPWR VPWR sky130_fd_sc_hd__decap_3
X_4260_ _4274_/A _4260_/B _4260_/C VGND VGND VPWR VPWR _4269_/A sky130_fd_sc_hd__or3_4
X_4191_ _4185_/A _4184_/Y _4188_/X _4190_/Y VGND VGND VPWR VPWR _4194_/A sky130_fd_sc_hd__a211o_2
XFILLER_79_294 VGND VGND VPWR VPWR sky130_fd_sc_hd__decap_3
XFILLER_39_147 VGND VGND VPWR VPWR sky130_fd_sc_hd__fill_1
XFILLER_39_169 VGND VGND VPWR VPWR sky130_fd_sc_hd__decap_3
XFILLER_54_139 VGND VGND VPWR VPWR sky130_fd_sc_hd__fill_1
X_6901_ _7393_/CLK _6901_/D VGND VGND VPWR VPWR _6901_/Q sky130_fd_sc_hd__dfxtp_2
X_6832_ _6838_/A _6832_/B VGND VGND VPWR VPWR _7574_/D sky130_fd_sc_hd__and2_2
XFILLER_50_312 VGND VGND VPWR VPWR sky130_fd_sc_hd__fill_1
XFILLER_62_161 VGND VGND VPWR VPWR sky130_fd_sc_hd__decap_3
XFILLER_23_559 VGND VGND VPWR VPWR sky130_fd_sc_hd__fill_1
X_6763_ _6201_/X _7541_/Q _6765_/S VGND VGND VPWR VPWR _7541_/D sky130_fd_sc_hd__mux2_2
X_3975_ _3975_/A _3975_/B _3975_/C VGND VGND VPWR VPWR _4144_/B sky130_fd_sc_hd__and3_2
XTAP_TAPCELL_ROW_61_863 VGND VPWR sky130_fd_sc_hd__tapvpwrvgnd_1
X_6694_ _6694_/A0 _6185_/X _6704_/S VGND VGND VPWR VPWR _7508_/D sky130_fd_sc_hd__mux2_2
XTAP_TAPCELL_ROW_33_565 VGND VPWR sky130_fd_sc_hd__tapvpwrvgnd_1
X_5576_ _5576_/A0 _4670_/X _5576_/S VGND VGND VPWR VPWR _7220_/D sky130_fd_sc_hd__mux2_2
X_7315_ _7606_/CLK _7315_/D place2051/X VGND VGND VPWR VPWR _7315_/Q sky130_fd_sc_hd__dfrtp_2
X_4527_ _4538_/S _4531_/B _4527_/C VGND VGND VPWR VPWR _4527_/Y sky130_fd_sc_hd__nor3_2
X_7246_ _7247_/CLK _7246_/D VGND VGND VPWR VPWR _7246_/Q sky130_fd_sc_hd__dfxtp_2
X_4458_ _7594_/D _4475_/S _4452_/S VGND VGND VPWR VPWR _4458_/Y sky130_fd_sc_hd__a21oi_2
X_7177_ _7289_/CLK _7177_/D VGND VGND VPWR VPWR _7177_/Q sky130_fd_sc_hd__dfxtp_2
X_3409_ _3409_/A _3443_/C VGND VGND VPWR VPWR _3409_/Y sky130_fd_sc_hd__nand2_4
X_6128_ _6219_/A1 _6220_/A2 _6185_/B1 _7598_/Q _6127_/X VGND VGND VPWR VPWR _6128_/X
+ sky130_fd_sc_hd__o221a_2
X_4389_ _4388_/X _6729_/A1 _4452_/S VGND VGND VPWR VPWR _7299_/D sky130_fd_sc_hd__mux2_2
XTAP_TAPCELL_ROW_69_952 VGND VPWR sky130_fd_sc_hd__tapvpwrvgnd_1
XTAP_TAPCELL_ROW_5_279 VGND VPWR sky130_fd_sc_hd__tapvpwrvgnd_1
XFILLER_45_106 VGND VGND VPWR VPWR sky130_fd_sc_hd__decap_3
X_6059_ _6448_/A1 _7049_/Q _6853_/Q _6450_/B2 VGND VGND VPWR VPWR _6059_/X sky130_fd_sc_hd__o22a_2
XFILLER_26_331 VGND VGND VPWR VPWR sky130_fd_sc_hd__fill_1
XFILLER_45_128 VGND VGND VPWR VPWR sky130_fd_sc_hd__decap_3
XFILLER_26_342 VGND VGND VPWR VPWR sky130_fd_sc_hd__decap_3
XFILLER_60_109 VGND VGND VPWR VPWR sky130_fd_sc_hd__fill_2
XFILLER_14_526 VGND VGND VPWR VPWR sky130_fd_sc_hd__decap_3
XFILLER_41_312 VGND VGND VPWR VPWR sky130_fd_sc_hd__decap_3
XFILLER_81_36 VGND VGND VPWR VPWR sky130_fd_sc_hd__fill_2
XFILLER_41_378 VGND VGND VPWR VPWR sky130_fd_sc_hd__fill_1
XFILLER_14_74 VGND VGND VPWR VPWR sky130_fd_sc_hd__decap_3
XFILLER_14_85 VGND VGND VPWR VPWR sky130_fd_sc_hd__decap_3
XFILLER_22_581 VGND VGND VPWR VPWR sky130_fd_sc_hd__decap_3
XFILLER_30_40 VGND VGND VPWR VPWR sky130_fd_sc_hd__fill_2
XFILLER_1_485 VGND VGND VPWR VPWR sky130_fd_sc_hd__decap_3
XFILLER_39_71 VGND VGND VPWR VPWR sky130_fd_sc_hd__fill_1
XFILLER_49_445 VGND VGND VPWR VPWR sky130_fd_sc_hd__decap_3
XFILLER_36_106 VGND VGND VPWR VPWR sky130_fd_sc_hd__decap_3
XFILLER_29_180 VGND VGND VPWR VPWR sky130_fd_sc_hd__decap_3
XFILLER_55_70 VGND VGND VPWR VPWR sky130_fd_sc_hd__decap_3
XFILLER_32_323 VGND VGND VPWR VPWR sky130_fd_sc_hd__decap_3
XFILLER_44_183 VGND VGND VPWR VPWR sky130_fd_sc_hd__fill_2
X_3760_ _4231_/A _4231_/B VGND VGND VPWR VPWR _3760_/Y sky130_fd_sc_hd__nand2_2
XTAP_TAPCELL_ROW_30_535 VGND VPWR sky130_fd_sc_hd__tapvpwrvgnd_1
XFILLER_9_585 VGND VGND VPWR VPWR sky130_fd_sc_hd__decap_3
X_3691_ _7387_/Q _3776_/A2 _3776_/A3 _3810_/B1 _7451_/Q VGND VGND VPWR VPWR _3696_/A
+ sky130_fd_sc_hd__a32o_2
X_5361_ _5361_/A0 _5606_/A1 _5361_/S VGND VGND VPWR VPWR _7122_/D sky130_fd_sc_hd__mux2_2
X_7100_ _7275_/CLK _7100_/D VGND VGND VPWR VPWR _7100_/Q sky130_fd_sc_hd__dfxtp_2
X_4312_ _7581_/D _4312_/B VGND VGND VPWR VPWR _4313_/C sky130_fd_sc_hd__xor2_2
XFILLER_4_290 VGND VGND VPWR VPWR sky130_fd_sc_hd__fill_1
XFILLER_59_209 VGND VGND VPWR VPWR sky130_fd_sc_hd__decap_3
X_7031_ _7235_/CLK _7031_/D VGND VGND VPWR VPWR _7031_/Q sky130_fd_sc_hd__dfxtp_2
X_4243_ _4248_/A1 _4240_/Y _4242_/Y _6163_/A VGND VGND VPWR VPWR _4243_/X sky130_fd_sc_hd__o211a_2
XFILLER_99_389 VGND VGND VPWR VPWR sky130_fd_sc_hd__decap_3
X_4174_ _4174_/A _4174_/B VGND VGND VPWR VPWR _4174_/X sky130_fd_sc_hd__and2_2
XFILLER_67_253 VGND VGND VPWR VPWR sky130_fd_sc_hd__fill_1
XFILLER_95_584 VGND VGND VPWR VPWR sky130_fd_sc_hd__fill_1
XTAP_TAPCELL_ROW_66_911 VGND VPWR sky130_fd_sc_hd__tapvpwrvgnd_1
XTAP_TAPCELL_ROW_38_624 VGND VPWR sky130_fd_sc_hd__tapvpwrvgnd_1
XTAP_TAPCELL_ROW_2_249 VGND VPWR sky130_fd_sc_hd__tapvpwrvgnd_1
XFILLER_70_418 VGND VGND VPWR VPWR sky130_fd_sc_hd__fill_2
XFILLER_23_312 VGND VGND VPWR VPWR sky130_fd_sc_hd__decap_3
XFILLER_35_172 VGND VGND VPWR VPWR sky130_fd_sc_hd__decap_3
XFILLER_23_389 VGND VGND VPWR VPWR sky130_fd_sc_hd__decap_3
X_6746_ _6113_/X _6746_/A1 _6773_/S VGND VGND VPWR VPWR _7533_/D sky130_fd_sc_hd__mux2_2
X_3958_ _3931_/B _6804_/A1 _3958_/B1 VGND VGND VPWR VPWR _4099_/B sky130_fd_sc_hd__a21oi_2
X_6677_ _6677_/A0 _6091_/X _6687_/S VGND VGND VPWR VPWR _7500_/D sky130_fd_sc_hd__mux2_2
X_3889_ _7430_/Q _3931_/B _4396_/A _4362_/A _3888_/X VGND VGND VPWR VPWR _3889_/X
+ sky130_fd_sc_hd__a41o_2
X_5559_ _5559_/A0 _4727_/C _5574_/S VGND VGND VPWR VPWR _7212_/D sky130_fd_sc_hd__mux2_2
X_7229_ _7290_/CLK _7229_/D VGND VGND VPWR VPWR _7229_/Q sky130_fd_sc_hd__dfxtp_2
XFILLER_18_106 VGND VGND VPWR VPWR sky130_fd_sc_hd__decap_3
XFILLER_58_253 VGND VGND VPWR VPWR sky130_fd_sc_hd__decap_3
XFILLER_46_459 VGND VGND VPWR VPWR sky130_fd_sc_hd__fill_2
XFILLER_14_301 VGND VGND VPWR VPWR sky130_fd_sc_hd__decap_3
XFILLER_26_194 VGND VGND VPWR VPWR sky130_fd_sc_hd__fill_2
XFILLER_25_84 VGND VGND VPWR VPWR sky130_fd_sc_hd__decap_3
XFILLER_41_153 VGND VGND VPWR VPWR sky130_fd_sc_hd__decap_3
XFILLER_41_197 VGND VGND VPWR VPWR sky130_fd_sc_hd__fill_2
XFILLER_10_573 VGND VGND VPWR VPWR sky130_fd_sc_hd__fill_2
XFILLER_6_533 VGND VGND VPWR VPWR sky130_fd_sc_hd__decap_3
XFILLER_96_337 VGND VGND VPWR VPWR sky130_fd_sc_hd__decap_3
XFILLER_49_242 VGND VGND VPWR VPWR sky130_fd_sc_hd__fill_1
XFILLER_49_264 VGND VGND VPWR VPWR sky130_fd_sc_hd__fill_2
XFILLER_64_256 VGND VGND VPWR VPWR sky130_fd_sc_hd__fill_1
XFILLER_33_610 VGND VGND VPWR VPWR sky130_fd_sc_hd__fill_2
XFILLER_45_481 VGND VGND VPWR VPWR sky130_fd_sc_hd__decap_3
XFILLER_64_278 VGND VGND VPWR VPWR sky130_fd_sc_hd__decap_3
XFILLER_92_587 VGND VGND VPWR VPWR sky130_fd_sc_hd__fill_1
X_4930_ _4930_/A0 _5696_/A1 _4930_/S VGND VGND VPWR VPWR _6939_/D sky130_fd_sc_hd__mux2_2
XFILLER_20_304 VGND VGND VPWR VPWR sky130_fd_sc_hd__decap_3
XFILLER_20_315 VGND VGND VPWR VPWR sky130_fd_sc_hd__decap_3
X_6600_ _6600_/A0 _6074_/X _6600_/S VGND VGND VPWR VPWR _7464_/D sky130_fd_sc_hd__mux2_2
X_3812_ _7534_/Q _3812_/A2 _3812_/B1 _7470_/Q VGND VGND VPWR VPWR _3813_/C sky130_fd_sc_hd__a22oi_2
XTAP_TAPCELL_ROW_43_671 VGND VPWR sky130_fd_sc_hd__tapvpwrvgnd_1
XANTENNA_16 _7054_/Q VGND VGND VPWR VPWR sky130_fd_sc_hd__diode_2
XANTENNA_27 _5064_/A0 VGND VGND VPWR VPWR sky130_fd_sc_hd__diode_2
XANTENNA_38 _7111_/Q VGND VGND VPWR VPWR sky130_fd_sc_hd__diode_2
X_7580_ clkload2/A _7580_/D place2029/X VGND VGND VPWR VPWR _7580_/Q sky130_fd_sc_hd__dfrtp_2
XTAP_TAPCELL_ROW_15_384 VGND VPWR sky130_fd_sc_hd__tapvpwrvgnd_1
XANTENNA_49 _7000_/Q VGND VGND VPWR VPWR sky130_fd_sc_hd__diode_2
X_6531_ _7436_/Q _6091_/X _6541_/S VGND VGND VPWR VPWR _7436_/D sky130_fd_sc_hd__mux2_2
X_3743_ _7441_/Q _3858_/B1 _3828_/B2 _7473_/Q VGND VGND VPWR VPWR _3746_/A sky130_fd_sc_hd__a22o_2
XFILLER_9_393 VGND VGND VPWR VPWR sky130_fd_sc_hd__decap_3
X_6462_ _6511_/B2 _7163_/Q _7135_/Q _6510_/B2 VGND VGND VPWR VPWR _6462_/X sky130_fd_sc_hd__o22a_2
X_3674_ _7446_/Q _3718_/B1 _3781_/B1 _7350_/Q _3673_/X VGND VGND VPWR VPWR _3674_/X
+ sky130_fd_sc_hd__a221o_2
X_6393_ _6399_/A1 _7232_/Q _7148_/Q _6393_/B2 VGND VGND VPWR VPWR _6393_/X sky130_fd_sc_hd__o22a_2
X_5413_ _5413_/A0 _5718_/A1 _5423_/S VGND VGND VPWR VPWR _7145_/D sky130_fd_sc_hd__mux2_2
XTAP_TAPCELL_ROW_76_1017 VGND VPWR sky130_fd_sc_hd__tapvpwrvgnd_1
X_5344_ _5344_/A0 _5344_/A1 _5357_/S VGND VGND VPWR VPWR _7114_/D sky130_fd_sc_hd__mux2_2
Xhold2903 _7476_/Q VGND VGND VPWR VPWR _6626_/A0 sky130_fd_sc_hd__dlygate4sd3_1
Xhold2914 _7467_/Q VGND VGND VPWR VPWR _6607_/A0 sky130_fd_sc_hd__dlygate4sd3_1
Xhold2925 _7462_/Q VGND VGND VPWR VPWR _6596_/A0 sky130_fd_sc_hd__dlygate4sd3_1
Xhold2936 _7474_/Q VGND VGND VPWR VPWR _6622_/A0 sky130_fd_sc_hd__dlygate4sd3_1
Xhold2947 _6369_/X VGND VGND VPWR VPWR _7399_/D sky130_fd_sc_hd__dlygate4sd3_1
X_7014_ _7275_/CLK _7014_/D VGND VGND VPWR VPWR _7014_/Q sky130_fd_sc_hd__dfxtp_2
X_4226_ _4226_/A VGND VGND VPWR VPWR _4238_/C sky130_fd_sc_hd__inv_2
XFILLER_101_169 VGND VGND VPWR VPWR sky130_fd_sc_hd__fill_1
XFILLER_28_415 VGND VGND VPWR VPWR sky130_fd_sc_hd__decap_3
Xhold2958 _7389_/Q VGND VGND VPWR VPWR _6356_/B2 sky130_fd_sc_hd__dlygate4sd3_1
Xhold2969 _7484_/Q VGND VGND VPWR VPWR _6643_/A0 sky130_fd_sc_hd__dlygate4sd3_1
X_4157_ _4157_/A _4157_/B VGND VGND VPWR VPWR _4157_/Y sky130_fd_sc_hd__nor2_2
XFILLER_83_532 VGND VGND VPWR VPWR sky130_fd_sc_hd__fill_1
XTAP_TAPCELL_ROW_87_1135 VGND VPWR sky130_fd_sc_hd__tapvpwrvgnd_1
XFILLER_55_256 VGND VGND VPWR VPWR sky130_fd_sc_hd__decap_3
X_4088_ _7320_/Q _4088_/B VGND VGND VPWR VPWR _4091_/B sky130_fd_sc_hd__nand2_2
XFILLER_24_610 VGND VGND VPWR VPWR sky130_fd_sc_hd__fill_2
XFILLER_23_120 VGND VGND VPWR VPWR sky130_fd_sc_hd__fill_1
XFILLER_102_89 VGND VGND VPWR VPWR sky130_fd_sc_hd__fill_1
XFILLER_51_495 VGND VGND VPWR VPWR sky130_fd_sc_hd__fill_2
X_6729_ _6018_/X _6729_/A1 _6775_/S VGND VGND VPWR VPWR _7525_/D sky130_fd_sc_hd__mux2_2
XTAP_TAPCELL_ROW_98_1253 VGND VPWR sky130_fd_sc_hd__tapvpwrvgnd_1
XFILLER_3_503 VGND VGND VPWR VPWR sky130_fd_sc_hd__fill_1
XFILLER_87_57 VGND VGND VPWR VPWR sky130_fd_sc_hd__fill_1
XFILLER_59_595 VGND VGND VPWR VPWR sky130_fd_sc_hd__fill_1
XFILLER_27_492 VGND VGND VPWR VPWR sky130_fd_sc_hd__decap_3
XFILLER_36_83 VGND VGND VPWR VPWR sky130_fd_sc_hd__fill_1
XFILLER_61_237 VGND VGND VPWR VPWR sky130_fd_sc_hd__decap_3
XFILLER_14_164 VGND VGND VPWR VPWR sky130_fd_sc_hd__fill_2
XFILLER_14_175 VGND VGND VPWR VPWR sky130_fd_sc_hd__decap_3
XFILLER_14_197 VGND VGND VPWR VPWR sky130_fd_sc_hd__decap_3
XTAP_TAPCELL_ROW_40_641 VGND VPWR sky130_fd_sc_hd__tapvpwrvgnd_1
XTAP_TAPCELL_ROW_12_354 VGND VPWR sky130_fd_sc_hd__tapvpwrvgnd_1
Xplace1508 _3807_/C VGND VGND VPWR VPWR _4676_/A0 sky130_fd_sc_hd__buf_2
XFILLER_6_363 VGND VGND VPWR VPWR sky130_fd_sc_hd__fill_1
Xplace1519 _3738_/X VGND VGND VPWR VPWR _4296_/A sky130_fd_sc_hd__buf_2
XFILLER_69_304 VGND VGND VPWR VPWR sky130_fd_sc_hd__decap_3
XFILLER_96_101 VGND VGND VPWR VPWR sky130_fd_sc_hd__decap_3
XFILLER_2_580 VGND VGND VPWR VPWR sky130_fd_sc_hd__fill_1
XFILLER_69_337 VGND VGND VPWR VPWR sky130_fd_sc_hd__decap_3
XFILLER_96_134 VGND VGND VPWR VPWR sky130_fd_sc_hd__fill_2
XFILLER_28_3 VGND VGND VPWR VPWR sky130_fd_sc_hd__decap_3
XFILLER_77_90 VGND VGND VPWR VPWR sky130_fd_sc_hd__decap_3
XFILLER_96_167 VGND VGND VPWR VPWR sky130_fd_sc_hd__fill_2
X_4011_ _4011_/A _4011_/B _4011_/C VGND VGND VPWR VPWR _4011_/Y sky130_fd_sc_hd__nand3_2
XFILLER_37_212 VGND VGND VPWR VPWR sky130_fd_sc_hd__decap_3
XFILLER_65_521 VGND VGND VPWR VPWR sky130_fd_sc_hd__fill_2
XFILLER_65_543 VGND VGND VPWR VPWR sky130_fd_sc_hd__fill_1
XTAP_TAPCELL_ROW_48_730 VGND VPWR sky130_fd_sc_hd__tapvpwrvgnd_1
XFILLER_37_278 VGND VGND VPWR VPWR sky130_fd_sc_hd__fill_2
XFILLER_52_204 VGND VGND VPWR VPWR sky130_fd_sc_hd__fill_1
X_5962_ _4638_/Y _5962_/B _5962_/C _5962_/D VGND VGND VPWR VPWR _6011_/A sky130_fd_sc_hd__nand4b_4
XFILLER_80_568 VGND VGND VPWR VPWR sky130_fd_sc_hd__fill_2
X_4913_ _4913_/A0 _5162_/A1 _4930_/S VGND VGND VPWR VPWR _6931_/D sky130_fd_sc_hd__mux2_2
X_5893_ _6390_/A1 _7058_/Q _6862_/Q _6390_/B2 VGND VGND VPWR VPWR _5893_/X sky130_fd_sc_hd__o22a_2
XFILLER_20_101 VGND VGND VPWR VPWR sky130_fd_sc_hd__decap_3
XFILLER_20_123 VGND VGND VPWR VPWR sky130_fd_sc_hd__decap_3
XFILLER_60_281 VGND VGND VPWR VPWR sky130_fd_sc_hd__fill_2
XTAP_TAPCELL_ROW_82_1087 VGND VPWR sky130_fd_sc_hd__tapvpwrvgnd_1
X_7563_ _7565_/CLK _7563_/D place2015/X VGND VGND VPWR VPWR _7563_/Q sky130_fd_sc_hd__dfrtp_2
XFILLER_20_178 VGND VGND VPWR VPWR sky130_fd_sc_hd__decap_3
X_6514_ _4155_/X _5841_/X _6514_/B1 _5843_/A VGND VGND VPWR VPWR _6514_/X sky130_fd_sc_hd__a211o_2
X_3726_ _7385_/Q _6704_/S VGND VGND VPWR VPWR _4287_/C sky130_fd_sc_hd__nand2_2
X_7494_ clkload4/A _7494_/D place2063/X VGND VGND VPWR VPWR _7494_/Q sky130_fd_sc_hd__dfrtp_2
X_6376_ _6679_/A0 _6376_/A2 _6411_/A3 _6411_/B1 _6376_/B2 VGND VGND VPWR VPWR _7405_/D
+ sky130_fd_sc_hd__a32o_2
Xoutput2074 _4178_/X VGND VGND VPWR VPWR result[13] sky130_fd_sc_hd__clkdlybuf4s25_1
Xoutput2085 place120/X VGND VGND VPWR VPWR result[23] sky130_fd_sc_hd__clkbuf_2
Xoutput2096 _4105_/Y VGND VGND VPWR VPWR result[4] sky130_fd_sc_hd__clkdlybuf4s25_1
X_5327_ _5327_/A0 _5572_/A1 _5329_/S VGND VGND VPWR VPWR _7106_/D sky130_fd_sc_hd__mux2_2
XFILLER_0_539 VGND VGND VPWR VPWR sky130_fd_sc_hd__decap_3
Xhold2700 _7139_/Q VGND VGND VPWR VPWR _5400_/A0 sky130_fd_sc_hd__dlygate4sd3_1
Xhold2711 _6882_/Q VGND VGND VPWR VPWR _4804_/A0 sky130_fd_sc_hd__dlygate4sd3_1
Xhold2722 _6945_/Q VGND VGND VPWR VPWR _4943_/A0 sky130_fd_sc_hd__dlygate4sd3_1
Xhold2733 _7049_/Q VGND VGND VPWR VPWR _5175_/A0 sky130_fd_sc_hd__dlygate4sd3_1
Xhold2744 _7513_/Q VGND VGND VPWR VPWR _6704_/A0 sky130_fd_sc_hd__dlygate4sd3_1
Xhold2755 _7210_/Q VGND VGND VPWR VPWR _5555_/A0 sky130_fd_sc_hd__dlygate4sd3_1
XFILLER_28_223 VGND VGND VPWR VPWR sky130_fd_sc_hd__decap_3
Xhold2766 _6847_/Q VGND VGND VPWR VPWR _4600_/A0 sky130_fd_sc_hd__dlygate4sd3_1
Xhold2777 _7096_/Q VGND VGND VPWR VPWR _5306_/A0 sky130_fd_sc_hd__dlygate4sd3_1
Xhold2788 _7282_/Q VGND VGND VPWR VPWR _5711_/A0 sky130_fd_sc_hd__dlygate4sd3_1
Xhold2799 _7088_/Q VGND VGND VPWR VPWR _5280_/A0 sky130_fd_sc_hd__dlygate4sd3_1
X_4209_ _4209_/A _4209_/B _3797_/Y VGND VGND VPWR VPWR _4209_/X sky130_fd_sc_hd__or3b_4
XFILLER_28_245 VGND VGND VPWR VPWR sky130_fd_sc_hd__decap_3
XFILLER_28_256 VGND VGND VPWR VPWR sky130_fd_sc_hd__decap_3
XFILLER_73_37 VGND VGND VPWR VPWR sky130_fd_sc_hd__decap_3
XFILLER_71_535 VGND VGND VPWR VPWR sky130_fd_sc_hd__fill_2
XTAP_TAPCELL_ROW_54_788 VGND VPWR sky130_fd_sc_hd__tapvpwrvgnd_1
XFILLER_24_473 VGND VGND VPWR VPWR sky130_fd_sc_hd__decap_3
XFILLER_24_484 VGND VGND VPWR VPWR sky130_fd_sc_hd__decap_3
XFILLER_24_495 VGND VGND VPWR VPWR sky130_fd_sc_hd__decap_3
XTAP_TAPCELL_ROW_102_1290 VGND VPWR sky130_fd_sc_hd__tapvpwrvgnd_1
XFILLER_11_178 VGND VGND VPWR VPWR sky130_fd_sc_hd__decap_3
XFILLER_7_116 VGND VGND VPWR VPWR sky130_fd_sc_hd__decap_3
XFILLER_22_63 VGND VGND VPWR VPWR sky130_fd_sc_hd__decap_3
XFILLER_22_85 VGND VGND VPWR VPWR sky130_fd_sc_hd__decap_3
XFILLER_7_149 VGND VGND VPWR VPWR sky130_fd_sc_hd__fill_2
XFILLER_3_399 VGND VGND VPWR VPWR sky130_fd_sc_hd__decap_3
XFILLER_19_201 VGND VGND VPWR VPWR sky130_fd_sc_hd__decap_3
XFILLER_19_223 VGND VGND VPWR VPWR sky130_fd_sc_hd__fill_1
XFILLER_59_381 VGND VGND VPWR VPWR sky130_fd_sc_hd__decap_3
XFILLER_19_245 VGND VGND VPWR VPWR sky130_fd_sc_hd__decap_3
XFILLER_19_267 VGND VGND VPWR VPWR sky130_fd_sc_hd__fill_2
XFILLER_19_278 VGND VGND VPWR VPWR sky130_fd_sc_hd__fill_2
XFILLER_47_587 VGND VGND VPWR VPWR sky130_fd_sc_hd__fill_2
XTAP_TAPCELL_ROW_45_700 VGND VPWR sky130_fd_sc_hd__tapvpwrvgnd_1
XTAP_TAPCELL_ROW_17_402 VGND VPWR sky130_fd_sc_hd__tapvpwrvgnd_1
XFILLER_34_248 VGND VGND VPWR VPWR sky130_fd_sc_hd__decap_3
XFILLER_42_281 VGND VGND VPWR VPWR sky130_fd_sc_hd__decap_3
XPHY_EDGE_ROW_7_Left_111 VGND VGND VPWR VPWR sky130_fd_sc_hd__decap_3
XTAP_TAPCELL_ROW_25_490 VGND VPWR sky130_fd_sc_hd__tapvpwrvgnd_1
X_4560_ _7610_/D _4559_/A _4550_/S VGND VGND VPWR VPWR _4560_/Y sky130_fd_sc_hd__a21oi_2
Xplace2028 place2031/X VGND VGND VPWR VPWR place2028/X sky130_fd_sc_hd__buf_2
Xplace2017 place2018/X VGND VGND VPWR VPWR place2017/X sky130_fd_sc_hd__buf_2
Xplace2006 _4473_/A VGND VGND VPWR VPWR _4503_/A sky130_fd_sc_hd__buf_2
XFILLER_6_171 VGND VGND VPWR VPWR sky130_fd_sc_hd__decap_3
Xplace1305 _4109_/Y VGND VGND VPWR VPWR _5778_/A1 sky130_fd_sc_hd__buf_2
Xplace1316 _5980_/A1 VGND VGND VPWR VPWR _6477_/A2 sky130_fd_sc_hd__buf_2
Xplace2039 place2045/X VGND VGND VPWR VPWR place2039/X sky130_fd_sc_hd__buf_2
X_4491_ _4490_/X _6750_/A1 _4539_/S VGND VGND VPWR VPWR _7309_/D sky130_fd_sc_hd__mux2_2
X_3511_ _3628_/A1 _3826_/A _3480_/Y _3510_/Y VGND VGND VPWR VPWR _3511_/Y sky130_fd_sc_hd__o22ai_2
Xplace1327 _5999_/A1 VGND VGND VPWR VPWR _6213_/A1 sky130_fd_sc_hd__buf_6
Xplace1338 _5984_/B1 VGND VGND VPWR VPWR _6390_/A1 sky130_fd_sc_hd__buf_6
Xplace1349 _4238_/C VGND VGND VPWR VPWR _4228_/A sky130_fd_sc_hd__buf_2
X_6230_ _6230_/A1 _5848_/X _4341_/X VGND VGND VPWR VPWR _6347_/B sky130_fd_sc_hd__o21ai_2
X_3442_ _4473_/B _3442_/B VGND VGND VPWR VPWR _3446_/A sky130_fd_sc_hd__nand2_2
X_6161_ _6161_/A1 _6161_/A2 _6160_/X _6184_/B1 _6184_/C1 VGND VGND VPWR VPWR _6161_/X
+ sky130_fd_sc_hd__a221o_2
X_5112_ _5112_/A0 _5446_/A1 _5118_/S VGND VGND VPWR VPWR _7020_/D sky130_fd_sc_hd__mux2_2
XFILLER_69_167 VGND VGND VPWR VPWR sky130_fd_sc_hd__fill_1
XFILLER_38_510 VGND VGND VPWR VPWR sky130_fd_sc_hd__decap_3
XFILLER_38_521 VGND VGND VPWR VPWR sky130_fd_sc_hd__decap_3
XFILLER_97_498 VGND VGND VPWR VPWR sky130_fd_sc_hd__decap_3
XFILLER_38_576 VGND VGND VPWR VPWR sky130_fd_sc_hd__decap_3
XFILLER_38_598 VGND VGND VPWR VPWR sky130_fd_sc_hd__fill_1
XTAP_TAPCELL_ROW_84_1105 VGND VPWR sky130_fd_sc_hd__tapvpwrvgnd_1
X_6994_ _7241_/CLK _6994_/D VGND VGND VPWR VPWR _6994_/Q sky130_fd_sc_hd__dfxtp_2
X_5945_ _6229_/A1 _6229_/A2 _6229_/B1 _7587_/Q VGND VGND VPWR VPWR _5945_/X sky130_fd_sc_hd__o22a_2
XFILLER_33_281 VGND VGND VPWR VPWR sky130_fd_sc_hd__decap_3
X_5876_ _6448_/A1 _7177_/Q _7149_/Q _6448_/B2 VGND VGND VPWR VPWR _5876_/X sky130_fd_sc_hd__o22a_2
XTAP_TAPCELL_ROW_51_758 VGND VPWR sky130_fd_sc_hd__tapvpwrvgnd_1
XFILLER_5_609 VGND VGND VPWR VPWR sky130_fd_sc_hd__decap_3
X_7546_ clkload3/A _7546_/D place2066/X VGND VGND VPWR VPWR _7546_/Q sky130_fd_sc_hd__dfrtp_2
X_7477_ _7542_/CLK _7477_/D place2047/X VGND VGND VPWR VPWR _7477_/Q sky130_fd_sc_hd__dfrtp_2
X_3709_ _3780_/A1 _3815_/A2 _7384_/Q _3815_/B1 _7576_/Q VGND VGND VPWR VPWR _3709_/X
+ sky130_fd_sc_hd__a32o_2
XTAP_TAPCELL_ROW_95_1223 VGND VPWR sky130_fd_sc_hd__tapvpwrvgnd_1
X_6428_ _6426_/X _6427_/X _6048_/A VGND VGND VPWR VPWR _6435_/B sky130_fd_sc_hd__a21oi_2
Xplace1872 _6769_/S VGND VGND VPWR VPWR _6765_/S sky130_fd_sc_hd__buf_2
Xplace1861 _3519_/C VGND VGND VPWR VPWR _3652_/B sky130_fd_sc_hd__buf_6
Xplace1850 _3463_/X VGND VGND VPWR VPWR _4734_/A3 sky130_fd_sc_hd__buf_2
XFILLER_88_421 VGND VGND VPWR VPWR sky130_fd_sc_hd__fill_1
Xplace1894 _3524_/B VGND VGND VPWR VPWR _5847_/A3 sky130_fd_sc_hd__buf_2
Xplace1883 _3499_/A VGND VGND VPWR VPWR _3440_/B2 sky130_fd_sc_hd__buf_2
X_6359_ _6651_/A0 _6362_/A2 _6362_/A3 _6363_/B1 _7392_/Q VGND VGND VPWR VPWR _6359_/X
+ sky130_fd_sc_hd__a32o_2
XFILLER_102_253 VGND VGND VPWR VPWR sky130_fd_sc_hd__decap_3
Xhold2530 _7046_/Q VGND VGND VPWR VPWR _5169_/A0 sky130_fd_sc_hd__dlygate4sd3_1
Xhold2574 _7155_/Q VGND VGND VPWR VPWR _5435_/A0 sky130_fd_sc_hd__dlygate4sd3_1
Xhold2563 _6942_/Q VGND VGND VPWR VPWR _4937_/A0 sky130_fd_sc_hd__dlygate4sd3_1
Xhold2552 _7015_/Q VGND VGND VPWR VPWR _5101_/A0 sky130_fd_sc_hd__dlygate4sd3_1
Xhold2541 _7127_/Q VGND VGND VPWR VPWR _5374_/A0 sky130_fd_sc_hd__dlygate4sd3_1
XTAP_TAPCELL_ROW_59_847 VGND VPWR sky130_fd_sc_hd__tapvpwrvgnd_1
XFILLER_29_532 VGND VGND VPWR VPWR sky130_fd_sc_hd__decap_3
Xhold2596 _7195_/Q VGND VGND VPWR VPWR _5522_/A0 sky130_fd_sc_hd__dlygate4sd3_1
Xhold2585 _7106_/Q VGND VGND VPWR VPWR _5327_/A0 sky130_fd_sc_hd__dlygate4sd3_1
XFILLER_16_215 VGND VGND VPWR VPWR sky130_fd_sc_hd__decap_3
XFILLER_71_365 VGND VGND VPWR VPWR sky130_fd_sc_hd__fill_2
XFILLER_8_436 VGND VGND VPWR VPWR sky130_fd_sc_hd__fill_2
XPHY_EDGE_ROW_89_Left_193 VGND VGND VPWR VPWR sky130_fd_sc_hd__decap_3
XFILLER_12_6 VGND VGND VPWR VPWR sky130_fd_sc_hd__decap_3
XFILLER_47_340 VGND VGND VPWR VPWR sky130_fd_sc_hd__decap_3
XFILLER_66_137 VGND VGND VPWR VPWR sky130_fd_sc_hd__decap_3
XFILLER_35_502 VGND VGND VPWR VPWR sky130_fd_sc_hd__fill_2
XFILLER_62_365 VGND VGND VPWR VPWR sky130_fd_sc_hd__decap_3
X_3991_ _7490_/Q _3968_/B _3990_/X VGND VGND VPWR VPWR _3994_/A sky130_fd_sc_hd__a21oi_2
XFILLER_95_3 VGND VGND VPWR VPWR sky130_fd_sc_hd__decap_3
X_5730_ _5730_/A0 _5730_/A1 _5730_/S VGND VGND VPWR VPWR _7291_/D sky130_fd_sc_hd__mux2_2
X_7400_ _7493_/CLK _7400_/D place2042/X VGND VGND VPWR VPWR _7400_/Q sky130_fd_sc_hd__dfrtp_2
X_5661_ _5661_/A0 _5661_/A1 _5669_/S VGND VGND VPWR VPWR _7259_/D sky130_fd_sc_hd__mux2_2
X_4612_ _4576_/X _4612_/A1 _4629_/S VGND VGND VPWR VPWR _4612_/X sky130_fd_sc_hd__mux2_2
X_7331_ _7581_/CLK _7331_/D place2023/X VGND VGND VPWR VPWR _7331_/Q sky130_fd_sc_hd__dfrtp_2
Xplace1102 _4223_/X VGND VGND VPWR VPWR _6161_/A1 sky130_fd_sc_hd__buf_2
Xplace1113 _4738_/Y VGND VGND VPWR VPWR _5351_/A1 sky130_fd_sc_hd__buf_2
Xplace1124 _4700_/X VGND VGND VPWR VPWR _5707_/A1 sky130_fd_sc_hd__buf_2
X_7262_ _7290_/CLK _7262_/D VGND VGND VPWR VPWR _7262_/Q sky130_fd_sc_hd__dfxtp_2
Xplace1135 _4255_/Y VGND VGND VPWR VPWR _4267_/A1 sky130_fd_sc_hd__buf_6
Xplace1146 _4241_/Y VGND VGND VPWR VPWR _4242_/A2 sky130_fd_sc_hd__buf_2
Xplace1157 _4614_/X VGND VGND VPWR VPWR _5317_/A1 sky130_fd_sc_hd__buf_2
Xplace1168 _5211_/S VGND VGND VPWR VPWR _5181_/S sky130_fd_sc_hd__buf_2
Xrebuffer2114 _3838_/A2 VGND VGND VPWR VPWR _3857_/A2 sky130_fd_sc_hd__buf_4
Xrebuffer2125 place1720/X VGND VGND VPWR VPWR _3984_/B1 sky130_fd_sc_hd__buf_2
Xrebuffer2136 _3652_/B VGND VGND VPWR VPWR _3505_/C1 sky130_fd_sc_hd__buf_2
Xrebuffer2147 _3983_/B VGND VGND VPWR VPWR _3993_/B1 sky130_fd_sc_hd__buf_6
X_6213_ _6213_/A1 _7007_/Q _6979_/Q _6213_/B2 VGND VGND VPWR VPWR _6213_/X sky130_fd_sc_hd__o22a_2
X_4474_ _4481_/B _4477_/C _7306_/Q VGND VGND VPWR VPWR _4474_/X sky130_fd_sc_hd__a21o_2
Xplace1179 _4147_/Y VGND VGND VPWR VPWR _6016_/A1 sky130_fd_sc_hd__buf_2
Xrebuffer2158 _5750_/X VGND VGND VPWR VPWR _6424_/B2 sky130_fd_sc_hd__buf_2
Xrebuffer2169 _6136_/A2 VGND VGND VPWR VPWR _5815_/A1 sky130_fd_sc_hd__buf_2
X_7193_ _7282_/CLK _7193_/D VGND VGND VPWR VPWR _7193_/Q sky130_fd_sc_hd__dfxtp_2
X_3425_ _3415_/Y _3417_/Y _3421_/Y _3424_/Y VGND VGND VPWR VPWR _3598_/A sky130_fd_sc_hd__a31oi_4
X_6144_ _6219_/A1 _6220_/A2 _6185_/B1 _7599_/Q _6143_/X VGND VGND VPWR VPWR _6144_/X
+ sky130_fd_sc_hd__o221a_4
XTAP_TAPCELL_ROW_90_1164 VGND VPWR sky130_fd_sc_hd__tapvpwrvgnd_1
X_5026_ _5026_/A0 _5296_/A1 _5028_/S VGND VGND VPWR VPWR _6981_/D sky130_fd_sc_hd__mux2_2
XFILLER_26_513 VGND VGND VPWR VPWR sky130_fd_sc_hd__decap_3
XTAP_TAPCELL_ROW_56_806 VGND VPWR sky130_fd_sc_hd__tapvpwrvgnd_1
XTAP_TAPCELL_ROW_28_519 VGND VPWR sky130_fd_sc_hd__tapvpwrvgnd_1
XFILLER_13_207 VGND VGND VPWR VPWR sky130_fd_sc_hd__decap_3
X_6977_ _7276_/CLK _6977_/D VGND VGND VPWR VPWR _6977_/Q sky130_fd_sc_hd__dfxtp_2
XFILLER_41_538 VGND VGND VPWR VPWR sky130_fd_sc_hd__decap_3
X_5928_ _6484_/A2 _7070_/Q _7042_/Q _6480_/B2 VGND VGND VPWR VPWR _5928_/X sky130_fd_sc_hd__o22a_2
XTAP_TAPCELL_ROW_64_894 VGND VPWR sky130_fd_sc_hd__tapvpwrvgnd_1
XTAP_TAPCELL_ROW_36_596 VGND VPWR sky130_fd_sc_hd__tapvpwrvgnd_1
XFILLER_21_284 VGND VGND VPWR VPWR sky130_fd_sc_hd__decap_3
XFILLER_5_417 VGND VGND VPWR VPWR sky130_fd_sc_hd__fill_1
X_7529_ clkload4/A _7529_/D place2065/X VGND VGND VPWR VPWR _7529_/Q sky130_fd_sc_hd__dfrtp_2
XFILLER_5_439 VGND VGND VPWR VPWR sky130_fd_sc_hd__fill_2
XFILLER_79_47 VGND VGND VPWR VPWR sky130_fd_sc_hd__fill_1
XFILLER_0_100 VGND VGND VPWR VPWR sky130_fd_sc_hd__decap_3
Xplace1680 _6363_/A2 VGND VGND VPWR VPWR _6362_/A2 sky130_fd_sc_hd__buf_2
Xplace1691 _5843_/B VGND VGND VPWR VPWR _4325_/B sky130_fd_sc_hd__buf_2
XFILLER_0_155 VGND VGND VPWR VPWR sky130_fd_sc_hd__decap_3
XFILLER_0_166 VGND VGND VPWR VPWR sky130_fd_sc_hd__fill_2
XFILLER_48_115 VGND VGND VPWR VPWR sky130_fd_sc_hd__decap_3
XFILLER_88_273 VGND VGND VPWR VPWR sky130_fd_sc_hd__fill_2
XFILLER_95_24 VGND VGND VPWR VPWR sky130_fd_sc_hd__decap_3
Xhold2382 _7009_/Q VGND VGND VPWR VPWR _5087_/A0 sky130_fd_sc_hd__dlygate4sd3_1
Xhold2371 _6869_/Q VGND VGND VPWR VPWR _4765_/A0 sky130_fd_sc_hd__dlygate4sd3_1
XFILLER_29_340 VGND VGND VPWR VPWR sky130_fd_sc_hd__decap_3
Xhold2393 _7259_/Q VGND VGND VPWR VPWR _5661_/A0 sky130_fd_sc_hd__dlygate4sd3_1
XFILLER_28_95 VGND VGND VPWR VPWR sky130_fd_sc_hd__fill_1
XFILLER_44_321 VGND VGND VPWR VPWR sky130_fd_sc_hd__decap_3
XFILLER_56_192 VGND VGND VPWR VPWR sky130_fd_sc_hd__decap_3
XFILLER_44_343 VGND VGND VPWR VPWR sky130_fd_sc_hd__decap_3
XFILLER_32_549 VGND VGND VPWR VPWR sky130_fd_sc_hd__decap_3
XFILLER_44_398 VGND VGND VPWR VPWR sky130_fd_sc_hd__fill_1
XFILLER_44_94 VGND VGND VPWR VPWR sky130_fd_sc_hd__decap_3
XFILLER_71_195 VGND VGND VPWR VPWR sky130_fd_sc_hd__decap_3
XFILLER_12_251 VGND VGND VPWR VPWR sky130_fd_sc_hd__fill_1
XFILLER_8_200 VGND VGND VPWR VPWR sky130_fd_sc_hd__decap_3
XPHY_EDGE_ROW_97_Left_201 VGND VGND VPWR VPWR sky130_fd_sc_hd__decap_3
X_4190_ _4190_/A _4190_/B VGND VGND VPWR VPWR _4190_/Y sky130_fd_sc_hd__nor2_2
XFILLER_10_3 VGND VGND VPWR VPWR sky130_fd_sc_hd__fill_2
XFILLER_35_321 VGND VGND VPWR VPWR sky130_fd_sc_hd__fill_2
XFILLER_35_332 VGND VGND VPWR VPWR sky130_fd_sc_hd__decap_3
XFILLER_47_181 VGND VGND VPWR VPWR sky130_fd_sc_hd__decap_3
XFILLER_94_298 VGND VGND VPWR VPWR sky130_fd_sc_hd__fill_2
X_6900_ _7276_/CLK _6900_/D VGND VGND VPWR VPWR _6900_/Q sky130_fd_sc_hd__dfxtp_2
XFILLER_62_173 VGND VGND VPWR VPWR sky130_fd_sc_hd__decap_3
XFILLER_50_346 VGND VGND VPWR VPWR sky130_fd_sc_hd__decap_3
X_3974_ _3946_/X _3974_/A2 _3957_/X _4579_/B _3973_/Y VGND VGND VPWR VPWR _4017_/C
+ sky130_fd_sc_hd__o2111ai_2
XFILLER_50_368 VGND VGND VPWR VPWR sky130_fd_sc_hd__decap_3
X_5713_ _5713_/A0 _5713_/A1 _5730_/S VGND VGND VPWR VPWR _7283_/D sky130_fd_sc_hd__mux2_2
XTAP_TAPCELL_ROW_61_864 VGND VPWR sky130_fd_sc_hd__tapvpwrvgnd_1
XTAP_TAPCELL_ROW_33_566 VGND VPWR sky130_fd_sc_hd__tapvpwrvgnd_1
X_5644_ _5644_/A0 _5705_/A1 _5654_/S VGND VGND VPWR VPWR _7251_/D sky130_fd_sc_hd__mux2_2
XTAP_TAPCELL_ROW_79_1048 VGND VPWR sky130_fd_sc_hd__tapvpwrvgnd_1
X_7314_ _7606_/CLK _7314_/D place2051/X VGND VGND VPWR VPWR _7314_/Q sky130_fd_sc_hd__dfrtp_2
XFILLER_2_409 VGND VGND VPWR VPWR sky130_fd_sc_hd__decap_3
X_4526_ _4532_/A _4532_/D _4532_/B VGND VGND VPWR VPWR _4527_/C sky130_fd_sc_hd__a21oi_2
X_7245_ _7273_/CLK _7245_/D VGND VGND VPWR VPWR _7245_/Q sky130_fd_sc_hd__dfxtp_2
X_4457_ _4475_/S _4457_/B _4456_/Y VGND VGND VPWR VPWR _4457_/X sky130_fd_sc_hd__or3b_2
X_7176_ _7288_/CLK _7176_/D VGND VGND VPWR VPWR _7176_/Q sky130_fd_sc_hd__dfxtp_2
XFILLER_58_424 VGND VGND VPWR VPWR sky130_fd_sc_hd__fill_1
X_6127_ _4204_/X _6161_/A2 _6184_/B1 _6126_/X _6184_/C1 VGND VGND VPWR VPWR _6127_/X
+ sky130_fd_sc_hd__a221o_2
X_4388_ _4387_/X _7589_/D _4388_/S VGND VGND VPWR VPWR _4388_/X sky130_fd_sc_hd__mux2_2
XFILLER_58_435 VGND VGND VPWR VPWR sky130_fd_sc_hd__fill_2
XFILLER_58_446 VGND VGND VPWR VPWR sky130_fd_sc_hd__fill_2
XFILLER_100_565 VGND VGND VPWR VPWR sky130_fd_sc_hd__fill_2
X_6058_ _6220_/A1 _6182_/A2 _6220_/B1 _7591_/Q _6057_/X VGND VGND VPWR VPWR _6058_/X
+ sky130_fd_sc_hd__o221a_2
X_5009_ _5009_/A0 _5342_/A1 _5024_/S VGND VGND VPWR VPWR _6973_/D sky130_fd_sc_hd__mux2_2
XFILLER_26_354 VGND VGND VPWR VPWR sky130_fd_sc_hd__fill_2
XFILLER_26_365 VGND VGND VPWR VPWR sky130_fd_sc_hd__decap_3
XFILLER_41_357 VGND VGND VPWR VPWR sky130_fd_sc_hd__decap_3
XFILLER_30_63 VGND VGND VPWR VPWR sky130_fd_sc_hd__fill_2
XFILLER_30_85 VGND VGND VPWR VPWR sky130_fd_sc_hd__decap_3
XFILLER_96_519 VGND VGND VPWR VPWR sky130_fd_sc_hd__decap_3
XFILLER_39_83 VGND VGND VPWR VPWR sky130_fd_sc_hd__decap_3
XFILLER_76_276 VGND VGND VPWR VPWR sky130_fd_sc_hd__decap_3
XFILLER_57_490 VGND VGND VPWR VPWR sky130_fd_sc_hd__decap_3
XPHY_EDGE_ROW_101_Right_101 VGND VGND VPWR VPWR sky130_fd_sc_hd__decap_3
XFILLER_44_151 VGND VGND VPWR VPWR sky130_fd_sc_hd__decap_3
XFILLER_44_162 VGND VGND VPWR VPWR sky130_fd_sc_hd__fill_1
XFILLER_32_335 VGND VGND VPWR VPWR sky130_fd_sc_hd__decap_3
XFILLER_32_357 VGND VGND VPWR VPWR sky130_fd_sc_hd__decap_3
XFILLER_32_368 VGND VGND VPWR VPWR sky130_fd_sc_hd__decap_3
XFILLER_9_520 VGND VGND VPWR VPWR sky130_fd_sc_hd__decap_3
XTAP_TAPCELL_ROW_30_536 VGND VPWR sky130_fd_sc_hd__tapvpwrvgnd_1
XFILLER_58_3 VGND VGND VPWR VPWR sky130_fd_sc_hd__decap_3
X_7030_ _7114_/CLK _7030_/D VGND VGND VPWR VPWR _7030_/Q sky130_fd_sc_hd__dfxtp_2
X_4242_ _4242_/A1 _4242_/A2 _4248_/A1 VGND VGND VPWR VPWR _4242_/Y sky130_fd_sc_hd__o21ai_2
X_4173_ _4176_/A1 _4176_/A2 _3887_/D VGND VGND VPWR VPWR _4174_/B sky130_fd_sc_hd__a21o_2
XTAP_TAPCELL_ROW_66_912 VGND VPWR sky130_fd_sc_hd__tapvpwrvgnd_1
XFILLER_55_449 VGND VGND VPWR VPWR sky130_fd_sc_hd__decap_3
XTAP_TAPCELL_ROW_38_625 VGND VPWR sky130_fd_sc_hd__tapvpwrvgnd_1
XTAP_TAPCELL_ROW_2_239 VGND VPWR sky130_fd_sc_hd__tapvpwrvgnd_1
XFILLER_35_162 VGND VGND VPWR VPWR sky130_fd_sc_hd__fill_2
XFILLER_23_324 VGND VGND VPWR VPWR sky130_fd_sc_hd__decap_3
XFILLER_35_184 VGND VGND VPWR VPWR sky130_fd_sc_hd__decap_3
XFILLER_50_110 VGND VGND VPWR VPWR sky130_fd_sc_hd__decap_3
XFILLER_50_132 VGND VGND VPWR VPWR sky130_fd_sc_hd__decap_3
X_6814_ _6842_/A _6814_/B VGND VGND VPWR VPWR _7565_/D sky130_fd_sc_hd__and2_2
XFILLER_50_154 VGND VGND VPWR VPWR sky130_fd_sc_hd__decap_3
X_3957_ _3957_/A _3957_/B _4099_/A VGND VGND VPWR VPWR _3957_/X sky130_fd_sc_hd__or3_4
XFILLER_50_176 VGND VGND VPWR VPWR sky130_fd_sc_hd__fill_2
XFILLER_50_187 VGND VGND VPWR VPWR sky130_fd_sc_hd__decap_3
X_3888_ _3842_/C _5839_/B1 _7366_/Q _4395_/A1 _7558_/Q VGND VGND VPWR VPWR _3888_/X
+ sky130_fd_sc_hd__a32o_2
X_5627_ _5627_/A0 _5688_/A1 _5637_/S VGND VGND VPWR VPWR _7243_/D sky130_fd_sc_hd__mux2_2
XFILLER_2_206 VGND VGND VPWR VPWR sky130_fd_sc_hd__fill_2
X_4509_ _4475_/S _4506_/X _4507_/Y _4508_/X VGND VGND VPWR VPWR _4509_/X sky130_fd_sc_hd__o31a_2
X_7228_ _7575_/CLK _7228_/D VGND VGND VPWR VPWR _7228_/Q sky130_fd_sc_hd__dfxtp_2
XFILLER_58_221 VGND VGND VPWR VPWR sky130_fd_sc_hd__decap_3
XFILLER_86_541 VGND VGND VPWR VPWR sky130_fd_sc_hd__fill_2
X_7159_ _7217_/CLK _7159_/D VGND VGND VPWR VPWR _7159_/Q sky130_fd_sc_hd__dfxtp_2
XFILLER_100_351 VGND VGND VPWR VPWR sky130_fd_sc_hd__decap_3
XFILLER_58_276 VGND VGND VPWR VPWR sky130_fd_sc_hd__decap_3
XFILLER_18_118 VGND VGND VPWR VPWR sky130_fd_sc_hd__decap_3
XFILLER_39_490 VGND VGND VPWR VPWR sky130_fd_sc_hd__fill_2
Xclkbuf_leaf_38_clk clkbuf_3_2__f_clk/X VGND VGND VPWR VPWR _7608_/CLK sky130_fd_sc_hd__clkbuf_16
XFILLER_25_30 VGND VGND VPWR VPWR sky130_fd_sc_hd__decap_3
XFILLER_42_611 VGND VGND VPWR VPWR sky130_fd_sc_hd__fill_1
XFILLER_14_368 VGND VGND VPWR VPWR sky130_fd_sc_hd__fill_2
XFILLER_25_96 VGND VGND VPWR VPWR sky130_fd_sc_hd__fill_2
XFILLER_41_165 VGND VGND VPWR VPWR sky130_fd_sc_hd__decap_3
XFILLER_41_176 VGND VGND VPWR VPWR sky130_fd_sc_hd__decap_3
XFILLER_6_589 VGND VGND VPWR VPWR sky130_fd_sc_hd__decap_3
XFILLER_96_349 VGND VGND VPWR VPWR sky130_fd_sc_hd__fill_1
XFILLER_49_287 VGND VGND VPWR VPWR sky130_fd_sc_hd__fill_1
XFILLER_66_81 VGND VGND VPWR VPWR sky130_fd_sc_hd__decap_3
Xclkbuf_leaf_29_clk clkbuf_3_6__f_clk/X VGND VGND VPWR VPWR _7407_/CLK sky130_fd_sc_hd__clkbuf_16
XFILLER_17_140 VGND VGND VPWR VPWR sky130_fd_sc_hd__fill_2
XFILLER_17_162 VGND VGND VPWR VPWR sky130_fd_sc_hd__decap_3
XFILLER_45_460 VGND VGND VPWR VPWR sky130_fd_sc_hd__decap_3
XFILLER_52_419 VGND VGND VPWR VPWR sky130_fd_sc_hd__fill_1
XFILLER_17_195 VGND VGND VPWR VPWR sky130_fd_sc_hd__decap_3
X_4860_ _4860_/A0 _5688_/A1 _4870_/S VGND VGND VPWR VPWR _6907_/D sky130_fd_sc_hd__mux2_2
XFILLER_32_165 VGND VGND VPWR VPWR sky130_fd_sc_hd__decap_3
X_3811_ _6330_/B2 _3811_/A2 _3907_/B1 _7406_/Q VGND VGND VPWR VPWR _3813_/B sky130_fd_sc_hd__a22oi_2
XTAP_TAPCELL_ROW_71_970 VGND VPWR sky130_fd_sc_hd__tapvpwrvgnd_1
XANTENNA_17 _7058_/Q VGND VGND VPWR VPWR sky130_fd_sc_hd__diode_2
XANTENNA_28 _5003_/A0 VGND VGND VPWR VPWR sky130_fd_sc_hd__diode_2
XANTENNA_39 _7536_/Q VGND VGND VPWR VPWR sky130_fd_sc_hd__diode_2
XFILLER_20_327 VGND VGND VPWR VPWR sky130_fd_sc_hd__decap_3
XPHY_EDGE_ROW_25_Left_129 VGND VGND VPWR VPWR sky130_fd_sc_hd__decap_3
X_4791_ _4791_/A0 _5681_/A1 _4808_/S VGND VGND VPWR VPWR _6876_/D sky130_fd_sc_hd__mux2_2
XTAP_TAPCELL_ROW_43_672 VGND VPWR sky130_fd_sc_hd__tapvpwrvgnd_1
XTAP_TAPCELL_ROW_15_385 VGND VPWR sky130_fd_sc_hd__tapvpwrvgnd_1
X_3742_ _3742_/A _3742_/B _3742_/C _3742_/D VGND VGND VPWR VPWR _3742_/Y sky130_fd_sc_hd__nor4_4
X_6461_ _7079_/Q _6502_/A2 _6502_/B1 _7107_/Q _6460_/X VGND VGND VPWR VPWR _6461_/X
+ sky130_fd_sc_hd__o221a_2
X_3673_ _3717_/A1 _3792_/A2 _7382_/Q _3792_/B1 _7574_/Q VGND VGND VPWR VPWR _3673_/X
+ sky130_fd_sc_hd__a32o_2
X_6392_ _6392_/A _6392_/B VGND VGND VPWR VPWR _6403_/A sky130_fd_sc_hd__nor2_2
XTAP_TAPCELL_ROW_76_1018 VGND VPWR sky130_fd_sc_hd__tapvpwrvgnd_1
XPHY_EDGE_ROW_34_Left_138 VGND VGND VPWR VPWR sky130_fd_sc_hd__decap_3
Xhold2904 _7506_/Q VGND VGND VPWR VPWR _6689_/A0 sky130_fd_sc_hd__dlygate4sd3_1
X_5274_ _5274_/A0 _5344_/A1 _5293_/S VGND VGND VPWR VPWR _7086_/D sky130_fd_sc_hd__mux2_2
Xhold2915 _7339_/Q VGND VGND VPWR VPWR _6264_/B sky130_fd_sc_hd__dlygate4sd3_1
Xhold2926 _7384_/Q VGND VGND VPWR VPWR _6343_/B2 sky130_fd_sc_hd__dlygate4sd3_1
Xhold2937 _7496_/Q VGND VGND VPWR VPWR _6668_/A0 sky130_fd_sc_hd__dlygate4sd3_1
Xhold2948 _7367_/Q VGND VGND VPWR VPWR _6320_/B2 sky130_fd_sc_hd__dlygate4sd3_1
X_7013_ _7266_/CLK _7013_/D VGND VGND VPWR VPWR _7013_/Q sky130_fd_sc_hd__dfxtp_2
X_4225_ _4225_/A1 _4224_/Y _4225_/A3 _3785_/A _4220_/A VGND VGND VPWR VPWR _4226_/A
+ sky130_fd_sc_hd__o32ai_2
Xhold2959 _7376_/Q VGND VGND VPWR VPWR _6332_/B2 sky130_fd_sc_hd__dlygate4sd3_1
XFILLER_28_427 VGND VGND VPWR VPWR sky130_fd_sc_hd__decap_3
XFILLER_55_213 VGND VGND VPWR VPWR sky130_fd_sc_hd__fill_2
XFILLER_95_393 VGND VGND VPWR VPWR sky130_fd_sc_hd__decap_3
X_4087_ _4542_/B _4548_/A _4558_/B _4085_/D _7320_/Q VGND VGND VPWR VPWR _4089_/A
+ sky130_fd_sc_hd__a41o_2
XTAP_TAPCELL_ROW_87_1136 VGND VPWR sky130_fd_sc_hd__tapvpwrvgnd_1
XFILLER_102_24 VGND VGND VPWR VPWR sky130_fd_sc_hd__decap_3
XFILLER_102_79 VGND VGND VPWR VPWR sky130_fd_sc_hd__decap_3
XPHY_EDGE_ROW_43_Left_147 VGND VGND VPWR VPWR sky130_fd_sc_hd__decap_3
XFILLER_23_143 VGND VGND VPWR VPWR sky130_fd_sc_hd__fill_1
XFILLER_23_165 VGND VGND VPWR VPWR sky130_fd_sc_hd__decap_3
XTAP_TAPCELL_ROW_98_1254 VGND VPWR sky130_fd_sc_hd__tapvpwrvgnd_1
XFILLER_11_43 VGND VGND VPWR VPWR sky130_fd_sc_hd__fill_1
XFILLER_11_54 VGND VGND VPWR VPWR sky130_fd_sc_hd__fill_2
XFILLER_3_548 VGND VGND VPWR VPWR sky130_fd_sc_hd__decap_3
XPHY_EDGE_ROW_52_Left_156 VGND VGND VPWR VPWR sky130_fd_sc_hd__decap_3
XFILLER_74_533 VGND VGND VPWR VPWR sky130_fd_sc_hd__decap_3
XFILLER_86_371 VGND VGND VPWR VPWR sky130_fd_sc_hd__fill_1
XFILLER_46_235 VGND VGND VPWR VPWR sky130_fd_sc_hd__decap_3
XFILLER_46_246 VGND VGND VPWR VPWR sky130_fd_sc_hd__fill_2
XFILLER_34_419 VGND VGND VPWR VPWR sky130_fd_sc_hd__fill_1
XPHY_EDGE_ROW_61_Left_165 VGND VGND VPWR VPWR sky130_fd_sc_hd__decap_3
XFILLER_36_95 VGND VGND VPWR VPWR sky130_fd_sc_hd__fill_1
XFILLER_61_249 VGND VGND VPWR VPWR sky130_fd_sc_hd__fill_1
XFILLER_14_154 VGND VGND VPWR VPWR sky130_fd_sc_hd__decap_3
XFILLER_42_463 VGND VGND VPWR VPWR sky130_fd_sc_hd__decap_3
XFILLER_52_72 VGND VGND VPWR VPWR sky130_fd_sc_hd__fill_1
XFILLER_52_83 VGND VGND VPWR VPWR sky130_fd_sc_hd__fill_1
XTAP_TAPCELL_ROW_40_642 VGND VPWR sky130_fd_sc_hd__tapvpwrvgnd_1
XTAP_TAPCELL_ROW_12_344 VGND VPWR sky130_fd_sc_hd__tapvpwrvgnd_1
XFILLER_6_342 VGND VGND VPWR VPWR sky130_fd_sc_hd__decap_3
XPHY_EDGE_ROW_70_Left_174 VGND VGND VPWR VPWR sky130_fd_sc_hd__decap_3
Xplace1509 _3793_/X VGND VGND VPWR VPWR _4697_/B1 sky130_fd_sc_hd__buf_2
XFILLER_69_316 VGND VGND VPWR VPWR sky130_fd_sc_hd__decap_3
X_4010_ _4010_/A _4011_/C _4011_/B _4011_/A VGND VGND VPWR VPWR _4133_/A sky130_fd_sc_hd__nand4_2
XFILLER_37_202 VGND VGND VPWR VPWR sky130_fd_sc_hd__decap_3
XFILLER_77_393 VGND VGND VPWR VPWR sky130_fd_sc_hd__fill_2
XTAP_TAPCELL_ROW_48_731 VGND VPWR sky130_fd_sc_hd__tapvpwrvgnd_1
XFILLER_18_460 VGND VGND VPWR VPWR sky130_fd_sc_hd__fill_2
XFILLER_18_471 VGND VGND VPWR VPWR sky130_fd_sc_hd__decap_3
XFILLER_25_408 VGND VGND VPWR VPWR sky130_fd_sc_hd__fill_1
XFILLER_25_419 VGND VGND VPWR VPWR sky130_fd_sc_hd__fill_2
XFILLER_92_363 VGND VGND VPWR VPWR sky130_fd_sc_hd__fill_1
X_5961_ _5959_/X _5960_/X _6505_/B1 _6070_/A2 VGND VGND VPWR VPWR _5962_/D sky130_fd_sc_hd__a211o_2
XFILLER_18_493 VGND VGND VPWR VPWR sky130_fd_sc_hd__decap_3
XFILLER_45_290 VGND VGND VPWR VPWR sky130_fd_sc_hd__fill_1
XFILLER_33_452 VGND VGND VPWR VPWR sky130_fd_sc_hd__decap_3
X_5892_ _6395_/B1 _5877_/X _5891_/X VGND VGND VPWR VPWR _5892_/Y sky130_fd_sc_hd__o21ai_2
X_4843_ _5427_/A _5671_/B _5549_/B VGND VGND VPWR VPWR _4900_/S sky130_fd_sc_hd__and3_2
XTAP_TAPCELL_ROW_82_1088 VGND VPWR sky130_fd_sc_hd__tapvpwrvgnd_1
XFILLER_20_135 VGND VGND VPWR VPWR sky130_fd_sc_hd__decap_3
XFILLER_20_157 VGND VGND VPWR VPWR sky130_fd_sc_hd__decap_3
X_7562_ _7579_/CLK _7562_/D place2014/X VGND VGND VPWR VPWR _7562_/Q sky130_fd_sc_hd__dfrtp_2
X_4774_ _6404_/A2 _4774_/A2 _4773_/X VGND VGND VPWR VPWR _4774_/Y sky130_fd_sc_hd__a21oi_2
X_7493_ _7493_/CLK _7493_/D place2042/X VGND VGND VPWR VPWR _7493_/Q sky130_fd_sc_hd__dfrtp_2
X_6513_ _6506_/X _6509_/X _6512_/X _6513_/B1 VGND VGND VPWR VPWR _6513_/X sky130_fd_sc_hd__a31o_2
X_3725_ _7513_/Q _3725_/A2 _3757_/B1 _7449_/Q VGND VGND VPWR VPWR _4287_/B sky130_fd_sc_hd__a22oi_2
XFILLER_9_191 VGND VGND VPWR VPWR sky130_fd_sc_hd__fill_1
Xclkbuf_leaf_9_clk clkbuf_leaf_9_clk/A VGND VGND VPWR VPWR _7272_/CLK sky130_fd_sc_hd__clkbuf_16
X_6444_ _6444_/A0 _5863_/X _6497_/S VGND VGND VPWR VPWR _7424_/D sky130_fd_sc_hd__mux2_2
X_3587_ _4313_/B _3592_/B1 _3587_/B1 _3957_/B VGND VGND VPWR VPWR _3587_/X sky130_fd_sc_hd__o22a_4
XFILLER_0_518 VGND VGND VPWR VPWR sky130_fd_sc_hd__decap_3
Xoutput2075 _6079_/A1 VGND VGND VPWR VPWR result[14] sky130_fd_sc_hd__dlygate4sd1_1
Xoutput2086 _4243_/X VGND VGND VPWR VPWR result[24] sky130_fd_sc_hd__dlymetal6s4s_1
Xoutput2097 _4114_/Y VGND VGND VPWR VPWR result[5] sky130_fd_sc_hd__clkdlybuf4s25_1
Xhold2701 _7011_/Q VGND VGND VPWR VPWR _5091_/A0 sky130_fd_sc_hd__dlygate4sd3_1
Xhold2712 _6997_/Q VGND VGND VPWR VPWR _5062_/A0 sky130_fd_sc_hd__dlygate4sd3_1
Xhold2723 _7064_/Q VGND VGND VPWR VPWR _5207_/A0 sky130_fd_sc_hd__dlygate4sd3_1
XTAP_TAPCELL_ROW_93_1195 VGND VPWR sky130_fd_sc_hd__tapvpwrvgnd_1
XFILLER_75_319 VGND VGND VPWR VPWR sky130_fd_sc_hd__fill_1
Xhold2734 _7025_/Q VGND VGND VPWR VPWR _5123_/A0 sky130_fd_sc_hd__dlygate4sd3_1
Xhold2745 _6410_/X VGND VGND VPWR VPWR _7417_/D sky130_fd_sc_hd__dlygate4sd3_1
Xhold2756 _7118_/Q VGND VGND VPWR VPWR _5353_/A0 sky130_fd_sc_hd__dlygate4sd3_1
X_4208_ _4206_/Y _4204_/C _4235_/A _4207_/Y VGND VGND VPWR VPWR _4208_/Y sky130_fd_sc_hd__a211oi_4
XFILLER_56_522 VGND VGND VPWR VPWR sky130_fd_sc_hd__fill_1
Xhold2767 _7131_/Q VGND VGND VPWR VPWR _5383_/A0 sky130_fd_sc_hd__dlygate4sd3_1
Xhold2778 _6999_/Q VGND VGND VPWR VPWR _5066_/A0 sky130_fd_sc_hd__dlygate4sd3_1
Xhold2789 _6879_/Q VGND VGND VPWR VPWR _4798_/A0 sky130_fd_sc_hd__dlygate4sd3_1
X_5188_ _5188_/A0 _5188_/A1 _5207_/S VGND VGND VPWR VPWR _7055_/D sky130_fd_sc_hd__mux2_2
XFILLER_56_533 VGND VGND VPWR VPWR sky130_fd_sc_hd__decap_3
XFILLER_56_566 VGND VGND VPWR VPWR sky130_fd_sc_hd__decap_3
XFILLER_28_268 VGND VGND VPWR VPWR sky130_fd_sc_hd__decap_3
XFILLER_43_216 VGND VGND VPWR VPWR sky130_fd_sc_hd__decap_3
XFILLER_71_503 VGND VGND VPWR VPWR sky130_fd_sc_hd__fill_1
XFILLER_73_16 VGND VGND VPWR VPWR sky130_fd_sc_hd__decap_3
XFILLER_24_430 VGND VGND VPWR VPWR sky130_fd_sc_hd__decap_3
XTAP_TAPCELL_ROW_54_789 VGND VPWR sky130_fd_sc_hd__tapvpwrvgnd_1
XFILLER_51_293 VGND VGND VPWR VPWR sky130_fd_sc_hd__fill_2
XTAP_TAPCELL_ROW_102_1291 VGND VPWR sky130_fd_sc_hd__tapvpwrvgnd_1
XFILLER_11_157 VGND VGND VPWR VPWR sky130_fd_sc_hd__decap_3
XFILLER_7_106 VGND VGND VPWR VPWR sky130_fd_sc_hd__decap_3
XFILLER_7_128 VGND VGND VPWR VPWR sky130_fd_sc_hd__decap_3
XFILLER_3_312 VGND VGND VPWR VPWR sky130_fd_sc_hd__decap_3
XFILLER_3_367 VGND VGND VPWR VPWR sky130_fd_sc_hd__fill_2
XFILLER_3_389 VGND VGND VPWR VPWR sky130_fd_sc_hd__decap_3
XFILLER_66_319 VGND VGND VPWR VPWR sky130_fd_sc_hd__fill_1
XFILLER_47_533 VGND VGND VPWR VPWR sky130_fd_sc_hd__decap_3
XFILLER_47_555 VGND VGND VPWR VPWR sky130_fd_sc_hd__decap_3
XFILLER_59_393 VGND VGND VPWR VPWR sky130_fd_sc_hd__fill_1
XFILLER_34_216 VGND VGND VPWR VPWR sky130_fd_sc_hd__decap_3
XFILLER_74_363 VGND VGND VPWR VPWR sky130_fd_sc_hd__fill_1
XFILLER_74_374 VGND VGND VPWR VPWR sky130_fd_sc_hd__decap_3
XTAP_TAPCELL_ROW_17_403 VGND VPWR sky130_fd_sc_hd__tapvpwrvgnd_1
Xclkbuf_3_4__f_clk clkbuf_0_clk/X VGND VGND VPWR VPWR clkbuf_leaf_8_clk/A sky130_fd_sc_hd__clkbuf_8
XFILLER_30_455 VGND VGND VPWR VPWR sky130_fd_sc_hd__decap_3
XFILLER_42_293 VGND VGND VPWR VPWR sky130_fd_sc_hd__decap_3
XFILLER_30_477 VGND VGND VPWR VPWR sky130_fd_sc_hd__decap_3
XFILLER_8_44 VGND VGND VPWR VPWR sky130_fd_sc_hd__fill_2
XFILLER_8_55 VGND VGND VPWR VPWR sky130_fd_sc_hd__decap_3
Xplace2018 place2034/X VGND VGND VPWR VPWR place2018/X sky130_fd_sc_hd__buf_2
Xplace2007 _3422_/Y VGND VGND VPWR VPWR _4473_/A sky130_fd_sc_hd__buf_2
X_3510_ _3524_/B _3826_/A VGND VGND VPWR VPWR _3510_/Y sky130_fd_sc_hd__nand2_2
XFILLER_6_150 VGND VGND VPWR VPWR sky130_fd_sc_hd__decap_3
Xplace1306 _6505_/B1 VGND VGND VPWR VPWR _6509_/B1 sky130_fd_sc_hd__buf_2
Xplace1317 _6511_/A1 VGND VGND VPWR VPWR _6468_/A2 sky130_fd_sc_hd__buf_2
Xplace2029 place2031/X VGND VGND VPWR VPWR place2029/X sky130_fd_sc_hd__buf_2
X_4490_ _4489_/X _7599_/D _4538_/S VGND VGND VPWR VPWR _4490_/X sky130_fd_sc_hd__mux2_2
XFILLER_6_183 VGND VGND VPWR VPWR sky130_fd_sc_hd__decap_3
Xplace1328 _6175_/A2 VGND VGND VPWR VPWR _6139_/A1 sky130_fd_sc_hd__buf_6
Xplace1339 _5987_/B2 VGND VGND VPWR VPWR _5984_/B1 sky130_fd_sc_hd__buf_8
X_3441_ _3441_/A1 _3441_/A2 _3545_/A _5841_/B VGND VGND VPWR VPWR _3441_/X sky130_fd_sc_hd__o211a_2
X_6160_ _6183_/A _6160_/B _6183_/C _6183_/B VGND VGND VPWR VPWR _6160_/X sky130_fd_sc_hd__or4_4
X_6091_ _6219_/A1 _6220_/A2 _6566_/A2 _7596_/Q _6090_/X VGND VGND VPWR VPWR _6091_/X
+ sky130_fd_sc_hd__o221a_4
XFILLER_97_488 VGND VGND VPWR VPWR sky130_fd_sc_hd__fill_1
X_5042_ _5042_/A0 _5376_/A1 _5059_/S VGND VGND VPWR VPWR _6988_/D sky130_fd_sc_hd__mux2_2
XFILLER_84_138 VGND VGND VPWR VPWR sky130_fd_sc_hd__fill_2
XFILLER_53_503 VGND VGND VPWR VPWR sky130_fd_sc_hd__fill_1
XFILLER_65_352 VGND VGND VPWR VPWR sky130_fd_sc_hd__decap_3
XTAP_TAPCELL_ROW_84_1106 VGND VPWR sky130_fd_sc_hd__tapvpwrvgnd_1
XFILLER_53_547 VGND VGND VPWR VPWR sky130_fd_sc_hd__fill_2
XFILLER_53_558 VGND VGND VPWR VPWR sky130_fd_sc_hd__fill_2
X_6993_ _7241_/CLK _6993_/D VGND VGND VPWR VPWR _6993_/Q sky130_fd_sc_hd__dfxtp_2
X_5944_ _6229_/A1 _6229_/A2 _6229_/B1 _7586_/Q VGND VGND VPWR VPWR _5944_/X sky130_fd_sc_hd__o22a_2
XTAP_TAPCELL_ROW_51_759 VGND VPWR sky130_fd_sc_hd__tapvpwrvgnd_1
XFILLER_21_488 VGND VGND VPWR VPWR sky130_fd_sc_hd__decap_3
X_7545_ _7610_/CLK _7545_/D place2053/X VGND VGND VPWR VPWR _7545_/Q sky130_fd_sc_hd__dfrtp_2
X_4757_ _4757_/A1 _4757_/A2 _4756_/X VGND VGND VPWR VPWR _4757_/Y sky130_fd_sc_hd__a21oi_2
XFILLER_4_109 VGND VGND VPWR VPWR sky130_fd_sc_hd__decap_3
X_7476_ _7542_/CLK _7476_/D place2047/X VGND VGND VPWR VPWR _7476_/Q sky130_fd_sc_hd__dfrtp_2
X_4688_ _4688_/A0 _5336_/A1 _4759_/S VGND VGND VPWR VPWR _6858_/D sky130_fd_sc_hd__mux2_2
XTAP_TAPCELL_ROW_95_1224 VGND VPWR sky130_fd_sc_hd__tapvpwrvgnd_1
X_6427_ _6477_/A2 _7069_/Q _7041_/Q _6476_/A1 VGND VGND VPWR VPWR _6427_/X sky130_fd_sc_hd__o22a_2
Xplace1862 _4510_/C VGND VGND VPWR VPWR _4300_/A3 sky130_fd_sc_hd__buf_2
Xplace1851 _3463_/X VGND VGND VPWR VPWR _4470_/A3 sky130_fd_sc_hd__buf_2
Xplace1840 _3952_/A1 VGND VGND VPWR VPWR _3995_/A1 sky130_fd_sc_hd__buf_4
X_6358_ _7487_/Q _6362_/A2 _6362_/A3 _6363_/B1 _6358_/B2 VGND VGND VPWR VPWR _6358_/X
+ sky130_fd_sc_hd__a32o_2
XFILLER_0_337 VGND VGND VPWR VPWR sky130_fd_sc_hd__decap_3
Xplace1895 _3463_/A VGND VGND VPWR VPWR _4340_/B sky130_fd_sc_hd__buf_2
Xplace1884 _3499_/A VGND VGND VPWR VPWR _6230_/A1 sky130_fd_sc_hd__buf_2
Xplace1873 _6720_/S VGND VGND VPWR VPWR _6769_/S sky130_fd_sc_hd__buf_2
XFILLER_0_359 VGND VGND VPWR VPWR sky130_fd_sc_hd__decap_3
Xhold2531 _6956_/Q VGND VGND VPWR VPWR _4973_/A0 sky130_fd_sc_hd__dlygate4sd3_1
Xhold2520 _6893_/Q VGND VGND VPWR VPWR _4828_/A0 sky130_fd_sc_hd__dlygate4sd3_1
XFILLER_29_500 VGND VGND VPWR VPWR sky130_fd_sc_hd__decap_3
XFILLER_29_511 VGND VGND VPWR VPWR sky130_fd_sc_hd__decap_3
Xhold2564 _7249_/Q VGND VGND VPWR VPWR _5640_/A0 sky130_fd_sc_hd__dlygate4sd3_1
Xhold2553 _7211_/Q VGND VGND VPWR VPWR _5557_/A0 sky130_fd_sc_hd__dlygate4sd3_1
Xhold2542 _6929_/Q VGND VGND VPWR VPWR _4909_/A0 sky130_fd_sc_hd__dlygate4sd3_1
XFILLER_29_544 VGND VGND VPWR VPWR sky130_fd_sc_hd__decap_3
Xhold2597 _6981_/Q VGND VGND VPWR VPWR _5026_/A0 sky130_fd_sc_hd__dlygate4sd3_1
Xhold2586 _7189_/Q VGND VGND VPWR VPWR _5509_/A0 sky130_fd_sc_hd__dlygate4sd3_1
Xhold2575 _6994_/Q VGND VGND VPWR VPWR _5055_/A0 sky130_fd_sc_hd__dlygate4sd3_1
XFILLER_29_577 VGND VGND VPWR VPWR sky130_fd_sc_hd__fill_2
XFILLER_16_227 VGND VGND VPWR VPWR sky130_fd_sc_hd__fill_1
XFILLER_17_53 VGND VGND VPWR VPWR sky130_fd_sc_hd__decap_3
XFILLER_44_536 VGND VGND VPWR VPWR sky130_fd_sc_hd__decap_3
XFILLER_16_249 VGND VGND VPWR VPWR sky130_fd_sc_hd__decap_3
XFILLER_33_85 VGND VGND VPWR VPWR sky130_fd_sc_hd__decap_3
XTAP_TAPCELL_ROW_22_450 VGND VPWR sky130_fd_sc_hd__tapvpwrvgnd_1
XFILLER_8_459 VGND VGND VPWR VPWR sky130_fd_sc_hd__decap_3
XFILLER_4_610 VGND VGND VPWR VPWR sky130_fd_sc_hd__fill_2
XFILLER_3_131 VGND VGND VPWR VPWR sky130_fd_sc_hd__decap_3
XFILLER_47_352 VGND VGND VPWR VPWR sky130_fd_sc_hd__decap_3
XFILLER_35_525 VGND VGND VPWR VPWR sky130_fd_sc_hd__decap_3
XFILLER_35_558 VGND VGND VPWR VPWR sky130_fd_sc_hd__fill_2
X_3990_ _3990_/A1 _3901_/C _6312_/B2 _4007_/A2 _7458_/Q VGND VGND VPWR VPWR _3990_/X
+ sky130_fd_sc_hd__a32o_2
XFILLER_22_219 VGND VGND VPWR VPWR sky130_fd_sc_hd__decap_3
XFILLER_50_539 VGND VGND VPWR VPWR sky130_fd_sc_hd__decap_3
X_5591_ _5591_/A0 _5591_/A1 _5593_/S VGND VGND VPWR VPWR _7227_/D sky130_fd_sc_hd__mux2_2
X_7330_ _7393_/CLK _7330_/D place2023/X VGND VGND VPWR VPWR _7330_/Q sky130_fd_sc_hd__dfrtp_2
X_4542_ _7316_/Q _4542_/B _4542_/C VGND VGND VPWR VPWR _4558_/D sky130_fd_sc_hd__and3_2
Xplace1103 _4218_/X VGND VGND VPWR VPWR _6158_/A1 sky130_fd_sc_hd__buf_2
Xplace1114 _4738_/Y VGND VGND VPWR VPWR _5718_/A1 sky130_fd_sc_hd__buf_2
Xplace1125 _4686_/X VGND VGND VPWR VPWR _5703_/A1 sky130_fd_sc_hd__buf_2
X_7261_ _7289_/CLK _7261_/D VGND VGND VPWR VPWR _7261_/Q sky130_fd_sc_hd__dfxtp_2
X_4473_ _4473_/A _4473_/B _4473_/C _4473_/D VGND VGND VPWR VPWR _4477_/C sky130_fd_sc_hd__or4_2
Xplace1136 _4233_/A VGND VGND VPWR VPWR _6163_/C sky130_fd_sc_hd__buf_2
Xplace1147 _4221_/X VGND VGND VPWR VPWR _4228_/B sky130_fd_sc_hd__buf_2
Xplace1158 _4194_/Y VGND VGND VPWR VPWR _4199_/A2 sky130_fd_sc_hd__buf_2
Xrebuffer2115 _3536_/X VGND VGND VPWR VPWR _3838_/A2 sky130_fd_sc_hd__buf_6
Xrebuffer2126 _5755_/Y VGND VGND VPWR VPWR _5980_/A1 sky130_fd_sc_hd__buf_2
Xrebuffer2137 _3951_/Y VGND VGND VPWR VPWR _4101_/A2 sky130_fd_sc_hd__buf_2
X_6212_ _6396_/A1 _7035_/Q _6951_/Q _6393_/B2 VGND VGND VPWR VPWR _6212_/X sky130_fd_sc_hd__o22a_2
X_3424_ _3437_/D _4315_/A _4337_/D _3845_/C VGND VGND VPWR VPWR _3424_/Y sky130_fd_sc_hd__a31oi_2
Xplace1169 _5211_/S VGND VGND VPWR VPWR _5179_/S sky130_fd_sc_hd__buf_2
Xrebuffer2148 _3515_/Y VGND VGND VPWR VPWR _3836_/A1 sky130_fd_sc_hd__buf_4
Xrebuffer2159 _3919_/B VGND VGND VPWR VPWR _4608_/A2 sky130_fd_sc_hd__buf_2
X_7192_ _7276_/CLK _7192_/D VGND VGND VPWR VPWR _7192_/Q sky130_fd_sc_hd__dfxtp_2
X_6143_ _6184_/B1 _6142_/X _6143_/B1 _6161_/A2 _6184_/C1 VGND VGND VPWR VPWR _6143_/X
+ sky130_fd_sc_hd__a221o_2
XTAP_TAPCELL_ROW_90_1165 VGND VPWR sky130_fd_sc_hd__tapvpwrvgnd_1
XFILLER_57_116 VGND VGND VPWR VPWR sky130_fd_sc_hd__decap_3
X_6074_ _6220_/A1 _6182_/A2 _6220_/B1 _7592_/Q _6073_/X VGND VGND VPWR VPWR _6074_/X
+ sky130_fd_sc_hd__o221a_2
XFILLER_57_138 VGND VGND VPWR VPWR sky130_fd_sc_hd__decap_3
XFILLER_57_149 VGND VGND VPWR VPWR sky130_fd_sc_hd__decap_3
XTAP_TAPCELL_ROW_56_807 VGND VPWR sky130_fd_sc_hd__tapvpwrvgnd_1
XFILLER_26_536 VGND VGND VPWR VPWR sky130_fd_sc_hd__decap_3
XFILLER_54_29 VGND VGND VPWR VPWR sky130_fd_sc_hd__decap_3
XFILLER_53_355 VGND VGND VPWR VPWR sky130_fd_sc_hd__fill_2
XFILLER_80_141 VGND VGND VPWR VPWR sky130_fd_sc_hd__fill_2
XFILLER_80_152 VGND VGND VPWR VPWR sky130_fd_sc_hd__decap_3
X_6976_ _7235_/CLK _6976_/D VGND VGND VPWR VPWR _6976_/Q sky130_fd_sc_hd__dfxtp_2
XFILLER_13_219 VGND VGND VPWR VPWR sky130_fd_sc_hd__decap_3
X_5927_ _5927_/A _5927_/B VGND VGND VPWR VPWR _5927_/Y sky130_fd_sc_hd__nand2_2
XTAP_TAPCELL_ROW_64_895 VGND VPWR sky130_fd_sc_hd__tapvpwrvgnd_1
XTAP_TAPCELL_ROW_36_597 VGND VPWR sky130_fd_sc_hd__tapvpwrvgnd_1
XFILLER_21_241 VGND VGND VPWR VPWR sky130_fd_sc_hd__decap_3
XFILLER_21_263 VGND VGND VPWR VPWR sky130_fd_sc_hd__decap_3
XPHY_EDGE_ROW_17_Right_17 VGND VGND VPWR VPWR sky130_fd_sc_hd__decap_3
X_5789_ _5789_/A _5789_/B _5789_/C _5789_/D VGND VGND VPWR VPWR _5789_/X sky130_fd_sc_hd__or4_4
X_7528_ clkload4/A _7528_/D place2065/X VGND VGND VPWR VPWR _7528_/Q sky130_fd_sc_hd__dfrtp_2
X_7459_ _7581_/CLK _7459_/D place2032/X VGND VGND VPWR VPWR _7459_/Q sky130_fd_sc_hd__dfrtp_2
Xplace1670 place1671/X VGND VGND VPWR VPWR _3901_/C sky130_fd_sc_hd__buf_8
Xplace1681 _3515_/Y VGND VGND VPWR VPWR _6363_/A2 sky130_fd_sc_hd__buf_6
Xhold3040 _7445_/Q VGND VGND VPWR VPWR _6553_/A0 sky130_fd_sc_hd__dlygate4sd3_1
Xplace1692 _3846_/X VGND VGND VPWR VPWR _4399_/A1 sky130_fd_sc_hd__buf_2
XPHY_EDGE_ROW_26_Right_26 VGND VGND VPWR VPWR sky130_fd_sc_hd__decap_3
XFILLER_29_330 VGND VGND VPWR VPWR sky130_fd_sc_hd__decap_3
XFILLER_48_127 VGND VGND VPWR VPWR sky130_fd_sc_hd__fill_2
Xhold2372 _7108_/Q VGND VGND VPWR VPWR _5331_/A0 sky130_fd_sc_hd__dlygate4sd3_1
XFILLER_17_503 VGND VGND VPWR VPWR sky130_fd_sc_hd__fill_1
Xhold2394 _7031_/Q VGND VGND VPWR VPWR _5135_/A0 sky130_fd_sc_hd__dlygate4sd3_1
Xhold2383 _7051_/Q VGND VGND VPWR VPWR _5179_/A0 sky130_fd_sc_hd__dlygate4sd3_1
XFILLER_28_85 VGND VGND VPWR VPWR sky130_fd_sc_hd__decap_3
Xplace119 _4251_/Y VGND VGND VPWR VPWR place119/X sky130_fd_sc_hd__buf_4
XFILLER_44_333 VGND VGND VPWR VPWR sky130_fd_sc_hd__decap_3
XFILLER_71_130 VGND VGND VPWR VPWR sky130_fd_sc_hd__fill_2
XFILLER_44_40 VGND VGND VPWR VPWR sky130_fd_sc_hd__decap_3
XFILLER_44_73 VGND VGND VPWR VPWR sky130_fd_sc_hd__decap_3
XFILLER_8_212 VGND VGND VPWR VPWR sky130_fd_sc_hd__decap_3
XPHY_EDGE_ROW_35_Right_35 VGND VGND VPWR VPWR sky130_fd_sc_hd__decap_3
XFILLER_40_583 VGND VGND VPWR VPWR sky130_fd_sc_hd__decap_3
XFILLER_8_256 VGND VGND VPWR VPWR sky130_fd_sc_hd__fill_1
XFILLER_8_267 VGND VGND VPWR VPWR sky130_fd_sc_hd__decap_3
XFILLER_4_462 VGND VGND VPWR VPWR sky130_fd_sc_hd__decap_3
XFILLER_99_539 VGND VGND VPWR VPWR sky130_fd_sc_hd__decap_3
XPHY_EDGE_ROW_44_Right_44 VGND VGND VPWR VPWR sky130_fd_sc_hd__decap_3
XFILLER_47_160 VGND VGND VPWR VPWR sky130_fd_sc_hd__decap_3
XFILLER_47_193 VGND VGND VPWR VPWR sky130_fd_sc_hd__decap_3
X_6830_ _6838_/A _6830_/B VGND VGND VPWR VPWR _7573_/D sky130_fd_sc_hd__and2_2
XFILLER_23_539 VGND VGND VPWR VPWR sky130_fd_sc_hd__decap_3
XFILLER_35_388 VGND VGND VPWR VPWR sky130_fd_sc_hd__decap_3
XFILLER_35_399 VGND VGND VPWR VPWR sky130_fd_sc_hd__fill_1
X_6761_ _6185_/X _6761_/A1 _6765_/S VGND VGND VPWR VPWR _7540_/D sky130_fd_sc_hd__mux2_2
XPHY_EDGE_ROW_53_Right_53 VGND VGND VPWR VPWR sky130_fd_sc_hd__decap_3
X_3973_ _3973_/A _3973_/B VGND VGND VPWR VPWR _3973_/Y sky130_fd_sc_hd__nor2_2
XFILLER_31_572 VGND VGND VPWR VPWR sky130_fd_sc_hd__decap_3
X_6692_ _6692_/A0 _6548_/Y _6698_/S VGND VGND VPWR VPWR _7507_/D sky130_fd_sc_hd__mux2_2
XTAP_TAPCELL_ROW_61_865 VGND VPWR sky130_fd_sc_hd__tapvpwrvgnd_1
XTAP_TAPCELL_ROW_33_567 VGND VPWR sky130_fd_sc_hd__tapvpwrvgnd_1
X_5574_ _5574_/A0 _5635_/A1 _5574_/S VGND VGND VPWR VPWR _7219_/D sky130_fd_sc_hd__mux2_2
XTAP_TAPCELL_ROW_79_1049 VGND VPWR sky130_fd_sc_hd__tapvpwrvgnd_1
X_7313_ _7606_/CLK _7313_/D place2050/X VGND VGND VPWR VPWR _7313_/Q sky130_fd_sc_hd__dfrtp_2
X_4525_ _4532_/A _4532_/B _4532_/D VGND VGND VPWR VPWR _4531_/B sky130_fd_sc_hd__and3_2
XPHY_EDGE_ROW_62_Right_62 VGND VGND VPWR VPWR sky130_fd_sc_hd__decap_3
X_7244_ _7272_/CLK _7244_/D VGND VGND VPWR VPWR _7244_/Q sky130_fd_sc_hd__dfxtp_2
X_4456_ _7303_/Q _4482_/B _4472_/C _4444_/X VGND VGND VPWR VPWR _4456_/Y sky130_fd_sc_hd__o211ai_2
X_7175_ _7288_/CLK _7175_/D VGND VGND VPWR VPWR _7175_/Q sky130_fd_sc_hd__dfxtp_2
X_4387_ _4387_/A _4387_/B VGND VGND VPWR VPWR _4387_/X sky130_fd_sc_hd__or2_2
X_6126_ _6122_/X _6125_/X _6547_/A1 VGND VGND VPWR VPWR _6126_/X sky130_fd_sc_hd__a21o_2
XFILLER_100_522 VGND VGND VPWR VPWR sky130_fd_sc_hd__fill_1
XFILLER_85_233 VGND VGND VPWR VPWR sky130_fd_sc_hd__fill_2
XTAP_TAPCELL_ROW_69_943 VGND VPWR sky130_fd_sc_hd__tapvpwrvgnd_1
XFILLER_73_406 VGND VGND VPWR VPWR sky130_fd_sc_hd__fill_1
X_6057_ _6057_/A1 _5841_/X _6515_/A1 _6056_/Y _5843_/X VGND VGND VPWR VPWR _6057_/X
+ sky130_fd_sc_hd__a221o_2
XFILLER_38_171 VGND VGND VPWR VPWR sky130_fd_sc_hd__fill_2
XFILLER_45_119 VGND VGND VPWR VPWR sky130_fd_sc_hd__decap_3
XFILLER_53_141 VGND VGND VPWR VPWR sky130_fd_sc_hd__decap_3
XFILLER_41_303 VGND VGND VPWR VPWR sky130_fd_sc_hd__decap_3
XPHY_EDGE_ROW_71_Right_71 VGND VGND VPWR VPWR sky130_fd_sc_hd__decap_3
X_6959_ _7272_/CLK _6959_/D VGND VGND VPWR VPWR _6959_/Q sky130_fd_sc_hd__dfxtp_2
XFILLER_41_369 VGND VGND VPWR VPWR sky130_fd_sc_hd__decap_3
XFILLER_14_65 VGND VGND VPWR VPWR sky130_fd_sc_hd__decap_3
XFILLER_22_572 VGND VGND VPWR VPWR sky130_fd_sc_hd__decap_3
XPHY_EDGE_ROW_80_Right_80 VGND VGND VPWR VPWR sky130_fd_sc_hd__decap_3
XFILLER_39_51 VGND VGND VPWR VPWR sky130_fd_sc_hd__decap_3
XFILLER_49_403 VGND VGND VPWR VPWR sky130_fd_sc_hd__fill_1
XFILLER_103_393 VGND VGND VPWR VPWR sky130_fd_sc_hd__decap_3
XTAP_TAPCELL_ROW_4_270 VGND VPWR sky130_fd_sc_hd__tapvpwrvgnd_1
XFILLER_29_193 VGND VGND VPWR VPWR sky130_fd_sc_hd__decap_3
XFILLER_72_461 VGND VGND VPWR VPWR sky130_fd_sc_hd__decap_3
XFILLER_13_561 VGND VGND VPWR VPWR sky130_fd_sc_hd__decap_3
XTAP_TAPCELL_ROW_30_537 VGND VPWR sky130_fd_sc_hd__tapvpwrvgnd_1
X_5290_ _5290_/A0 _5600_/A1 _5299_/S VGND VGND VPWR VPWR _7091_/D sky130_fd_sc_hd__mux2_2
XFILLER_4_270 VGND VGND VPWR VPWR sky130_fd_sc_hd__decap_3
X_4241_ _4215_/Y _4219_/Y _4236_/X VGND VGND VPWR VPWR _4241_/Y sky130_fd_sc_hd__a21oi_4
X_4172_ _3887_/D _4176_/A1 _4176_/A2 _4250_/C1 VGND VGND VPWR VPWR _4174_/A sky130_fd_sc_hd__a31oi_2
XFILLER_28_609 VGND VGND VPWR VPWR sky130_fd_sc_hd__decap_3
XTAP_TAPCELL_ROW_66_913 VGND VPWR sky130_fd_sc_hd__tapvpwrvgnd_1
XTAP_TAPCELL_ROW_38_626 VGND VPWR sky130_fd_sc_hd__tapvpwrvgnd_1
XFILLER_35_152 VGND VGND VPWR VPWR sky130_fd_sc_hd__decap_3
XFILLER_35_196 VGND VGND VPWR VPWR sky130_fd_sc_hd__decap_3
XFILLER_11_509 VGND VGND VPWR VPWR sky130_fd_sc_hd__fill_2
XFILLER_23_369 VGND VGND VPWR VPWR sky130_fd_sc_hd__decap_3
X_6744_ _6091_/X _6744_/A1 _6773_/S VGND VGND VPWR VPWR _7532_/D sky130_fd_sc_hd__mux2_2
X_3956_ _3955_/Y _3999_/B1 _4395_/A1 VGND VGND VPWR VPWR _3956_/Y sky130_fd_sc_hd__a21oi_2
XFILLER_31_380 VGND VGND VPWR VPWR sky130_fd_sc_hd__decap_3
X_6675_ _6675_/A0 _6086_/X _6675_/S VGND VGND VPWR VPWR _7499_/D sky130_fd_sc_hd__mux2_2
X_3887_ _4185_/A _3887_/B _3887_/C _3887_/D VGND VGND VPWR VPWR _3918_/A sky130_fd_sc_hd__nand4b_2
X_5557_ _5557_/A0 _5679_/A1 _5574_/S VGND VGND VPWR VPWR _7211_/D sky130_fd_sc_hd__mux2_2
XFILLER_2_229 VGND VGND VPWR VPWR sky130_fd_sc_hd__decap_3
X_5488_ _5671_/A _5488_/B _5549_/C VGND VGND VPWR VPWR _5547_/S sky130_fd_sc_hd__and3_2
X_4508_ _4508_/A _4508_/B _7601_/D VGND VGND VPWR VPWR _4508_/X sky130_fd_sc_hd__or3b_2
XFILLER_78_509 VGND VGND VPWR VPWR sky130_fd_sc_hd__decap_3
X_7227_ _7235_/CLK _7227_/D VGND VGND VPWR VPWR _7227_/Q sky130_fd_sc_hd__dfxtp_2
X_4439_ _4436_/Y _4460_/A _4439_/C _4439_/D VGND VGND VPWR VPWR _4450_/A sky130_fd_sc_hd__and4bb_2
XFILLER_76_16 VGND VGND VPWR VPWR sky130_fd_sc_hd__decap_3
XFILLER_86_531 VGND VGND VPWR VPWR sky130_fd_sc_hd__fill_1
X_7158_ _7243_/CLK _7158_/D VGND VGND VPWR VPWR _7158_/Q sky130_fd_sc_hd__dfxtp_2
X_7089_ _7276_/CLK _7089_/D VGND VGND VPWR VPWR _7089_/Q sky130_fd_sc_hd__dfxtp_2
X_6109_ _6139_/A1 _6998_/Q _6970_/Q _6397_/B2 VGND VGND VPWR VPWR _6109_/X sky130_fd_sc_hd__o22a_2
XFILLER_58_299 VGND VGND VPWR VPWR sky130_fd_sc_hd__decap_3
XFILLER_73_225 VGND VGND VPWR VPWR sky130_fd_sc_hd__decap_3
XFILLER_26_141 VGND VGND VPWR VPWR sky130_fd_sc_hd__decap_3
XFILLER_25_42 VGND VGND VPWR VPWR sky130_fd_sc_hd__decap_3
XFILLER_26_185 VGND VGND VPWR VPWR sky130_fd_sc_hd__decap_3
XFILLER_41_122 VGND VGND VPWR VPWR sky130_fd_sc_hd__decap_3
XFILLER_25_75 VGND VGND VPWR VPWR sky130_fd_sc_hd__decap_3
XFILLER_41_188 VGND VGND VPWR VPWR sky130_fd_sc_hd__decap_3
XFILLER_10_531 VGND VGND VPWR VPWR sky130_fd_sc_hd__fill_1
XFILLER_10_542 VGND VGND VPWR VPWR sky130_fd_sc_hd__decap_3
XFILLER_6_524 VGND VGND VPWR VPWR sky130_fd_sc_hd__decap_3
XFILLER_6_579 VGND VGND VPWR VPWR sky130_fd_sc_hd__fill_2
XFILLER_2_24 VGND VGND VPWR VPWR sky130_fd_sc_hd__decap_3
XFILLER_49_200 VGND VGND VPWR VPWR sky130_fd_sc_hd__decap_3
XFILLER_92_501 VGND VGND VPWR VPWR sky130_fd_sc_hd__fill_1
XFILLER_49_277 VGND VGND VPWR VPWR sky130_fd_sc_hd__decap_3
XFILLER_64_236 VGND VGND VPWR VPWR sky130_fd_sc_hd__decap_3
XFILLER_45_472 VGND VGND VPWR VPWR sky130_fd_sc_hd__fill_2
XFILLER_92_589 VGND VGND VPWR VPWR sky130_fd_sc_hd__decap_3
XFILLER_17_174 VGND VGND VPWR VPWR sky130_fd_sc_hd__decap_3
XFILLER_72_291 VGND VGND VPWR VPWR sky130_fd_sc_hd__fill_2
X_3810_ _7502_/Q _3810_/A2 _3810_/B1 _7438_/Q VGND VGND VPWR VPWR _3813_/A sky130_fd_sc_hd__a22oi_2
XTAP_TAPCELL_ROW_71_971 VGND VPWR sky130_fd_sc_hd__tapvpwrvgnd_1
XANTENNA_18 _7058_/Q VGND VGND VPWR VPWR sky130_fd_sc_hd__diode_2
XANTENNA_29 _4709_/A0 VGND VGND VPWR VPWR sky130_fd_sc_hd__diode_2
XFILLER_20_339 VGND VGND VPWR VPWR sky130_fd_sc_hd__fill_1
X_3741_ _3741_/A _3741_/B _4283_/C _3741_/D VGND VGND VPWR VPWR _3742_/B sky130_fd_sc_hd__nand4_4
XTAP_TAPCELL_ROW_43_673 VGND VPWR sky130_fd_sc_hd__tapvpwrvgnd_1
XFILLER_9_373 VGND VGND VPWR VPWR sky130_fd_sc_hd__fill_1
X_6460_ _6511_/B2 _7051_/Q _6855_/Q _6507_/B2 VGND VGND VPWR VPWR _6460_/X sky130_fd_sc_hd__o22a_2
X_6391_ _7092_/Q _6401_/A1 _6399_/A1 _7120_/Q _6390_/X VGND VGND VPWR VPWR _6392_/B
+ sky130_fd_sc_hd__o221a_2
XTAP_TAPCELL_ROW_76_1019 VGND VPWR sky130_fd_sc_hd__tapvpwrvgnd_1
X_5342_ _5342_/A0 _5342_/A1 _5357_/S VGND VGND VPWR VPWR _7113_/D sky130_fd_sc_hd__mux2_2
XFILLER_99_166 VGND VGND VPWR VPWR sky130_fd_sc_hd__fill_2
Xhold2905 _7331_/Q VGND VGND VPWR VPWR _6247_/B sky130_fd_sc_hd__dlygate4sd3_1
X_7012_ _7264_/CLK _7012_/D VGND VGND VPWR VPWR _7012_/Q sky130_fd_sc_hd__dfxtp_2
XFILLER_68_531 VGND VGND VPWR VPWR sky130_fd_sc_hd__fill_1
Xhold2916 _7493_/Q VGND VGND VPWR VPWR _6662_/A0 sky130_fd_sc_hd__dlygate4sd3_1
Xhold2927 _6343_/X VGND VGND VPWR VPWR _7384_/D sky130_fd_sc_hd__dlygate4sd3_1
Xhold2938 _6370_/X VGND VGND VPWR VPWR _7400_/D sky130_fd_sc_hd__dlygate4sd3_1
X_4224_ _7311_/Q _3698_/B _4561_/B1 VGND VGND VPWR VPWR _4224_/Y sky130_fd_sc_hd__a21oi_2
XFILLER_101_149 VGND VGND VPWR VPWR sky130_fd_sc_hd__fill_1
Xhold2949 _6320_/X VGND VGND VPWR VPWR _7367_/D sky130_fd_sc_hd__dlygate4sd3_1
X_4155_ _4163_/A3 _4155_/B _4155_/C VGND VGND VPWR VPWR _4155_/X sky130_fd_sc_hd__and3b_2
X_4086_ _4086_/A _4088_/B VGND VGND VPWR VPWR _7609_/D sky130_fd_sc_hd__nor2_2
XTAP_TAPCELL_ROW_87_1137 VGND VPWR sky130_fd_sc_hd__tapvpwrvgnd_1
XFILLER_24_601 VGND VGND VPWR VPWR sky130_fd_sc_hd__decap_3
XFILLER_36_450 VGND VGND VPWR VPWR sky130_fd_sc_hd__decap_3
XFILLER_83_578 VGND VGND VPWR VPWR sky130_fd_sc_hd__decap_3
XFILLER_36_483 VGND VGND VPWR VPWR sky130_fd_sc_hd__fill_1
XFILLER_36_494 VGND VGND VPWR VPWR sky130_fd_sc_hd__decap_3
XFILLER_23_199 VGND VGND VPWR VPWR sky130_fd_sc_hd__fill_2
X_4988_ _4988_/A0 _5688_/A1 _4994_/S VGND VGND VPWR VPWR _6963_/D sky130_fd_sc_hd__mux2_2
X_6727_ _6017_/X _6727_/A1 _6775_/S VGND VGND VPWR VPWR _7524_/D sky130_fd_sc_hd__mux2_2
X_3939_ _4448_/A _3844_/A _4448_/C _3939_/B1 VGND VGND VPWR VPWR _3939_/X sky130_fd_sc_hd__a31o_2
X_6658_ _6658_/A0 _6496_/X _6658_/S VGND VGND VPWR VPWR _7491_/D sky130_fd_sc_hd__mux2_2
XTAP_TAPCELL_ROW_98_1255 VGND VPWR sky130_fd_sc_hd__tapvpwrvgnd_1
XFILLER_11_66 VGND VGND VPWR VPWR sky130_fd_sc_hd__fill_2
XFILLER_3_505 VGND VGND VPWR VPWR sky130_fd_sc_hd__decap_3
XFILLER_87_37 VGND VGND VPWR VPWR sky130_fd_sc_hd__decap_3
XFILLER_19_406 VGND VGND VPWR VPWR sky130_fd_sc_hd__fill_1
XFILLER_19_428 VGND VGND VPWR VPWR sky130_fd_sc_hd__fill_1
XFILLER_46_214 VGND VGND VPWR VPWR sky130_fd_sc_hd__decap_3
XFILLER_74_589 VGND VGND VPWR VPWR sky130_fd_sc_hd__decap_3
XFILLER_36_74 VGND VGND VPWR VPWR sky130_fd_sc_hd__decap_3
XFILLER_61_228 VGND VGND VPWR VPWR sky130_fd_sc_hd__decap_3
XFILLER_42_475 VGND VGND VPWR VPWR sky130_fd_sc_hd__fill_1
XFILLER_52_62 VGND VGND VPWR VPWR sky130_fd_sc_hd__fill_1
XTAP_TAPCELL_ROW_40_643 VGND VPWR sky130_fd_sc_hd__tapvpwrvgnd_1
XTAP_TAPCELL_ROW_12_345 VGND VPWR sky130_fd_sc_hd__tapvpwrvgnd_1
XFILLER_10_350 VGND VGND VPWR VPWR sky130_fd_sc_hd__fill_2
XFILLER_10_361 VGND VGND VPWR VPWR sky130_fd_sc_hd__decap_3
XFILLER_6_321 VGND VGND VPWR VPWR sky130_fd_sc_hd__decap_3
XFILLER_6_354 VGND VGND VPWR VPWR sky130_fd_sc_hd__decap_3
XFILLER_6_398 VGND VGND VPWR VPWR sky130_fd_sc_hd__decap_3
XFILLER_37_225 VGND VGND VPWR VPWR sky130_fd_sc_hd__decap_3
XFILLER_65_534 VGND VGND VPWR VPWR sky130_fd_sc_hd__fill_1
XTAP_TAPCELL_ROW_48_732 VGND VPWR sky130_fd_sc_hd__tapvpwrvgnd_1
XFILLER_37_269 VGND VGND VPWR VPWR sky130_fd_sc_hd__decap_3
XFILLER_65_578 VGND VGND VPWR VPWR sky130_fd_sc_hd__fill_2
X_5960_ _6988_/Q _5980_/A1 _7016_/Q _5960_/B2 VGND VGND VPWR VPWR _5960_/X sky130_fd_sc_hd__o22a_2
X_5891_ _6398_/B1 _5882_/X _5885_/X _5813_/A _5890_/X VGND VGND VPWR VPWR _5891_/X
+ sky130_fd_sc_hd__o221a_2
X_4911_ _4911_/A0 _5099_/A1 _4930_/S VGND VGND VPWR VPWR _6930_/D sky130_fd_sc_hd__mux2_2
XFILLER_21_604 VGND VGND VPWR VPWR sky130_fd_sc_hd__fill_1
XFILLER_33_464 VGND VGND VPWR VPWR sky130_fd_sc_hd__decap_3
X_4842_ _4842_/A _4842_/B _4842_/C VGND VGND VPWR VPWR _5549_/B sky130_fd_sc_hd__and3_2
XTAP_TAPCELL_ROW_82_1089 VGND VPWR sky130_fd_sc_hd__tapvpwrvgnd_1
X_7561_ clkload9/A _7561_/D place2033/X VGND VGND VPWR VPWR _7561_/Q sky130_fd_sc_hd__dfrtp_2
X_4773_ _4774_/A2 _4734_/X _4773_/B1 _4773_/B2 _6226_/B1 VGND VGND VPWR VPWR _4773_/X
+ sky130_fd_sc_hd__o221a_2
XFILLER_20_169 VGND VGND VPWR VPWR sky130_fd_sc_hd__decap_3
X_7492_ clkload5/A _7492_/D place2064/X VGND VGND VPWR VPWR _7492_/Q sky130_fd_sc_hd__dfrtp_2
X_6512_ _6510_/X _6511_/X _4904_/A _6512_/C1 VGND VGND VPWR VPWR _6512_/X sky130_fd_sc_hd__a211o_2
X_3724_ _7481_/Q _3769_/B1 _3723_/X VGND VGND VPWR VPWR _4287_/A sky130_fd_sc_hd__a21oi_2
X_3655_ _7511_/Q _3725_/A2 _3757_/B1 _7447_/Q VGND VGND VPWR VPWR _3660_/B sky130_fd_sc_hd__a22oi_2
X_6374_ _6091_/X _7404_/Q _6407_/S VGND VGND VPWR VPWR _7404_/D sky130_fd_sc_hd__mux2_2
Xoutput2076 _4187_/X VGND VGND VPWR VPWR result[15] sky130_fd_sc_hd__clkbuf_2
Xoutput2087 place119/X VGND VGND VPWR VPWR result[25] sky130_fd_sc_hd__clkbuf_2
X_5325_ _5325_/A0 _5570_/A1 _5361_/S VGND VGND VPWR VPWR _7105_/D sky130_fd_sc_hd__mux2_2
Xhold2702 _6876_/Q VGND VGND VPWR VPWR _4791_/A0 sky130_fd_sc_hd__dlygate4sd3_1
Xhold2713 _7003_/Q VGND VGND VPWR VPWR _5074_/A0 sky130_fd_sc_hd__dlygate4sd3_1
Xoutput2098 _4135_/X VGND VGND VPWR VPWR result[6] sky130_fd_sc_hd__clkdlybuf4s25_1
XTAP_TAPCELL_ROW_93_1196 VGND VPWR sky130_fd_sc_hd__tapvpwrvgnd_1
Xhold2724 _7140_/Q VGND VGND VPWR VPWR _5402_/A0 sky130_fd_sc_hd__dlygate4sd3_1
Xhold2735 _7135_/Q VGND VGND VPWR VPWR _5391_/A0 sky130_fd_sc_hd__dlygate4sd3_1
Xhold2746 _7287_/Q VGND VGND VPWR VPWR _5722_/A0 sky130_fd_sc_hd__dlygate4sd3_1
X_4207_ _4201_/A _4204_/C _4206_/B VGND VGND VPWR VPWR _4207_/Y sky130_fd_sc_hd__a21boi_2
XFILLER_28_203 VGND VGND VPWR VPWR sky130_fd_sc_hd__decap_3
XFILLER_28_214 VGND VGND VPWR VPWR sky130_fd_sc_hd__decap_3
XFILLER_56_501 VGND VGND VPWR VPWR sky130_fd_sc_hd__fill_2
Xhold2757 _7146_/Q VGND VGND VPWR VPWR _5415_/A0 sky130_fd_sc_hd__dlygate4sd3_1
Xhold2768 _6852_/Q VGND VGND VPWR VPWR _4646_/A0 sky130_fd_sc_hd__dlygate4sd3_1
Xhold2779 _7239_/Q VGND VGND VPWR VPWR _5618_/A0 sky130_fd_sc_hd__dlygate4sd3_1
X_4138_ _4138_/A1 _4138_/A2 _4137_/X VGND VGND VPWR VPWR _4138_/Y sky130_fd_sc_hd__a21boi_2
XFILLER_73_28 VGND VGND VPWR VPWR sky130_fd_sc_hd__fill_1
X_4069_ _4067_/A _7312_/Q _4532_/A _4499_/C _4532_/B VGND VGND VPWR VPWR _4071_/A
+ sky130_fd_sc_hd__a41o_2
XFILLER_43_228 VGND VGND VPWR VPWR sky130_fd_sc_hd__decap_3
XFILLER_36_291 VGND VGND VPWR VPWR sky130_fd_sc_hd__decap_3
XFILLER_11_147 VGND VGND VPWR VPWR sky130_fd_sc_hd__fill_1
XFILLER_11_169 VGND VGND VPWR VPWR sky130_fd_sc_hd__decap_3
XTAP_TAPCELL_ROW_102_1292 VGND VPWR sky130_fd_sc_hd__tapvpwrvgnd_1
XFILLER_3_324 VGND VGND VPWR VPWR sky130_fd_sc_hd__decap_3
XFILLER_3_335 VGND VGND VPWR VPWR sky130_fd_sc_hd__fill_1
XFILLER_0_3 VGND VGND VPWR VPWR sky130_fd_sc_hd__fill_2
XFILLER_19_214 VGND VGND VPWR VPWR sky130_fd_sc_hd__decap_3
XFILLER_47_501 VGND VGND VPWR VPWR sky130_fd_sc_hd__decap_3
XFILLER_59_372 VGND VGND VPWR VPWR sky130_fd_sc_hd__decap_3
XFILLER_19_258 VGND VGND VPWR VPWR sky130_fd_sc_hd__decap_3
XTAP_TAPCELL_ROW_17_404 VGND VPWR sky130_fd_sc_hd__tapvpwrvgnd_1
XFILLER_62_559 VGND VGND VPWR VPWR sky130_fd_sc_hd__fill_1
XFILLER_30_434 VGND VGND VPWR VPWR sky130_fd_sc_hd__decap_3
XTAP_TAPCELL_ROW_25_481 VGND VPWR sky130_fd_sc_hd__tapvpwrvgnd_1
XFILLER_30_467 VGND VGND VPWR VPWR sky130_fd_sc_hd__decap_3
Xplace2019 place2025/X VGND VGND VPWR VPWR place2019/X sky130_fd_sc_hd__buf_2
Xplace2008 _3481_/A VGND VGND VPWR VPWR _3508_/C sky130_fd_sc_hd__buf_2
Xplace1307 _4778_/A VGND VGND VPWR VPWR _6505_/B1 sky130_fd_sc_hd__buf_2
Xplace1318 _6502_/A2 VGND VGND VPWR VPWR _6511_/A1 sky130_fd_sc_hd__buf_2
Xplace1329 _5999_/A1 VGND VGND VPWR VPWR _6175_/A2 sky130_fd_sc_hd__buf_8
X_3440_ _3460_/A _3459_/A _3440_/B1 _3440_/B2 _3519_/A VGND VGND VPWR VPWR _3440_/X
+ sky130_fd_sc_hd__o221a_4
XFILLER_97_401 VGND VGND VPWR VPWR sky130_fd_sc_hd__fill_1
XFILLER_33_3 VGND VGND VPWR VPWR sky130_fd_sc_hd__decap_3
X_6090_ _4196_/X _6161_/A2 _6088_/X _6184_/B1 _6184_/C1 VGND VGND VPWR VPWR _6090_/X
+ sky130_fd_sc_hd__a221o_2
X_5110_ _5110_/A0 _5688_/A1 _5118_/S VGND VGND VPWR VPWR _7019_/D sky130_fd_sc_hd__mux2_2
XFILLER_38_545 VGND VGND VPWR VPWR sky130_fd_sc_hd__decap_3
XFILLER_38_589 VGND VGND VPWR VPWR sky130_fd_sc_hd__fill_1
XFILLER_65_364 VGND VGND VPWR VPWR sky130_fd_sc_hd__decap_3
XTAP_TAPCELL_ROW_84_1107 VGND VPWR sky130_fd_sc_hd__tapvpwrvgnd_1
XFILLER_25_217 VGND VGND VPWR VPWR sky130_fd_sc_hd__decap_3
XFILLER_25_228 VGND VGND VPWR VPWR sky130_fd_sc_hd__decap_3
XFILLER_53_526 VGND VGND VPWR VPWR sky130_fd_sc_hd__decap_3
X_6992_ _7275_/CLK _6992_/D VGND VGND VPWR VPWR _6992_/Q sky130_fd_sc_hd__dfxtp_2
XFILLER_18_280 VGND VGND VPWR VPWR sky130_fd_sc_hd__decap_3
X_5943_ _5841_/B _6804_/A1 _6565_/B _7585_/Q _5942_/Y VGND VGND VPWR VPWR _5943_/X
+ sky130_fd_sc_hd__o221a_4
XFILLER_33_261 VGND VGND VPWR VPWR sky130_fd_sc_hd__decap_3
XFILLER_40_209 VGND VGND VPWR VPWR sky130_fd_sc_hd__fill_2
X_4825_ _4825_/A0 _5715_/A1 _4840_/S VGND VGND VPWR VPWR _6892_/D sky130_fd_sc_hd__mux2_2
X_7544_ _7608_/CLK _7544_/D place2049/X VGND VGND VPWR VPWR _7544_/Q sky130_fd_sc_hd__dfrtp_2
X_4756_ _4757_/A2 _4734_/X _4755_/Y _4773_/B2 _6547_/A1 VGND VGND VPWR VPWR _4756_/X
+ sky130_fd_sc_hd__o221a_2
X_7475_ _7514_/CLK _7475_/D place2037/X VGND VGND VPWR VPWR _7475_/Q sky130_fd_sc_hd__dfrtp_2
X_3707_ _3704_/X _3707_/B _3707_/C VGND VGND VPWR VPWR _3707_/Y sky130_fd_sc_hd__nand3b_2
XTAP_TAPCELL_ROW_95_1225 VGND VPWR sky130_fd_sc_hd__tapvpwrvgnd_1
Xplace1830 _3519_/D VGND VGND VPWR VPWR _3652_/C sky130_fd_sc_hd__buf_2
X_6426_ _6473_/A1 _7097_/Q _6845_/Q _6476_/B2 VGND VGND VPWR VPWR _6426_/X sky130_fd_sc_hd__o22a_2
X_3638_ _7412_/Q _6704_/S _3637_/X VGND VGND VPWR VPWR _4253_/C sky130_fd_sc_hd__a21oi_2
Xplace1863 _3802_/C VGND VGND VPWR VPWR _4510_/C sky130_fd_sc_hd__buf_2
Xplace1852 _3460_/Y VGND VGND VPWR VPWR _3513_/B1 sky130_fd_sc_hd__buf_2
Xplace1841 place1841/A VGND VGND VPWR VPWR _3952_/A1 sky130_fd_sc_hd__buf_4
X_6357_ _6357_/A1 _6362_/A2 _6362_/A3 _6363_/B1 _7390_/Q VGND VGND VPWR VPWR _6357_/X
+ sky130_fd_sc_hd__a32o_2
XFILLER_0_305 VGND VGND VPWR VPWR sky130_fd_sc_hd__decap_3
XFILLER_0_327 VGND VGND VPWR VPWR sky130_fd_sc_hd__decap_3
XFILLER_102_200 VGND VGND VPWR VPWR sky130_fd_sc_hd__decap_3
Xplace1896 _3445_/B VGND VGND VPWR VPWR _4025_/B1 sky130_fd_sc_hd__buf_2
Xplace1885 _3411_/Y VGND VGND VPWR VPWR _3441_/A1 sky130_fd_sc_hd__buf_2
Xplace1874 _3524_/Y VGND VGND VPWR VPWR _4023_/B sky130_fd_sc_hd__buf_2
X_5308_ _5308_/A0 _4755_/A _5331_/S VGND VGND VPWR VPWR _7097_/D sky130_fd_sc_hd__mux2_2
XFILLER_102_233 VGND VGND VPWR VPWR sky130_fd_sc_hd__fill_2
Xhold2521 _7163_/Q VGND VGND VPWR VPWR _5452_/A0 sky130_fd_sc_hd__dlygate4sd3_1
Xhold2510 _6990_/Q VGND VGND VPWR VPWR _5047_/A0 sky130_fd_sc_hd__dlygate4sd3_1
X_6288_ _6294_/A _6288_/B VGND VGND VPWR VPWR _7350_/D sky130_fd_sc_hd__and2_2
XFILLER_48_309 VGND VGND VPWR VPWR sky130_fd_sc_hd__fill_1
Xhold2565 _7245_/Q VGND VGND VPWR VPWR _5631_/A0 sky130_fd_sc_hd__dlygate4sd3_1
Xhold2554 _7149_/Q VGND VGND VPWR VPWR _5421_/A0 sky130_fd_sc_hd__dlygate4sd3_1
Xhold2543 _6883_/Q VGND VGND VPWR VPWR _4806_/A0 sky130_fd_sc_hd__dlygate4sd3_1
Xhold2532 _7121_/Q VGND VGND VPWR VPWR _5359_/A0 sky130_fd_sc_hd__dlygate4sd3_1
XTAP_TAPCELL_ROW_59_838 VGND VPWR sky130_fd_sc_hd__tapvpwrvgnd_1
XFILLER_75_139 VGND VGND VPWR VPWR sky130_fd_sc_hd__decap_3
Xhold2598 _7291_/Q VGND VGND VPWR VPWR _5730_/A0 sky130_fd_sc_hd__dlygate4sd3_1
Xhold2587 _7123_/Q VGND VGND VPWR VPWR _5363_/A0 sky130_fd_sc_hd__dlygate4sd3_1
Xhold2576 _6954_/Q VGND VGND VPWR VPWR _4962_/A0 sky130_fd_sc_hd__dlygate4sd3_1
XFILLER_16_206 VGND VGND VPWR VPWR sky130_fd_sc_hd__decap_3
XFILLER_44_548 VGND VGND VPWR VPWR sky130_fd_sc_hd__decap_3
XFILLER_56_397 VGND VGND VPWR VPWR sky130_fd_sc_hd__decap_3
XFILLER_17_76 VGND VGND VPWR VPWR sky130_fd_sc_hd__decap_3
XFILLER_31_209 VGND VGND VPWR VPWR sky130_fd_sc_hd__decap_3
XFILLER_52_581 VGND VGND VPWR VPWR sky130_fd_sc_hd__fill_2
XFILLER_24_283 VGND VGND VPWR VPWR sky130_fd_sc_hd__decap_3
XTAP_TAPCELL_ROW_22_451 VGND VPWR sky130_fd_sc_hd__tapvpwrvgnd_1
XFILLER_79_445 VGND VGND VPWR VPWR sky130_fd_sc_hd__decap_3
XFILLER_58_83 VGND VGND VPWR VPWR sky130_fd_sc_hd__fill_1
XFILLER_59_191 VGND VGND VPWR VPWR sky130_fd_sc_hd__decap_3
XFILLER_47_364 VGND VGND VPWR VPWR sky130_fd_sc_hd__decap_3
XFILLER_62_334 VGND VGND VPWR VPWR sky130_fd_sc_hd__decap_3
XFILLER_30_220 VGND VGND VPWR VPWR sky130_fd_sc_hd__decap_3
XFILLER_30_253 VGND VGND VPWR VPWR sky130_fd_sc_hd__decap_3
X_4610_ _4637_/A _6064_/A1 _4637_/B _4675_/C _4675_/A VGND VGND VPWR VPWR _4610_/X
+ sky130_fd_sc_hd__a32o_2
XFILLER_30_286 VGND VGND VPWR VPWR sky130_fd_sc_hd__fill_1
X_4541_ _7316_/Q _4542_/C _4542_/B VGND VGND VPWR VPWR _4541_/Y sky130_fd_sc_hd__a21oi_2
XFILLER_7_471 VGND VGND VPWR VPWR sky130_fd_sc_hd__fill_1
XFILLER_7_493 VGND VGND VPWR VPWR sky130_fd_sc_hd__fill_1
Xplace1104 _6012_/X VGND VGND VPWR VPWR _6515_/A1 sky130_fd_sc_hd__buf_6
Xplace1115 _5593_/A1 VGND VGND VPWR VPWR _5532_/A1 sky130_fd_sc_hd__buf_2
X_7260_ _7280_/CLK _7260_/D VGND VGND VPWR VPWR _7260_/Q sky130_fd_sc_hd__dfxtp_2
X_4472_ _4472_/A _4472_/B _4472_/C _4472_/D VGND VGND VPWR VPWR _4481_/B sky130_fd_sc_hd__and4_2
Xplace1126 _4686_/X VGND VGND VPWR VPWR _5336_/A1 sky130_fd_sc_hd__buf_2
Xplace1137 _4166_/Y VGND VGND VPWR VPWR _6057_/A1 sky130_fd_sc_hd__buf_2
Xplace1148 _4216_/X VGND VGND VPWR VPWR _4217_/B sky130_fd_sc_hd__buf_2
Xplace1159 _4185_/C VGND VGND VPWR VPWR _4186_/A2 sky130_fd_sc_hd__buf_2
Xrebuffer2116 _3536_/X VGND VGND VPWR VPWR _3553_/B2 sky130_fd_sc_hd__buf_6
Xrebuffer2127 _6089_/X VGND VGND VPWR VPWR _6547_/B1 sky130_fd_sc_hd__buf_4
Xrebuffer2138 place1609/X VGND VGND VPWR VPWR _3832_/A sky130_fd_sc_hd__buf_2
X_7191_ _7247_/CLK _7191_/D VGND VGND VPWR VPWR _7191_/Q sky130_fd_sc_hd__dfxtp_2
X_6211_ _6209_/X _6210_/X _6211_/B1 _6457_/C1 VGND VGND VPWR VPWR _6211_/X sky130_fd_sc_hd__a211o_2
X_3423_ _4473_/B _4473_/A VGND VGND VPWR VPWR _3845_/C sky130_fd_sc_hd__nor2_2
Xrebuffer2149 place1725/A VGND VGND VPWR VPWR _3614_/A2 sky130_fd_sc_hd__buf_2
X_6142_ _6183_/A _6142_/B _6183_/C _6183_/B VGND VGND VPWR VPWR _6142_/X sky130_fd_sc_hd__or4_4
XTAP_TAPCELL_ROW_90_1166 VGND VPWR sky130_fd_sc_hd__tapvpwrvgnd_1
X_6073_ _6073_/A1 _5841_/X _5843_/X _6072_/X VGND VGND VPWR VPWR _6073_/X sky130_fd_sc_hd__a211o_2
XFILLER_85_459 VGND VGND VPWR VPWR sky130_fd_sc_hd__decap_3
X_5024_ _5024_/A0 _4757_/Y _5024_/S VGND VGND VPWR VPWR _6980_/D sky130_fd_sc_hd__mux2_2
XFILLER_26_504 VGND VGND VPWR VPWR sky130_fd_sc_hd__fill_1
XTAP_TAPCELL_ROW_56_808 VGND VPWR sky130_fd_sc_hd__tapvpwrvgnd_1
XFILLER_65_172 VGND VGND VPWR VPWR sky130_fd_sc_hd__fill_2
X_6975_ _7565_/CLK _6975_/D VGND VGND VPWR VPWR _6975_/Q sky130_fd_sc_hd__dfxtp_2
X_5926_ _6484_/B2 _6902_/Q _7238_/Q _6476_/B2 VGND VGND VPWR VPWR _5927_/B sky130_fd_sc_hd__o22a_2
XTAP_TAPCELL_ROW_64_896 VGND VPWR sky130_fd_sc_hd__tapvpwrvgnd_1
XFILLER_21_220 VGND VGND VPWR VPWR sky130_fd_sc_hd__decap_3
XTAP_TAPCELL_ROW_36_598 VGND VPWR sky130_fd_sc_hd__tapvpwrvgnd_1
XFILLER_70_29 VGND VGND VPWR VPWR sky130_fd_sc_hd__fill_1
X_5857_ _7582_/Q _6565_/B _5856_/X VGND VGND VPWR VPWR _5857_/X sky130_fd_sc_hd__o21a_2
XFILLER_21_275 VGND VGND VPWR VPWR sky130_fd_sc_hd__decap_3
X_5788_ _5813_/A _5788_/B VGND VGND VPWR VPWR _5789_/D sky130_fd_sc_hd__nor2_2
X_4808_ _4808_/A0 _5698_/A1 _4808_/S VGND VGND VPWR VPWR _6884_/D sky130_fd_sc_hd__mux2_2
X_7527_ clkload4/A _7527_/D place2065/X VGND VGND VPWR VPWR _7527_/Q sky130_fd_sc_hd__dfrtp_2
XFILLER_79_16 VGND VGND VPWR VPWR sky130_fd_sc_hd__decap_3
X_7458_ _7490_/CLK _7458_/D place2024/X VGND VGND VPWR VPWR _7458_/Q sky130_fd_sc_hd__dfrtp_2
X_6409_ _6702_/A0 _6410_/A2 _6410_/A3 _6410_/B1 _7416_/Q VGND VGND VPWR VPWR _6409_/X
+ sky130_fd_sc_hd__a32o_2
XFILLER_1_603 VGND VGND VPWR VPWR sky130_fd_sc_hd__fill_1
Xplace1671 _3533_/Y VGND VGND VPWR VPWR place1671/X sky130_fd_sc_hd__buf_6
X_7389_ clkload7/A _7389_/D place2027/X VGND VGND VPWR VPWR _7389_/Q sky130_fd_sc_hd__dfrtp_2
XFILLER_0_135 VGND VGND VPWR VPWR sky130_fd_sc_hd__decap_3
XFILLER_49_607 VGND VGND VPWR VPWR sky130_fd_sc_hd__fill_1
Xhold3030 _7541_/Q VGND VGND VPWR VPWR _4535_/A1 sky130_fd_sc_hd__dlygate4sd3_1
Xhold3041 _7321_/Q VGND VGND VPWR VPWR _4091_/A sky130_fd_sc_hd__dlygate4sd3_1
Xplace1682 _6376_/A2 VGND VGND VPWR VPWR _6412_/A2 sky130_fd_sc_hd__buf_2
Xplace1693 _3829_/D VGND VGND VPWR VPWR place1693/X sky130_fd_sc_hd__buf_2
XFILLER_103_586 VGND VGND VPWR VPWR sky130_fd_sc_hd__fill_2
XFILLER_48_106 VGND VGND VPWR VPWR sky130_fd_sc_hd__decap_3
XFILLER_88_253 VGND VGND VPWR VPWR sky130_fd_sc_hd__decap_3
XFILLER_29_320 VGND VGND VPWR VPWR sky130_fd_sc_hd__decap_3
XFILLER_48_139 VGND VGND VPWR VPWR sky130_fd_sc_hd__fill_1
Xhold2373 _7067_/Q VGND VGND VPWR VPWR _5213_/A0 sky130_fd_sc_hd__dlygate4sd3_1
XFILLER_28_53 VGND VGND VPWR VPWR sky130_fd_sc_hd__decap_3
Xhold2395 _7006_/Q VGND VGND VPWR VPWR _5081_/A0 sky130_fd_sc_hd__dlygate4sd3_1
Xhold2384 _6877_/Q VGND VGND VPWR VPWR _4794_/A0 sky130_fd_sc_hd__dlygate4sd3_1
XFILLER_17_526 VGND VGND VPWR VPWR sky130_fd_sc_hd__decap_3
XFILLER_44_312 VGND VGND VPWR VPWR sky130_fd_sc_hd__decap_3
XFILLER_56_150 VGND VGND VPWR VPWR sky130_fd_sc_hd__decap_3
XFILLER_56_183 VGND VGND VPWR VPWR sky130_fd_sc_hd__decap_3
XTAP_TAPCELL_ROW_27_510 VGND VPWR sky130_fd_sc_hd__tapvpwrvgnd_1
XFILLER_17_559 VGND VGND VPWR VPWR sky130_fd_sc_hd__fill_1
XFILLER_25_570 VGND VGND VPWR VPWR sky130_fd_sc_hd__decap_3
XFILLER_32_518 VGND VGND VPWR VPWR sky130_fd_sc_hd__fill_2
XFILLER_44_85 VGND VGND VPWR VPWR sky130_fd_sc_hd__decap_3
XFILLER_12_242 VGND VGND VPWR VPWR sky130_fd_sc_hd__decap_3
XFILLER_12_253 VGND VGND VPWR VPWR sky130_fd_sc_hd__decap_3
XFILLER_4_474 VGND VGND VPWR VPWR sky130_fd_sc_hd__fill_2
XFILLER_5_57 VGND VGND VPWR VPWR sky130_fd_sc_hd__decap_3
XFILLER_35_312 VGND VGND VPWR VPWR sky130_fd_sc_hd__decap_3
XFILLER_47_172 VGND VGND VPWR VPWR sky130_fd_sc_hd__decap_3
XFILLER_63_610 VGND VGND VPWR VPWR sky130_fd_sc_hd__fill_2
XFILLER_35_345 VGND VGND VPWR VPWR sky130_fd_sc_hd__decap_3
XFILLER_62_164 VGND VGND VPWR VPWR sky130_fd_sc_hd__decap_3
X_5711_ _5711_/A0 _5711_/A1 _5711_/S VGND VGND VPWR VPWR _7282_/D sky130_fd_sc_hd__mux2_2
X_3972_ _3972_/A _3972_/B VGND VGND VPWR VPWR _3972_/Y sky130_fd_sc_hd__nor2_2
XTAP_TAPCELL_ROW_61_866 VGND VPWR sky130_fd_sc_hd__tapvpwrvgnd_1
XTAP_TAPCELL_ROW_33_568 VGND VPWR sky130_fd_sc_hd__tapvpwrvgnd_1
X_5642_ _5642_/A0 _4686_/X _5654_/S VGND VGND VPWR VPWR _7250_/D sky130_fd_sc_hd__mux2_2
X_7312_ _7606_/CLK _7312_/D place2052/X VGND VGND VPWR VPWR _7312_/Q sky130_fd_sc_hd__dfrtp_2
X_7243_ _7243_/CLK _7243_/D VGND VGND VPWR VPWR _7243_/Q sky130_fd_sc_hd__dfxtp_2
X_4455_ _4472_/A _4444_/X _4472_/C VGND VGND VPWR VPWR _4457_/B sky130_fd_sc_hd__a21oi_2
X_7174_ _7288_/CLK _7174_/D VGND VGND VPWR VPWR _7174_/Q sky130_fd_sc_hd__dfxtp_2
X_4386_ _4416_/B _4411_/C _4385_/A VGND VGND VPWR VPWR _4387_/B sky130_fd_sc_hd__a21oi_2
X_3406_ _3961_/A VGND VGND VPWR VPWR _3458_/A sky130_fd_sc_hd__inv_2
XFILLER_85_201 VGND VGND VPWR VPWR sky130_fd_sc_hd__fill_2
X_6125_ _6123_/X _6124_/X _6153_/B1 _6156_/C1 VGND VGND VPWR VPWR _6125_/X sky130_fd_sc_hd__a211o_2
XTAP_TAPCELL_ROW_69_944 VGND VPWR sky130_fd_sc_hd__tapvpwrvgnd_1
XFILLER_100_578 VGND VGND VPWR VPWR sky130_fd_sc_hd__fill_1
X_6056_ _6055_/X _4905_/A _6489_/A4 VGND VGND VPWR VPWR _6056_/Y sky130_fd_sc_hd__a21oi_2
XFILLER_26_312 VGND VGND VPWR VPWR sky130_fd_sc_hd__decap_3
XFILLER_45_109 VGND VGND VPWR VPWR sky130_fd_sc_hd__decap_3
X_5007_ _5007_/A0 _5190_/A1 _5024_/S VGND VGND VPWR VPWR _6972_/D sky130_fd_sc_hd__mux2_2
XFILLER_26_345 VGND VGND VPWR VPWR sky130_fd_sc_hd__decap_3
XFILLER_14_529 VGND VGND VPWR VPWR sky130_fd_sc_hd__decap_3
X_6958_ _7275_/CLK _6958_/D VGND VGND VPWR VPWR _6958_/Q sky130_fd_sc_hd__dfxtp_2
XFILLER_22_551 VGND VGND VPWR VPWR sky130_fd_sc_hd__fill_1
X_6889_ _7407_/CLK _6889_/D VGND VGND VPWR VPWR _6889_/Q sky130_fd_sc_hd__dfxtp_2
XFILLER_14_77 VGND VGND VPWR VPWR sky130_fd_sc_hd__decap_3
XFILLER_22_584 VGND VGND VPWR VPWR sky130_fd_sc_hd__decap_3
XFILLER_14_99 VGND VGND VPWR VPWR sky130_fd_sc_hd__decap_3
XFILLER_100_3 VGND VGND VPWR VPWR sky130_fd_sc_hd__decap_3
XFILLER_1_444 VGND VGND VPWR VPWR sky130_fd_sc_hd__decap_3
Xplace1490 _3956_/Y VGND VGND VPWR VPWR _4099_/A sky130_fd_sc_hd__buf_2
XTAP_TAPCELL_ROW_4_260 VGND VPWR sky130_fd_sc_hd__tapvpwrvgnd_1
XFILLER_29_172 VGND VGND VPWR VPWR sky130_fd_sc_hd__fill_1
XFILLER_36_109 VGND VGND VPWR VPWR sky130_fd_sc_hd__fill_1
XFILLER_55_51 VGND VGND VPWR VPWR sky130_fd_sc_hd__decap_3
XFILLER_55_73 VGND VGND VPWR VPWR sky130_fd_sc_hd__decap_3
XFILLER_32_326 VGND VGND VPWR VPWR sky130_fd_sc_hd__decap_3
XFILLER_32_348 VGND VGND VPWR VPWR sky130_fd_sc_hd__decap_3
XFILLER_9_511 VGND VGND VPWR VPWR sky130_fd_sc_hd__decap_3
XTAP_TAPCELL_ROW_30_538 VGND VPWR sky130_fd_sc_hd__tapvpwrvgnd_1
XFILLER_9_588 VGND VGND VPWR VPWR sky130_fd_sc_hd__fill_2
XFILLER_4_260 VGND VGND VPWR VPWR sky130_fd_sc_hd__decap_3
X_4240_ _4240_/A1 _4216_/X _4242_/A1 VGND VGND VPWR VPWR _4240_/Y sky130_fd_sc_hd__o21bai_2
XFILLER_36_610 VGND VGND VPWR VPWR sky130_fd_sc_hd__fill_2
XTAP_TAPCELL_ROW_66_914 VGND VPWR sky130_fd_sc_hd__tapvpwrvgnd_1
XTAP_TAPCELL_ROW_38_627 VGND VPWR sky130_fd_sc_hd__tapvpwrvgnd_1
XFILLER_23_315 VGND VGND VPWR VPWR sky130_fd_sc_hd__decap_3
XFILLER_35_175 VGND VGND VPWR VPWR sky130_fd_sc_hd__decap_3
XFILLER_50_145 VGND VGND VPWR VPWR sky130_fd_sc_hd__decap_3
X_3955_ _3955_/A _3955_/B VGND VGND VPWR VPWR _3955_/Y sky130_fd_sc_hd__nand2_2
X_5625_ _5625_/A0 _5686_/A1 _5635_/S VGND VGND VPWR VPWR _7242_/D sky130_fd_sc_hd__mux2_2
X_3886_ _3886_/A _3886_/B VGND VGND VPWR VPWR _4192_/B sky130_fd_sc_hd__nand2_2
X_4507_ _4506_/A _4506_/C _4506_/B VGND VGND VPWR VPWR _4507_/Y sky130_fd_sc_hd__a21oi_2
X_7226_ _7407_/CLK _7226_/D VGND VGND VPWR VPWR _7226_/Q sky130_fd_sc_hd__dfxtp_2
X_4438_ _4436_/Y _4439_/C _4439_/D VGND VGND VPWR VPWR _4460_/C sky130_fd_sc_hd__nand3b_2
XFILLER_58_212 VGND VGND VPWR VPWR sky130_fd_sc_hd__decap_3
X_7157_ _7276_/CLK _7157_/D VGND VGND VPWR VPWR _7157_/Q sky130_fd_sc_hd__dfxtp_2
X_4369_ _4361_/A _4341_/X _4352_/A _4337_/X VGND VGND VPWR VPWR _4369_/X sky130_fd_sc_hd__a31o_2
XFILLER_58_256 VGND VGND VPWR VPWR sky130_fd_sc_hd__decap_3
X_7088_ _7235_/CLK _7088_/D VGND VGND VPWR VPWR _7088_/Q sky130_fd_sc_hd__dfxtp_2
XFILLER_18_109 VGND VGND VPWR VPWR sky130_fd_sc_hd__decap_3
X_6039_ _4163_/X _5841_/X _5843_/X _6038_/X VGND VGND VPWR VPWR _6039_/X sky130_fd_sc_hd__a211o_2
XFILLER_39_481 VGND VGND VPWR VPWR sky130_fd_sc_hd__decap_3
XTAP_TAPCELL_ROW_1_230 VGND VPWR sky130_fd_sc_hd__tapvpwrvgnd_1
XFILLER_14_304 VGND VGND VPWR VPWR sky130_fd_sc_hd__decap_3
XFILLER_81_281 VGND VGND VPWR VPWR sky130_fd_sc_hd__fill_1
XFILLER_25_87 VGND VGND VPWR VPWR sky130_fd_sc_hd__decap_3
XFILLER_41_156 VGND VGND VPWR VPWR sky130_fd_sc_hd__decap_3
XFILLER_41_53 VGND VGND VPWR VPWR sky130_fd_sc_hd__decap_3
XFILLER_1_274 VGND VGND VPWR VPWR sky130_fd_sc_hd__decap_3
XFILLER_18_610 VGND VGND VPWR VPWR sky130_fd_sc_hd__fill_2
XFILLER_17_186 VGND VGND VPWR VPWR sky130_fd_sc_hd__decap_3
XFILLER_45_484 VGND VGND VPWR VPWR sky130_fd_sc_hd__fill_2
XANTENNA_19 _7064_/Q VGND VGND VPWR VPWR sky130_fd_sc_hd__diode_2
XFILLER_20_307 VGND VGND VPWR VPWR sky130_fd_sc_hd__fill_1
XFILLER_20_318 VGND VGND VPWR VPWR sky130_fd_sc_hd__decap_3
X_3740_ _4294_/A2 _3738_/B _4297_/B _4297_/D _3739_/Y VGND VGND VPWR VPWR _3741_/B
+ sky130_fd_sc_hd__o41a_4
XTAP_TAPCELL_ROW_71_972 VGND VPWR sky130_fd_sc_hd__tapvpwrvgnd_1
XTAP_TAPCELL_ROW_43_674 VGND VPWR sky130_fd_sc_hd__tapvpwrvgnd_1
XTAP_TAPCELL_ROW_15_376 VGND VPWR sky130_fd_sc_hd__tapvpwrvgnd_1
XFILLER_9_396 VGND VGND VPWR VPWR sky130_fd_sc_hd__fill_1
X_6390_ _6390_/A1 _7064_/Q _6868_/Q _6390_/B2 VGND VGND VPWR VPWR _6390_/X sky130_fd_sc_hd__o22a_2
X_5410_ _5410_/A0 _5532_/A1 _5410_/S VGND VGND VPWR VPWR _7144_/D sky130_fd_sc_hd__mux2_2
X_7011_ _7565_/CLK _7011_/D VGND VGND VPWR VPWR _7011_/Q sky130_fd_sc_hd__dfxtp_2
Xhold2906 _7480_/Q VGND VGND VPWR VPWR _6634_/A0 sky130_fd_sc_hd__dlygate4sd3_1
Xhold2917 _7514_/Q VGND VGND VPWR VPWR _6706_/A0 sky130_fd_sc_hd__dlygate4sd3_1
Xhold2928 _7472_/Q VGND VGND VPWR VPWR _6617_/A0 sky130_fd_sc_hd__dlygate4sd3_1
Xhold2939 _7502_/Q VGND VGND VPWR VPWR _6681_/A0 sky130_fd_sc_hd__dlygate4sd3_1
X_4223_ _4223_/A1 _4220_/A _6163_/A _4228_/B _4222_/Y VGND VGND VPWR VPWR _4223_/X
+ sky130_fd_sc_hd__o2111a_2
X_4154_ _4154_/A _4154_/B VGND VGND VPWR VPWR _4154_/Y sky130_fd_sc_hd__nand2_2
XFILLER_28_418 VGND VGND VPWR VPWR sky130_fd_sc_hd__fill_2
XFILLER_55_204 VGND VGND VPWR VPWR sky130_fd_sc_hd__decap_3
X_4085_ _4542_/B _7318_/Q _4558_/B _4085_/D VGND VGND VPWR VPWR _4088_/B sky130_fd_sc_hd__and4_2
XFILLER_83_557 VGND VGND VPWR VPWR sky130_fd_sc_hd__decap_3
XTAP_TAPCELL_ROW_87_1138 VGND VPWR sky130_fd_sc_hd__tapvpwrvgnd_1
XFILLER_51_410 VGND VGND VPWR VPWR sky130_fd_sc_hd__decap_3
XFILLER_63_281 VGND VGND VPWR VPWR sky130_fd_sc_hd__fill_2
X_3938_ _7395_/Q _4150_/A2 _3936_/X _3937_/X VGND VGND VPWR VPWR _3938_/X sky130_fd_sc_hd__a211o_2
X_3869_ _6524_/A0 _3923_/A2 _3923_/B1 _7337_/Q _3868_/X VGND VGND VPWR VPWR _3869_/X
+ sky130_fd_sc_hd__a221o_2
X_6588_ _6588_/A0 _6489_/X _6590_/S VGND VGND VPWR VPWR _7458_/D sky130_fd_sc_hd__mux2_2
X_5608_ _5608_/A0 _5608_/A1 _5608_/S VGND VGND VPWR VPWR _7235_/D sky130_fd_sc_hd__mux2_2
XTAP_TAPCELL_ROW_98_1256 VGND VPWR sky130_fd_sc_hd__tapvpwrvgnd_1
XFILLER_11_34 VGND VGND VPWR VPWR sky130_fd_sc_hd__fill_1
X_5539_ _5539_/A0 _5600_/A1 _5545_/S VGND VGND VPWR VPWR _7203_/D sky130_fd_sc_hd__mux2_2
X_7209_ _7393_/CLK _7209_/D VGND VGND VPWR VPWR _7209_/Q sky130_fd_sc_hd__dfxtp_2
XFILLER_100_150 VGND VGND VPWR VPWR sky130_fd_sc_hd__fill_2
XFILLER_46_259 VGND VGND VPWR VPWR sky130_fd_sc_hd__decap_3
XFILLER_27_473 VGND VGND VPWR VPWR sky130_fd_sc_hd__decap_3
XFILLER_54_270 VGND VGND VPWR VPWR sky130_fd_sc_hd__fill_1
XFILLER_14_145 VGND VGND VPWR VPWR sky130_fd_sc_hd__decap_3
XFILLER_14_178 VGND VGND VPWR VPWR sky130_fd_sc_hd__decap_3
XFILLER_42_487 VGND VGND VPWR VPWR sky130_fd_sc_hd__decap_3
XFILLER_52_85 VGND VGND VPWR VPWR sky130_fd_sc_hd__fill_1
XTAP_TAPCELL_ROW_40_644 VGND VPWR sky130_fd_sc_hd__tapvpwrvgnd_1
XTAP_TAPCELL_ROW_12_346 VGND VPWR sky130_fd_sc_hd__tapvpwrvgnd_1
XFILLER_69_307 VGND VGND VPWR VPWR sky130_fd_sc_hd__decap_3
XFILLER_28_6 VGND VGND VPWR VPWR sky130_fd_sc_hd__decap_3
XFILLER_37_237 VGND VGND VPWR VPWR sky130_fd_sc_hd__decap_3
XTAP_TAPCELL_ROW_48_722 VGND VPWR sky130_fd_sc_hd__tapvpwrvgnd_1
XFILLER_45_281 VGND VGND VPWR VPWR sky130_fd_sc_hd__decap_3
X_5890_ _5887_/X _5888_/X _6211_/B1 _6457_/C1 VGND VGND VPWR VPWR _5890_/X sky130_fd_sc_hd__a211o_2
XFILLER_60_240 VGND VGND VPWR VPWR sky130_fd_sc_hd__decap_3
XFILLER_20_104 VGND VGND VPWR VPWR sky130_fd_sc_hd__decap_3
XTAP_TAPCELL_ROW_82_1079 VGND VPWR sky130_fd_sc_hd__tapvpwrvgnd_1
XFILLER_20_126 VGND VGND VPWR VPWR sky130_fd_sc_hd__decap_3
X_7560_ clkload8/A _7560_/D place2017/X VGND VGND VPWR VPWR _7560_/Q sky130_fd_sc_hd__dfrtp_2
X_7491_ _7581_/CLK _7491_/D place2025/X VGND VGND VPWR VPWR _7491_/Q sky130_fd_sc_hd__dfrtp_2
X_6511_ _6511_/A1 _6878_/Q _7270_/Q _6511_/B2 VGND VGND VPWR VPWR _6511_/X sky130_fd_sc_hd__o22a_2
X_3723_ _7417_/Q _6331_/A2 _3817_/A3 _3893_/A2 _7545_/Q VGND VGND VPWR VPWR _3723_/X
+ sky130_fd_sc_hd__a32o_2
XFILLER_9_182 VGND VGND VPWR VPWR sky130_fd_sc_hd__decap_3
X_6442_ _6442_/A0 _6441_/X _6497_/S VGND VGND VPWR VPWR _7423_/D sky130_fd_sc_hd__mux2_2
X_6373_ _6675_/A0 _6376_/A2 _6411_/A3 _6411_/B1 _6373_/B2 VGND VGND VPWR VPWR _7403_/D
+ sky130_fd_sc_hd__a32o_2
X_3585_ _3585_/A VGND VGND VPWR VPWR _3585_/Y sky130_fd_sc_hd__inv_2
Xoutput2077 _4196_/X VGND VGND VPWR VPWR result[16] sky130_fd_sc_hd__clkdlybuf4s25_1
Xoutput2088 _4259_/X VGND VGND VPWR VPWR result[26] sky130_fd_sc_hd__clkbuf_2
Xhold2703 _7018_/Q VGND VGND VPWR VPWR _5108_/A0 sky130_fd_sc_hd__dlygate4sd3_1
Xhold2714 _7099_/Q VGND VGND VPWR VPWR _5312_/A0 sky130_fd_sc_hd__dlygate4sd3_1
Xoutput2099 _6495_/A1 VGND VGND VPWR VPWR result[7] sky130_fd_sc_hd__clkdlybuf4s25_1
X_5255_ _5255_/A0 _5698_/A1 _5255_/S VGND VGND VPWR VPWR _7080_/D sky130_fd_sc_hd__mux2_2
XTAP_TAPCELL_ROW_93_1197 VGND VPWR sky130_fd_sc_hd__tapvpwrvgnd_1
XFILLER_87_148 VGND VGND VPWR VPWR sky130_fd_sc_hd__fill_2
Xhold2725 _7265_/Q VGND VGND VPWR VPWR _5675_/A0 sky130_fd_sc_hd__dlygate4sd3_1
Xhold2736 _7142_/Q VGND VGND VPWR VPWR _5406_/A0 sky130_fd_sc_hd__dlygate4sd3_1
Xhold2747 _7240_/Q VGND VGND VPWR VPWR _5620_/A0 sky130_fd_sc_hd__dlygate4sd3_1
X_4206_ _4206_/A _4206_/B VGND VGND VPWR VPWR _4206_/Y sky130_fd_sc_hd__nor2_2
XFILLER_68_362 VGND VGND VPWR VPWR sky130_fd_sc_hd__fill_2
XFILLER_68_373 VGND VGND VPWR VPWR sky130_fd_sc_hd__decap_3
Xhold2758 _7050_/Q VGND VGND VPWR VPWR _5177_/A0 sky130_fd_sc_hd__dlygate4sd3_1
Xhold2769 _6857_/Q VGND VGND VPWR VPWR _4680_/A0 sky130_fd_sc_hd__dlygate4sd3_1
X_5186_ _5186_/A0 _5336_/A1 _5207_/S VGND VGND VPWR VPWR _7054_/D sky130_fd_sc_hd__mux2_2
XFILLER_28_226 VGND VGND VPWR VPWR sky130_fd_sc_hd__decap_3
XFILLER_28_248 VGND VGND VPWR VPWR sky130_fd_sc_hd__decap_3
X_4137_ _6180_/A1 _5839_/A2 _3802_/C _4138_/A1 _4138_/A2 VGND VGND VPWR VPWR _4137_/X
+ sky130_fd_sc_hd__o32a_2
XFILLER_28_259 VGND VGND VPWR VPWR sky130_fd_sc_hd__decap_3
X_4068_ _4068_/A _4077_/D VGND VGND VPWR VPWR _7603_/D sky130_fd_sc_hd__nor2_2
XFILLER_24_410 VGND VGND VPWR VPWR sky130_fd_sc_hd__decap_3
XFILLER_24_421 VGND VGND VPWR VPWR sky130_fd_sc_hd__decap_3
XFILLER_51_240 VGND VGND VPWR VPWR sky130_fd_sc_hd__fill_1
XFILLER_24_487 VGND VGND VPWR VPWR sky130_fd_sc_hd__fill_1
XFILLER_24_498 VGND VGND VPWR VPWR sky130_fd_sc_hd__fill_2
XFILLER_7_119 VGND VGND VPWR VPWR sky130_fd_sc_hd__decap_3
X_6709_ _6228_/Y _6229_/X _6664_/S _6708_/X VGND VGND VPWR VPWR _7515_/D sky130_fd_sc_hd__a31o_2
XTAP_TAPCELL_ROW_102_1293 VGND VPWR sky130_fd_sc_hd__tapvpwrvgnd_1
XFILLER_22_66 VGND VGND VPWR VPWR sky130_fd_sc_hd__decap_3
XFILLER_22_77 VGND VGND VPWR VPWR sky130_fd_sc_hd__fill_2
XFILLER_22_88 VGND VGND VPWR VPWR sky130_fd_sc_hd__decap_3
XFILLER_19_204 VGND VGND VPWR VPWR sky130_fd_sc_hd__decap_3
XFILLER_47_546 VGND VGND VPWR VPWR sky130_fd_sc_hd__decap_3
XFILLER_59_384 VGND VGND VPWR VPWR sky130_fd_sc_hd__fill_2
XFILLER_19_248 VGND VGND VPWR VPWR sky130_fd_sc_hd__decap_3
XFILLER_34_207 VGND VGND VPWR VPWR sky130_fd_sc_hd__decap_3
XFILLER_62_549 VGND VGND VPWR VPWR sky130_fd_sc_hd__fill_2
XTAP_TAPCELL_ROW_17_405 VGND VPWR sky130_fd_sc_hd__tapvpwrvgnd_1
XFILLER_27_281 VGND VGND VPWR VPWR sky130_fd_sc_hd__decap_3
XFILLER_15_465 VGND VGND VPWR VPWR sky130_fd_sc_hd__decap_3
XFILLER_15_487 VGND VGND VPWR VPWR sky130_fd_sc_hd__fill_1
XFILLER_42_284 VGND VGND VPWR VPWR sky130_fd_sc_hd__decap_3
XTAP_TAPCELL_ROW_53_780 VGND VPWR sky130_fd_sc_hd__tapvpwrvgnd_1
XTAP_TAPCELL_ROW_25_482 VGND VPWR sky130_fd_sc_hd__tapvpwrvgnd_1
Xplace2009 _4352_/B VGND VGND VPWR VPWR _6231_/A1 sky130_fd_sc_hd__buf_2
XFILLER_6_130 VGND VGND VPWR VPWR sky130_fd_sc_hd__decap_3
XFILLER_6_141 VGND VGND VPWR VPWR sky130_fd_sc_hd__decap_3
Xplace1308 _6457_/B1 VGND VGND VPWR VPWR _6153_/B1 sky130_fd_sc_hd__buf_2
XFILLER_6_174 VGND VGND VPWR VPWR sky130_fd_sc_hd__decap_3
Xplace1319 _5980_/A1 VGND VGND VPWR VPWR _6502_/A2 sky130_fd_sc_hd__buf_2
XFILLER_85_608 VGND VGND VPWR VPWR sky130_fd_sc_hd__decap_3
XFILLER_97_446 VGND VGND VPWR VPWR sky130_fd_sc_hd__fill_2
X_5040_ _5040_/A0 _5162_/A1 _5059_/S VGND VGND VPWR VPWR _6987_/D sky130_fd_sc_hd__mux2_2
XFILLER_26_3 VGND VGND VPWR VPWR sky130_fd_sc_hd__decap_3
XFILLER_38_524 VGND VGND VPWR VPWR sky130_fd_sc_hd__decap_3
XFILLER_38_579 VGND VGND VPWR VPWR sky130_fd_sc_hd__decap_3
XFILLER_53_505 VGND VGND VPWR VPWR sky130_fd_sc_hd__fill_2
X_6991_ _7264_/CLK _6991_/D VGND VGND VPWR VPWR _6991_/Q sky130_fd_sc_hd__dfxtp_2
XFILLER_92_184 VGND VGND VPWR VPWR sky130_fd_sc_hd__decap_3
X_5942_ _6495_/A2 _5940_/X _5941_/X VGND VGND VPWR VPWR _5942_/Y sky130_fd_sc_hd__o21ai_4
XTAP_TAPCELL_ROW_84_1108 VGND VPWR sky130_fd_sc_hd__tapvpwrvgnd_1
XFILLER_18_292 VGND VGND VPWR VPWR sky130_fd_sc_hd__decap_3
XFILLER_92_195 VGND VGND VPWR VPWR sky130_fd_sc_hd__fill_1
XFILLER_33_240 VGND VGND VPWR VPWR sky130_fd_sc_hd__decap_3
XFILLER_33_284 VGND VGND VPWR VPWR sky130_fd_sc_hd__decap_3
X_7543_ _7608_/CLK _7543_/D place2053/X VGND VGND VPWR VPWR _7543_/Q sky130_fd_sc_hd__dfrtp_2
X_4755_ _4755_/A VGND VGND VPWR VPWR _4755_/Y sky130_fd_sc_hd__inv_2
X_3706_ _7384_/Q _3811_/A2 _3907_/B1 _7416_/Q VGND VGND VPWR VPWR _4279_/C sky130_fd_sc_hd__a22oi_2
X_7474_ _7542_/CLK _7474_/D place2047/X VGND VGND VPWR VPWR _7474_/Q sky130_fd_sc_hd__dfrtp_2
X_4686_ _6329_/B2 _4707_/A2 _4707_/A3 _4685_/X VGND VGND VPWR VPWR _4686_/X sky130_fd_sc_hd__a31o_2
Xplace1820 _3931_/C VGND VGND VPWR VPWR _6182_/A2 sky130_fd_sc_hd__buf_2
X_6425_ _6422_/X _6424_/X _5778_/X VGND VGND VPWR VPWR _6435_/A sky130_fd_sc_hd__a21oi_2
X_3637_ _7444_/Q _3718_/B1 _3781_/B1 _7348_/Q _3636_/X VGND VGND VPWR VPWR _3637_/X
+ sky130_fd_sc_hd__a221o_2
Xplace1853 _3460_/Y VGND VGND VPWR VPWR _4613_/B1 sky130_fd_sc_hd__buf_2
Xplace1842 _3548_/A1 VGND VGND VPWR VPWR _3853_/C sky130_fd_sc_hd__buf_2
Xplace1831 _3497_/Y VGND VGND VPWR VPWR _4428_/B sky130_fd_sc_hd__buf_2
X_6356_ _6356_/A1 _6362_/A2 _6362_/A3 _6363_/B1 _6356_/B2 VGND VGND VPWR VPWR _7389_/D
+ sky130_fd_sc_hd__a32o_2
X_3568_ _7323_/Q _3568_/B VGND VGND VPWR VPWR _3568_/Y sky130_fd_sc_hd__nand2_2
XFILLER_68_29 VGND VGND VPWR VPWR sky130_fd_sc_hd__fill_1
Xplace1897 _3445_/C VGND VGND VPWR VPWR _4014_/A2 sky130_fd_sc_hd__buf_2
Xplace1886 _3845_/A VGND VGND VPWR VPWR _4448_/A sky130_fd_sc_hd__buf_2
Xplace1875 _3543_/B VGND VGND VPWR VPWR _6302_/C sky130_fd_sc_hd__buf_2
Xplace1864 _3826_/C VGND VGND VPWR VPWR _3802_/C sky130_fd_sc_hd__buf_2
Xhold2522 _6995_/Q VGND VGND VPWR VPWR _5057_/A0 sky130_fd_sc_hd__dlygate4sd3_1
Xhold2511 _7220_/Q VGND VGND VPWR VPWR _5576_/A0 sky130_fd_sc_hd__dlygate4sd3_1
Xhold2500 _6880_/Q VGND VGND VPWR VPWR _4800_/A0 sky130_fd_sc_hd__dlygate4sd3_1
X_3499_ _3499_/A _3499_/B VGND VGND VPWR VPWR _3500_/C sky130_fd_sc_hd__nand2_2
XFILLER_102_256 VGND VGND VPWR VPWR sky130_fd_sc_hd__fill_1
Xhold2555 _7260_/Q VGND VGND VPWR VPWR _5663_/A0 sky130_fd_sc_hd__dlygate4sd3_1
Xhold2544 _6964_/Q VGND VGND VPWR VPWR _4990_/A0 sky130_fd_sc_hd__dlygate4sd3_1
Xhold2533 _6859_/Q VGND VGND VPWR VPWR _4695_/A0 sky130_fd_sc_hd__dlygate4sd3_1
XFILLER_29_535 VGND VGND VPWR VPWR sky130_fd_sc_hd__decap_3
Xhold2588 _6966_/Q VGND VGND VPWR VPWR _4994_/A0 sky130_fd_sc_hd__dlygate4sd3_1
Xhold2577 _7134_/Q VGND VGND VPWR VPWR _5389_/A0 sky130_fd_sc_hd__dlygate4sd3_1
Xhold2566 _6928_/Q VGND VGND VPWR VPWR _4907_/A0 sky130_fd_sc_hd__dlygate4sd3_1
X_5169_ _5169_/A0 _5564_/A1 _5179_/S VGND VGND VPWR VPWR _7046_/D sky130_fd_sc_hd__mux2_2
XTAP_TAPCELL_ROW_59_839 VGND VPWR sky130_fd_sc_hd__tapvpwrvgnd_1
XFILLER_56_365 VGND VGND VPWR VPWR sky130_fd_sc_hd__fill_1
XFILLER_83_140 VGND VGND VPWR VPWR sky130_fd_sc_hd__fill_1
Xhold2599 _7111_/Q VGND VGND VPWR VPWR _5338_/A0 sky130_fd_sc_hd__dlygate4sd3_1
XFILLER_16_218 VGND VGND VPWR VPWR sky130_fd_sc_hd__decap_3
XFILLER_24_262 VGND VGND VPWR VPWR sky130_fd_sc_hd__decap_3
XFILLER_24_295 VGND VGND VPWR VPWR sky130_fd_sc_hd__fill_1
XFILLER_33_76 VGND VGND VPWR VPWR sky130_fd_sc_hd__decap_3
XTAP_TAPCELL_ROW_50_750 VGND VPWR sky130_fd_sc_hd__tapvpwrvgnd_1
XTAP_TAPCELL_ROW_22_452 VGND VPWR sky130_fd_sc_hd__tapvpwrvgnd_1
XFILLER_33_98 VGND VGND VPWR VPWR sky130_fd_sc_hd__decap_3
XPHY_EDGE_ROW_49_Left_153 VGND VGND VPWR VPWR sky130_fd_sc_hd__decap_3
XFILLER_3_122 VGND VGND VPWR VPWR sky130_fd_sc_hd__decap_3
XFILLER_79_479 VGND VGND VPWR VPWR sky130_fd_sc_hd__decap_3
XPHY_EDGE_ROW_58_Left_162 VGND VGND VPWR VPWR sky130_fd_sc_hd__decap_3
XFILLER_12_9 VGND VGND VPWR VPWR sky130_fd_sc_hd__fill_1
XFILLER_47_321 VGND VGND VPWR VPWR sky130_fd_sc_hd__decap_3
XFILLER_35_505 VGND VGND VPWR VPWR sky130_fd_sc_hd__decap_3
XFILLER_47_343 VGND VGND VPWR VPWR sky130_fd_sc_hd__decap_3
XFILLER_43_571 VGND VGND VPWR VPWR sky130_fd_sc_hd__fill_1
XFILLER_62_368 VGND VGND VPWR VPWR sky130_fd_sc_hd__fill_1
XPHY_EDGE_ROW_67_Left_171 VGND VGND VPWR VPWR sky130_fd_sc_hd__decap_3
Xclkbuf_leaf_10_clk clkbuf_leaf_9_clk/A VGND VGND VPWR VPWR _7247_/CLK sky130_fd_sc_hd__clkbuf_16
Xplace1105 _4774_/Y VGND VGND VPWR VPWR _5608_/A1 sky130_fd_sc_hd__buf_2
Xplace1116 _4728_/X VGND VGND VPWR VPWR _5593_/A1 sky130_fd_sc_hd__buf_2
X_4471_ _7303_/Q _4464_/B _4427_/X _4470_/X VGND VGND VPWR VPWR _4472_/B sky130_fd_sc_hd__a22o_2
Xplace1127 _5701_/A1 VGND VGND VPWR VPWR _5334_/A1 sky130_fd_sc_hd__buf_2
Xplace1138 _5728_/A1 VGND VGND VPWR VPWR _5606_/A1 sky130_fd_sc_hd__buf_2
Xplace1149 _4202_/C VGND VGND VPWR VPWR _4200_/B sky130_fd_sc_hd__buf_2
Xrebuffer2117 _3536_/X VGND VGND VPWR VPWR _3986_/B2 sky130_fd_sc_hd__buf_8
Xrebuffer2128 _3509_/Y VGND VGND VPWR VPWR _3628_/A2 sky130_fd_sc_hd__buf_6
X_7190_ _7274_/CLK _7190_/D VGND VGND VPWR VPWR _7190_/Q sky130_fd_sc_hd__dfxtp_2
X_6210_ _6213_/A1 _6895_/Q _7287_/Q _6213_/B2 VGND VGND VPWR VPWR _6210_/X sky130_fd_sc_hd__o22a_2
X_3422_ _3437_/D VGND VGND VPWR VPWR _3422_/Y sky130_fd_sc_hd__inv_2
Xrebuffer2139 _4239_/Y VGND VGND VPWR VPWR _4242_/A1 sky130_fd_sc_hd__buf_2
X_6141_ _6141_/A _6141_/B _6141_/C VGND VGND VPWR VPWR _6142_/B sky130_fd_sc_hd__and3_4
XPHY_EDGE_ROW_76_Left_180 VGND VGND VPWR VPWR sky130_fd_sc_hd__decap_3
X_6072_ _6226_/B1 _6071_/X _6515_/A3 _6515_/A1 VGND VGND VPWR VPWR _6072_/X sky130_fd_sc_hd__o211a_2
XTAP_TAPCELL_ROW_90_1167 VGND VPWR sky130_fd_sc_hd__tapvpwrvgnd_1
XFILLER_38_321 VGND VGND VPWR VPWR sky130_fd_sc_hd__decap_3
XFILLER_57_129 VGND VGND VPWR VPWR sky130_fd_sc_hd__decap_3
XFILLER_85_449 VGND VGND VPWR VPWR sky130_fd_sc_hd__fill_1
XFILLER_65_140 VGND VGND VPWR VPWR sky130_fd_sc_hd__decap_3
XTAP_TAPCELL_ROW_56_809 VGND VPWR sky130_fd_sc_hd__tapvpwrvgnd_1
XFILLER_26_516 VGND VGND VPWR VPWR sky130_fd_sc_hd__decap_3
X_6974_ _7280_/CLK _6974_/D VGND VGND VPWR VPWR _6974_/Q sky130_fd_sc_hd__dfxtp_2
XFILLER_0_91 VGND VGND VPWR VPWR sky130_fd_sc_hd__decap_3
X_5925_ _6484_/A2 _6874_/Q _7266_/Q _6480_/B2 VGND VGND VPWR VPWR _5927_/A sky130_fd_sc_hd__o22a_2
X_5856_ _6489_/A1 _4582_/A _4582_/B _6495_/A2 _6440_/B1 VGND VGND VPWR VPWR _5856_/X
+ sky130_fd_sc_hd__a41o_2
XTAP_TAPCELL_ROW_64_897 VGND VPWR sky130_fd_sc_hd__tapvpwrvgnd_1
XTAP_TAPCELL_ROW_36_599 VGND VPWR sky130_fd_sc_hd__tapvpwrvgnd_1
XFILLER_21_232 VGND VGND VPWR VPWR sky130_fd_sc_hd__decap_3
XFILLER_21_254 VGND VGND VPWR VPWR sky130_fd_sc_hd__decap_3
XPHY_EDGE_ROW_3_Right_3 VGND VGND VPWR VPWR sky130_fd_sc_hd__decap_3
XFILLER_21_287 VGND VGND VPWR VPWR sky130_fd_sc_hd__decap_3
X_5787_ _7089_/Q _6456_/A1 _6449_/B1 _7117_/Q _5786_/X VGND VGND VPWR VPWR _5788_/B
+ sky130_fd_sc_hd__o221a_2
X_7526_ clkload4/A _7526_/D place2063/X VGND VGND VPWR VPWR _7526_/Q sky130_fd_sc_hd__dfrtp_2
X_4738_ _4757_/A1 _4738_/A2 _4737_/X VGND VGND VPWR VPWR _4738_/Y sky130_fd_sc_hd__a21oi_2
X_7457_ clkload7/A _7457_/D place2027/X VGND VGND VPWR VPWR _7457_/Q sky130_fd_sc_hd__dfrtp_2
X_4669_ _4727_/C _4629_/S _4667_/Y _4669_/B2 _4668_/X VGND VGND VPWR VPWR _4669_/X
+ sky130_fd_sc_hd__o221a_2
XFILLER_79_28 VGND VGND VPWR VPWR sky130_fd_sc_hd__fill_2
XFILLER_0_103 VGND VGND VPWR VPWR sky130_fd_sc_hd__fill_1
Xplace1650 _6331_/A2 VGND VGND VPWR VPWR _6324_/A2 sky130_fd_sc_hd__buf_2
Xplace1661 _3857_/A2 VGND VGND VPWR VPWR _3769_/B1 sky130_fd_sc_hd__buf_8
Xplace1672 _3947_/A2 VGND VGND VPWR VPWR _6362_/A3 sky130_fd_sc_hd__buf_2
X_7388_ clkload7/A _7388_/D place2027/X VGND VGND VPWR VPWR _7388_/Q sky130_fd_sc_hd__dfrtp_2
Xhold3020 _7391_/Q VGND VGND VPWR VPWR _6358_/B2 sky130_fd_sc_hd__dlygate4sd3_1
Xhold3031 _7448_/Q VGND VGND VPWR VPWR _6562_/A0 sky130_fd_sc_hd__dlygate4sd3_1
Xhold3042 _7400_/Q VGND VGND VPWR VPWR _6321_/A1 sky130_fd_sc_hd__dlygate4sd3_1
Xplace1683 _6411_/A2 VGND VGND VPWR VPWR _6410_/A2 sky130_fd_sc_hd__buf_2
Xplace1694 _3652_/X VGND VGND VPWR VPWR _5850_/C sky130_fd_sc_hd__buf_2
X_6339_ _7412_/Q _6344_/A2 _6344_/A3 _6344_/B1 _6339_/B2 VGND VGND VPWR VPWR _6339_/X
+ sky130_fd_sc_hd__a32o_2
XFILLER_0_169 VGND VGND VPWR VPWR sky130_fd_sc_hd__decap_3
XFILLER_103_598 VGND VGND VPWR VPWR sky130_fd_sc_hd__fill_1
XFILLER_28_32 VGND VGND VPWR VPWR sky130_fd_sc_hd__decap_3
XFILLER_48_118 VGND VGND VPWR VPWR sky130_fd_sc_hd__decap_3
XFILLER_29_343 VGND VGND VPWR VPWR sky130_fd_sc_hd__decap_3
Xhold2396 _6894_/Q VGND VGND VPWR VPWR _4830_/A0 sky130_fd_sc_hd__dlygate4sd3_1
Xhold2385 _7097_/Q VGND VGND VPWR VPWR _5308_/A0 sky130_fd_sc_hd__dlygate4sd3_1
Xhold2374 _6925_/Q VGND VGND VPWR VPWR _4898_/A0 sky130_fd_sc_hd__dlygate4sd3_1
XFILLER_28_76 VGND VGND VPWR VPWR sky130_fd_sc_hd__decap_3
XFILLER_56_162 VGND VGND VPWR VPWR sky130_fd_sc_hd__decap_3
XFILLER_72_611 VGND VGND VPWR VPWR sky130_fd_sc_hd__fill_1
XFILLER_44_324 VGND VGND VPWR VPWR sky130_fd_sc_hd__decap_3
XFILLER_44_346 VGND VGND VPWR VPWR sky130_fd_sc_hd__decap_3
XFILLER_56_195 VGND VGND VPWR VPWR sky130_fd_sc_hd__fill_1
XTAP_TAPCELL_ROW_27_511 VGND VPWR sky130_fd_sc_hd__tapvpwrvgnd_1
XFILLER_25_582 VGND VGND VPWR VPWR sky130_fd_sc_hd__fill_2
XFILLER_40_530 VGND VGND VPWR VPWR sky130_fd_sc_hd__fill_2
XFILLER_44_64 VGND VGND VPWR VPWR sky130_fd_sc_hd__decap_3
XFILLER_71_198 VGND VGND VPWR VPWR sky130_fd_sc_hd__fill_2
XFILLER_40_552 VGND VGND VPWR VPWR sky130_fd_sc_hd__decap_3
XFILLER_44_97 VGND VGND VPWR VPWR sky130_fd_sc_hd__decap_3
XFILLER_8_203 VGND VGND VPWR VPWR sky130_fd_sc_hd__decap_3
XFILLER_40_574 VGND VGND VPWR VPWR sky130_fd_sc_hd__decap_3
XFILLER_8_225 VGND VGND VPWR VPWR sky130_fd_sc_hd__decap_3
XFILLER_67_416 VGND VGND VPWR VPWR sky130_fd_sc_hd__fill_2
XFILLER_94_257 VGND VGND VPWR VPWR sky130_fd_sc_hd__fill_2
XFILLER_47_151 VGND VGND VPWR VPWR sky130_fd_sc_hd__decap_3
XFILLER_82_419 VGND VGND VPWR VPWR sky130_fd_sc_hd__fill_1
XFILLER_94_279 VGND VGND VPWR VPWR sky130_fd_sc_hd__decap_3
XFILLER_35_335 VGND VGND VPWR VPWR sky130_fd_sc_hd__fill_1
XFILLER_47_184 VGND VGND VPWR VPWR sky130_fd_sc_hd__decap_3
X_3971_ _4734_/A2 _3961_/X _4012_/A1 _3964_/Y VGND VGND VPWR VPWR _3972_/B sky130_fd_sc_hd__o22a_2
XFILLER_16_571 VGND VGND VPWR VPWR sky130_fd_sc_hd__fill_1
XFILLER_50_349 VGND VGND VPWR VPWR sky130_fd_sc_hd__decap_3
XFILLER_62_176 VGND VGND VPWR VPWR sky130_fd_sc_hd__fill_2
XFILLER_31_541 VGND VGND VPWR VPWR sky130_fd_sc_hd__decap_3
XFILLER_43_390 VGND VGND VPWR VPWR sky130_fd_sc_hd__fill_2
XTAP_TAPCELL_ROW_61_867 VGND VPWR sky130_fd_sc_hd__tapvpwrvgnd_1
XTAP_TAPCELL_ROW_33_569 VGND VPWR sky130_fd_sc_hd__tapvpwrvgnd_1
X_5572_ _5572_/A0 _5572_/A1 _5574_/S VGND VGND VPWR VPWR _7218_/D sky130_fd_sc_hd__mux2_2
X_7311_ _7610_/CLK _7311_/D place2055/X VGND VGND VPWR VPWR _7311_/Q sky130_fd_sc_hd__dfrtp_2
X_4523_ _4522_/X _6759_/A1 _4539_/S VGND VGND VPWR VPWR _7313_/D sky130_fd_sc_hd__mux2_2
X_7242_ _7247_/CLK _7242_/D VGND VGND VPWR VPWR _7242_/Q sky130_fd_sc_hd__dfxtp_2
X_4454_ _7304_/Q _4464_/B VGND VGND VPWR VPWR _4472_/C sky130_fd_sc_hd__xor2_2
XFILLER_98_530 VGND VGND VPWR VPWR sky130_fd_sc_hd__fill_2
X_7173_ _7217_/CLK _7173_/D VGND VGND VPWR VPWR _7173_/Q sky130_fd_sc_hd__dfxtp_2
X_4385_ _4385_/A _4416_/B _4411_/C VGND VGND VPWR VPWR _4387_/A sky130_fd_sc_hd__and3_2
X_6124_ _6146_/A2 _6999_/Q _6971_/Q _6390_/A1 VGND VGND VPWR VPWR _6124_/X sky130_fd_sc_hd__o22a_2
X_6055_ _6055_/A _6055_/B _6055_/C _6055_/D VGND VGND VPWR VPWR _6055_/X sky130_fd_sc_hd__or4_4
XTAP_TAPCELL_ROW_69_945 VGND VPWR sky130_fd_sc_hd__tapvpwrvgnd_1
XFILLER_26_302 VGND VGND VPWR VPWR sky130_fd_sc_hd__decap_3
XFILLER_54_611 VGND VGND VPWR VPWR sky130_fd_sc_hd__fill_1
XFILLER_53_110 VGND VGND VPWR VPWR sky130_fd_sc_hd__fill_2
XFILLER_26_368 VGND VGND VPWR VPWR sky130_fd_sc_hd__decap_3
XFILLER_53_165 VGND VGND VPWR VPWR sky130_fd_sc_hd__decap_3
X_6957_ _7490_/CLK _6957_/D VGND VGND VPWR VPWR _6957_/Q sky130_fd_sc_hd__dfxtp_2
X_6888_ _7280_/CLK _6888_/D VGND VGND VPWR VPWR _6888_/Q sky130_fd_sc_hd__dfxtp_2
X_5908_ _5908_/A _5908_/B _5908_/C VGND VGND VPWR VPWR _6160_/B sky130_fd_sc_hd__and3_4
XFILLER_14_56 VGND VGND VPWR VPWR sky130_fd_sc_hd__decap_3
X_5839_ _6180_/A1 _5839_/A2 _6183_/C _5839_/B1 _5839_/B2 VGND VGND VPWR VPWR _6486_/C
+ sky130_fd_sc_hd__o32a_2
X_7509_ _7509_/CLK _7509_/D place2069/X VGND VGND VPWR VPWR _7509_/Q sky130_fd_sc_hd__dfrtp_2
XFILLER_30_88 VGND VGND VPWR VPWR sky130_fd_sc_hd__decap_3
Xplace1480 _4011_/Y VGND VGND VPWR VPWR _4401_/A1 sky130_fd_sc_hd__buf_2
XFILLER_103_340 VGND VGND VPWR VPWR sky130_fd_sc_hd__fill_2
Xplace1491 _3923_/X VGND VGND VPWR VPWR _3924_/C1 sky130_fd_sc_hd__buf_2
XFILLER_103_362 VGND VGND VPWR VPWR sky130_fd_sc_hd__fill_2
XFILLER_76_224 VGND VGND VPWR VPWR sky130_fd_sc_hd__fill_2
XFILLER_39_86 VGND VGND VPWR VPWR sky130_fd_sc_hd__decap_3
XFILLER_76_246 VGND VGND VPWR VPWR sky130_fd_sc_hd__decap_3
XFILLER_29_140 VGND VGND VPWR VPWR sky130_fd_sc_hd__decap_3
XFILLER_76_279 VGND VGND VPWR VPWR sky130_fd_sc_hd__fill_1
XTAP_TAPCELL_ROW_4_261 VGND VPWR sky130_fd_sc_hd__tapvpwrvgnd_1
XFILLER_57_493 VGND VGND VPWR VPWR sky130_fd_sc_hd__fill_2
XFILLER_44_154 VGND VGND VPWR VPWR sky130_fd_sc_hd__fill_1
XFILLER_72_474 VGND VGND VPWR VPWR sky130_fd_sc_hd__fill_2
XFILLER_32_338 VGND VGND VPWR VPWR sky130_fd_sc_hd__decap_3
XFILLER_40_371 VGND VGND VPWR VPWR sky130_fd_sc_hd__decap_3
XTAP_TAPCELL_ROW_30_539 VGND VPWR sky130_fd_sc_hd__tapvpwrvgnd_1
XTAP_TAPCELL_ROW_78_1040 VGND VPWR sky130_fd_sc_hd__tapvpwrvgnd_1
XFILLER_4_250 VGND VGND VPWR VPWR sky130_fd_sc_hd__fill_2
XFILLER_58_6 VGND VGND VPWR VPWR sky130_fd_sc_hd__fill_1
X_4170_ _3916_/A _3916_/B _4157_/A _4169_/Y VGND VGND VPWR VPWR _4170_/X sky130_fd_sc_hd__o22a_2
XTAP_TAPCELL_ROW_66_915 VGND VPWR sky130_fd_sc_hd__tapvpwrvgnd_1
XTAP_TAPCELL_ROW_38_617 VGND VPWR sky130_fd_sc_hd__tapvpwrvgnd_1
X_6811_ _6840_/A _6811_/B VGND VGND VPWR VPWR _7564_/D sky130_fd_sc_hd__and2_2
XFILLER_23_327 VGND VGND VPWR VPWR sky130_fd_sc_hd__fill_1
XFILLER_35_187 VGND VGND VPWR VPWR sky130_fd_sc_hd__decap_3
XFILLER_50_113 VGND VGND VPWR VPWR sky130_fd_sc_hd__decap_3
XFILLER_50_135 VGND VGND VPWR VPWR sky130_fd_sc_hd__decap_3
XFILLER_50_157 VGND VGND VPWR VPWR sky130_fd_sc_hd__decap_3
X_6742_ _6086_/X _6742_/A1 _6775_/S VGND VGND VPWR VPWR _7531_/D sky130_fd_sc_hd__mux2_2
X_3954_ _7391_/Q _3978_/B VGND VGND VPWR VPWR _3955_/B sky130_fd_sc_hd__nand2_2
XFILLER_31_371 VGND VGND VPWR VPWR sky130_fd_sc_hd__decap_3
X_3885_ _3885_/A _3885_/B VGND VGND VPWR VPWR _3886_/B sky130_fd_sc_hd__nand2_2
X_5555_ _5555_/A0 _5677_/A1 _5574_/S VGND VGND VPWR VPWR _7210_/D sky130_fd_sc_hd__mux2_2
X_5486_ _5486_/A0 _5608_/A1 _5486_/S VGND VGND VPWR VPWR _7179_/D sky130_fd_sc_hd__mux2_2
X_4506_ _4506_/A _4506_/B _4506_/C VGND VGND VPWR VPWR _4506_/X sky130_fd_sc_hd__and3_2
X_7225_ _7407_/CLK _7225_/D VGND VGND VPWR VPWR _7225_/Q sky130_fd_sc_hd__dfxtp_2
X_4437_ _4448_/A _4437_/A2 _4437_/A3 _4437_/B1 _4437_/B2 VGND VGND VPWR VPWR _4439_/C
+ sky130_fd_sc_hd__a32o_2
X_7156_ _7490_/CLK _7156_/D VGND VGND VPWR VPWR _7156_/Q sky130_fd_sc_hd__dfxtp_2
XFILLER_58_224 VGND VGND VPWR VPWR sky130_fd_sc_hd__fill_2
XFILLER_76_29 VGND VGND VPWR VPWR sky130_fd_sc_hd__decap_3
XFILLER_98_393 VGND VGND VPWR VPWR sky130_fd_sc_hd__decap_3
X_6107_ _6154_/A1 _7026_/Q _6942_/Q _6154_/B2 VGND VGND VPWR VPWR _6107_/X sky130_fd_sc_hd__o22a_2
X_4368_ _4348_/C _7588_/D _4325_/B _4468_/C1 VGND VGND VPWR VPWR _4368_/X sky130_fd_sc_hd__o31a_2
X_7087_ _7575_/CLK _7087_/D VGND VGND VPWR VPWR _7087_/Q sky130_fd_sc_hd__dfxtp_2
X_4299_ _4296_/Y _4298_/Y _4295_/B1 VGND VGND VPWR VPWR _4299_/Y sky130_fd_sc_hd__o21bai_2
XFILLER_100_354 VGND VGND VPWR VPWR sky130_fd_sc_hd__fill_1
XFILLER_100_365 VGND VGND VPWR VPWR sky130_fd_sc_hd__decap_3
XFILLER_27_611 VGND VGND VPWR VPWR sky130_fd_sc_hd__fill_1
XFILLER_58_279 VGND VGND VPWR VPWR sky130_fd_sc_hd__decap_3
X_6038_ _6226_/B1 _6037_/X _6515_/A3 _6515_/A1 VGND VGND VPWR VPWR _6038_/X sky130_fd_sc_hd__o211a_2
XFILLER_73_249 VGND VGND VPWR VPWR sky130_fd_sc_hd__decap_3
XTAP_TAPCELL_ROW_1_231 VGND VPWR sky130_fd_sc_hd__tapvpwrvgnd_1
XFILLER_25_33 VGND VGND VPWR VPWR sky130_fd_sc_hd__decap_3
XFILLER_26_165 VGND VGND VPWR VPWR sky130_fd_sc_hd__decap_3
XFILLER_41_113 VGND VGND VPWR VPWR sky130_fd_sc_hd__fill_2
XFILLER_41_179 VGND VGND VPWR VPWR sky130_fd_sc_hd__fill_2
XFILLER_22_382 VGND VGND VPWR VPWR sky130_fd_sc_hd__decap_3
XTAP_TAPCELL_ROW_9_320 VGND VPWR sky130_fd_sc_hd__tapvpwrvgnd_1
XFILLER_1_220 VGND VGND VPWR VPWR sky130_fd_sc_hd__decap_3
XFILLER_77_555 VGND VGND VPWR VPWR sky130_fd_sc_hd__decap_3
XFILLER_37_408 VGND VGND VPWR VPWR sky130_fd_sc_hd__decap_3
XFILLER_77_577 VGND VGND VPWR VPWR sky130_fd_sc_hd__decap_3
XFILLER_64_249 VGND VGND VPWR VPWR sky130_fd_sc_hd__decap_3
XFILLER_45_463 VGND VGND VPWR VPWR sky130_fd_sc_hd__decap_3
XFILLER_17_165 VGND VGND VPWR VPWR sky130_fd_sc_hd__decap_3
XFILLER_32_102 VGND VGND VPWR VPWR sky130_fd_sc_hd__fill_2
XFILLER_72_271 VGND VGND VPWR VPWR sky130_fd_sc_hd__decap_3
XFILLER_82_50 VGND VGND VPWR VPWR sky130_fd_sc_hd__fill_1
XFILLER_17_198 VGND VGND VPWR VPWR sky130_fd_sc_hd__fill_1
XFILLER_32_168 VGND VGND VPWR VPWR sky130_fd_sc_hd__decap_3
XTAP_TAPCELL_ROW_71_973 VGND VPWR sky130_fd_sc_hd__tapvpwrvgnd_1
XTAP_TAPCELL_ROW_43_675 VGND VPWR sky130_fd_sc_hd__tapvpwrvgnd_1
XTAP_TAPCELL_ROW_15_377 VGND VPWR sky130_fd_sc_hd__tapvpwrvgnd_1
X_3670_ _3670_/A _3670_/B _3670_/C _3670_/D VGND VGND VPWR VPWR _4245_/A sky130_fd_sc_hd__or4_2
XFILLER_56_3 VGND VGND VPWR VPWR sky130_fd_sc_hd__decap_3
X_5340_ _5340_/A0 _5707_/A1 _5357_/S VGND VGND VPWR VPWR _7112_/D sky130_fd_sc_hd__mux2_2
X_5271_ _5271_/A0 _5342_/A1 _5293_/S VGND VGND VPWR VPWR _7085_/D sky130_fd_sc_hd__mux2_2
XFILLER_102_608 VGND VGND VPWR VPWR sky130_fd_sc_hd__decap_3
X_7010_ _7290_/CLK _7010_/D VGND VGND VPWR VPWR _7010_/Q sky130_fd_sc_hd__dfxtp_2
X_4222_ _4220_/B _4217_/B _4220_/A _4223_/A1 VGND VGND VPWR VPWR _4222_/Y sky130_fd_sc_hd__o211ai_2
XFILLER_101_129 VGND VGND VPWR VPWR sky130_fd_sc_hd__decap_3
Xhold2907 _7511_/Q VGND VGND VPWR VPWR _6700_/A0 sky130_fd_sc_hd__dlygate4sd3_1
Xhold2918 _6411_/X VGND VGND VPWR VPWR _7418_/D sky130_fd_sc_hd__dlygate4sd3_1
Xhold2929 _7468_/Q VGND VGND VPWR VPWR _6609_/A0 sky130_fd_sc_hd__dlygate4sd3_1
XFILLER_95_330 VGND VGND VPWR VPWR sky130_fd_sc_hd__decap_3
X_4153_ _4153_/A1 _4149_/B _4152_/X _6088_/A _4510_/C VGND VGND VPWR VPWR _4155_/B
+ sky130_fd_sc_hd__o32a_2
XFILLER_83_503 VGND VGND VPWR VPWR sky130_fd_sc_hd__fill_1
X_4084_ _4558_/B _4084_/B VGND VGND VPWR VPWR _4086_/A sky130_fd_sc_hd__nor2_2
XTAP_TAPCELL_ROW_87_1139 VGND VPWR sky130_fd_sc_hd__tapvpwrvgnd_1
XFILLER_102_27 VGND VGND VPWR VPWR sky130_fd_sc_hd__fill_1
XFILLER_23_113 VGND VGND VPWR VPWR sky130_fd_sc_hd__fill_1
XFILLER_51_400 VGND VGND VPWR VPWR sky130_fd_sc_hd__fill_1
XFILLER_51_444 VGND VGND VPWR VPWR sky130_fd_sc_hd__decap_3
X_4986_ _4986_/A0 _5686_/A1 _4994_/S VGND VGND VPWR VPWR _6962_/D sky130_fd_sc_hd__mux2_2
XFILLER_23_179 VGND VGND VPWR VPWR sky130_fd_sc_hd__decap_3
X_6725_ _5945_/X _7523_/Q _6769_/S VGND VGND VPWR VPWR _7523_/D sky130_fd_sc_hd__mux2_2
X_3937_ _7427_/Q _4576_/B1 _3996_/B1 _7331_/Q VGND VGND VPWR VPWR _3937_/X sky130_fd_sc_hd__a22o_2
XPHY_EDGE_ROW_12_Left_116 VGND VGND VPWR VPWR sky130_fd_sc_hd__decap_3
X_3868_ _3842_/C _3842_/B _7369_/Q _3936_/B1 _7561_/Q VGND VGND VPWR VPWR _3868_/X
+ sky130_fd_sc_hd__a32o_2
X_3799_ _7436_/Q _3913_/A2 _3816_/B1 _7340_/Q _3798_/X VGND VGND VPWR VPWR _3799_/X
+ sky130_fd_sc_hd__a221o_2
XTAP_TAPCELL_ROW_98_1257 VGND VPWR sky130_fd_sc_hd__tapvpwrvgnd_1
XFILLER_11_57 VGND VGND VPWR VPWR sky130_fd_sc_hd__decap_3
X_7208_ _7264_/CLK _7208_/D VGND VGND VPWR VPWR _7208_/Q sky130_fd_sc_hd__dfxtp_2
X_5469_ _5469_/A0 _5591_/A1 _5471_/S VGND VGND VPWR VPWR _7171_/D sky130_fd_sc_hd__mux2_2
Xwire2104 _3592_/Y VGND VGND VPWR VPWR _3945_/A2 sky130_fd_sc_hd__clkdlybuf4s25_1
XPHY_EDGE_ROW_21_Left_125 VGND VGND VPWR VPWR sky130_fd_sc_hd__decap_3
X_7139_ _7407_/CLK _7139_/D VGND VGND VPWR VPWR _7139_/Q sky130_fd_sc_hd__dfxtp_2
XFILLER_46_238 VGND VGND VPWR VPWR sky130_fd_sc_hd__fill_2
XFILLER_74_536 VGND VGND VPWR VPWR sky130_fd_sc_hd__decap_3
XFILLER_14_102 VGND VGND VPWR VPWR sky130_fd_sc_hd__decap_3
XFILLER_42_455 VGND VGND VPWR VPWR sky130_fd_sc_hd__fill_1
XFILLER_42_466 VGND VGND VPWR VPWR sky130_fd_sc_hd__decap_3
XPHY_EDGE_ROW_30_Left_134 VGND VGND VPWR VPWR sky130_fd_sc_hd__decap_3
XTAP_TAPCELL_ROW_40_645 VGND VPWR sky130_fd_sc_hd__tapvpwrvgnd_1
XFILLER_6_301 VGND VGND VPWR VPWR sky130_fd_sc_hd__decap_3
XTAP_TAPCELL_ROW_12_347 VGND VPWR sky130_fd_sc_hd__tapvpwrvgnd_1
XFILLER_6_312 VGND VGND VPWR VPWR sky130_fd_sc_hd__decap_3
XFILLER_6_345 VGND VGND VPWR VPWR sky130_fd_sc_hd__decap_3
XTAP_TAPCELL_ROW_75_1010 VGND VPWR sky130_fd_sc_hd__tapvpwrvgnd_1
XFILLER_69_319 VGND VGND VPWR VPWR sky130_fd_sc_hd__fill_1
XFILLER_77_330 VGND VGND VPWR VPWR sky130_fd_sc_hd__decap_3
XTAP_TAPCELL_ROW_48_723 VGND VPWR sky130_fd_sc_hd__tapvpwrvgnd_1
XFILLER_93_60 VGND VGND VPWR VPWR sky130_fd_sc_hd__fill_1
XFILLER_18_474 VGND VGND VPWR VPWR sky130_fd_sc_hd__fill_2
XFILLER_18_496 VGND VGND VPWR VPWR sky130_fd_sc_hd__decap_3
XFILLER_33_400 VGND VGND VPWR VPWR sky130_fd_sc_hd__decap_3
XFILLER_45_260 VGND VGND VPWR VPWR sky130_fd_sc_hd__fill_2
XFILLER_33_455 VGND VGND VPWR VPWR sky130_fd_sc_hd__decap_3
X_4840_ _4840_/A0 _5730_/A1 _4840_/S VGND VGND VPWR VPWR _6899_/D sky130_fd_sc_hd__mux2_2
XFILLER_33_488 VGND VGND VPWR VPWR sky130_fd_sc_hd__decap_3
XFILLER_20_138 VGND VGND VPWR VPWR sky130_fd_sc_hd__fill_2
X_6510_ _6510_/A1 _6906_/Q _7242_/Q _6510_/B2 VGND VGND VPWR VPWR _6510_/X sky130_fd_sc_hd__o22a_2
X_4771_ _4771_/A0 _5606_/A1 _4771_/S VGND VGND VPWR VPWR _6870_/D sky130_fd_sc_hd__mux2_2
X_7490_ _7490_/CLK _7490_/D place2024/X VGND VGND VPWR VPWR _7490_/Q sky130_fd_sc_hd__dfrtp_2
X_6441_ _6439_/Y _6515_/A3 _6440_/X VGND VGND VPWR VPWR _6441_/X sky130_fd_sc_hd__a21o_4
X_3653_ _3653_/A1 _3931_/B _3565_/Y _3653_/C1 _3652_/X VGND VGND VPWR VPWR _3653_/X
+ sky130_fd_sc_hd__a2111o_2
X_6372_ _6672_/A0 _6376_/A2 _6411_/A3 _6411_/B1 _6372_/B2 VGND VGND VPWR VPWR _7402_/D
+ sky130_fd_sc_hd__a32o_2
X_5323_ _5323_/A0 _4644_/X _5329_/S VGND VGND VPWR VPWR _7104_/D sky130_fd_sc_hd__mux2_2
X_3584_ _4608_/B1 _4608_/A1 _4608_/A2 _3582_/Y _3584_/C1 VGND VGND VPWR VPWR _3585_/A
+ sky130_fd_sc_hd__a311o_2
Xoutput2078 place171/X VGND VGND VPWR VPWR result[17] sky130_fd_sc_hd__dlymetal6s4s_1
Xhold2704 _7174_/Q VGND VGND VPWR VPWR _5476_/A0 sky130_fd_sc_hd__dlygate4sd3_1
Xoutput2089 _4270_/X VGND VGND VPWR VPWR result[27] sky130_fd_sc_hd__buf_6
XTAP_TAPCELL_ROW_93_1198 VGND VPWR sky130_fd_sc_hd__tapvpwrvgnd_1
XFILLER_102_438 VGND VGND VPWR VPWR sky130_fd_sc_hd__decap_3
Xhold2715 _6968_/Q VGND VGND VPWR VPWR _4998_/A0 sky130_fd_sc_hd__dlygate4sd3_1
Xhold2726 _7216_/Q VGND VGND VPWR VPWR _5568_/A0 sky130_fd_sc_hd__dlygate4sd3_1
Xhold2737 _6881_/Q VGND VGND VPWR VPWR _4802_/A0 sky130_fd_sc_hd__dlygate4sd3_1
Xhold2748 _7241_/Q VGND VGND VPWR VPWR _5623_/A0 sky130_fd_sc_hd__dlygate4sd3_1
Xhold2759 _7092_/Q VGND VGND VPWR VPWR _5293_/A0 sky130_fd_sc_hd__dlygate4sd3_1
X_4136_ _4406_/B1 _4136_/A2 _4133_/X _4131_/Y VGND VGND VPWR VPWR _4136_/Y sky130_fd_sc_hd__a22oi_2
XFILLER_56_536 VGND VGND VPWR VPWR sky130_fd_sc_hd__decap_3
XFILLER_56_569 VGND VGND VPWR VPWR sky130_fd_sc_hd__decap_3
XFILLER_73_19 VGND VGND VPWR VPWR sky130_fd_sc_hd__fill_1
X_4067_ _4067_/A _7312_/Q _4532_/A _4499_/C VGND VGND VPWR VPWR _4077_/D sky130_fd_sc_hd__and4_2
XFILLER_43_219 VGND VGND VPWR VPWR sky130_fd_sc_hd__decap_3
XFILLER_24_433 VGND VGND VPWR VPWR sky130_fd_sc_hd__fill_1
XFILLER_36_282 VGND VGND VPWR VPWR sky130_fd_sc_hd__decap_3
XFILLER_24_477 VGND VGND VPWR VPWR sky130_fd_sc_hd__fill_2
XFILLER_7_109 VGND VGND VPWR VPWR sky130_fd_sc_hd__decap_3
X_6708_ _6302_/C _6708_/A2 _6708_/A3 _7515_/Q VGND VGND VPWR VPWR _6708_/X sky130_fd_sc_hd__o31a_2
XTAP_TAPCELL_ROW_102_1294 VGND VPWR sky130_fd_sc_hd__tapvpwrvgnd_1
XFILLER_22_45 VGND VGND VPWR VPWR sky130_fd_sc_hd__fill_1
XFILLER_3_315 VGND VGND VPWR VPWR sky130_fd_sc_hd__decap_3
XFILLER_98_49 VGND VGND VPWR VPWR sky130_fd_sc_hd__fill_2
XFILLER_3_337 VGND VGND VPWR VPWR sky130_fd_sc_hd__decap_3
XFILLER_59_352 VGND VGND VPWR VPWR sky130_fd_sc_hd__decap_3
XFILLER_101_482 VGND VGND VPWR VPWR sky130_fd_sc_hd__fill_2
XFILLER_47_558 VGND VGND VPWR VPWR sky130_fd_sc_hd__fill_2
XFILLER_47_75 VGND VGND VPWR VPWR sky130_fd_sc_hd__decap_3
XFILLER_34_219 VGND VGND VPWR VPWR sky130_fd_sc_hd__fill_2
XFILLER_74_377 VGND VGND VPWR VPWR sky130_fd_sc_hd__fill_1
XTAP_TAPCELL_ROW_17_406 VGND VPWR sky130_fd_sc_hd__tapvpwrvgnd_1
XFILLER_42_230 VGND VGND VPWR VPWR sky130_fd_sc_hd__decap_3
XFILLER_42_296 VGND VGND VPWR VPWR sky130_fd_sc_hd__decap_3
XTAP_TAPCELL_ROW_53_781 VGND VPWR sky130_fd_sc_hd__tapvpwrvgnd_1
XTAP_TAPCELL_ROW_25_483 VGND VPWR sky130_fd_sc_hd__tapvpwrvgnd_1
XFILLER_30_458 VGND VGND VPWR VPWR sky130_fd_sc_hd__decap_3
XFILLER_8_58 VGND VGND VPWR VPWR sky130_fd_sc_hd__decap_3
XFILLER_10_160 VGND VGND VPWR VPWR sky130_fd_sc_hd__decap_3
XFILLER_7_610 VGND VGND VPWR VPWR sky130_fd_sc_hd__fill_2
XFILLER_10_182 VGND VGND VPWR VPWR sky130_fd_sc_hd__fill_1
XFILLER_6_153 VGND VGND VPWR VPWR sky130_fd_sc_hd__decap_3
XFILLER_6_186 VGND VGND VPWR VPWR sky130_fd_sc_hd__fill_1
Xplace1309 _4778_/A VGND VGND VPWR VPWR _6457_/B1 sky130_fd_sc_hd__buf_2
XFILLER_6_197 VGND VGND VPWR VPWR sky130_fd_sc_hd__fill_1
XFILLER_65_355 VGND VGND VPWR VPWR sky130_fd_sc_hd__decap_3
X_6990_ _7274_/CLK _6990_/D VGND VGND VPWR VPWR _6990_/Q sky130_fd_sc_hd__dfxtp_2
X_5941_ _5771_/Y _6515_/A3 _5941_/A3 _5734_/Y VGND VGND VPWR VPWR _5941_/X sky130_fd_sc_hd__o31a_2
XTAP_TAPCELL_ROW_84_1109 VGND VPWR sky130_fd_sc_hd__tapvpwrvgnd_1
XFILLER_33_252 VGND VGND VPWR VPWR sky130_fd_sc_hd__decap_3
XFILLER_61_561 VGND VGND VPWR VPWR sky130_fd_sc_hd__fill_1
X_7611_ _7611_/CLK _7611_/D place2060/X VGND VGND VPWR VPWR _7611_/Q sky130_fd_sc_hd__dfrtp_2
X_4823_ _4823_/A0 _5713_/A1 _4840_/S VGND VGND VPWR VPWR _6891_/D sky130_fd_sc_hd__mux2_2
X_7542_ _7542_/CLK _7542_/D place2047/X VGND VGND VPWR VPWR _7542_/Q sky130_fd_sc_hd__dfrtp_2
X_7473_ _7610_/CLK _7473_/D place2066/X VGND VGND VPWR VPWR _7473_/Q sky130_fd_sc_hd__dfrtp_2
X_3705_ _7512_/Q _3725_/A2 _3757_/B1 _7448_/Q VGND VGND VPWR VPWR _4279_/B sky130_fd_sc_hd__a22oi_2
X_4685_ _4743_/A _4733_/B1 _4727_/D _4683_/X _4684_/Y VGND VGND VPWR VPWR _4685_/X
+ sky130_fd_sc_hd__o311a_2
XTAP_TAPCELL_ROW_95_1216 VGND VPWR sky130_fd_sc_hd__tapvpwrvgnd_1
Xplace1821 _3652_/A VGND VGND VPWR VPWR _3931_/C sky130_fd_sc_hd__buf_2
Xplace1810 _3598_/C VGND VGND VPWR VPWR _3545_/B sky130_fd_sc_hd__buf_2
X_6424_ _6473_/A1 _7013_/Q _6929_/Q _6424_/B2 VGND VGND VPWR VPWR _6424_/X sky130_fd_sc_hd__o22a_2
X_3636_ _3717_/A1 _3792_/A2 _7380_/Q _3792_/B1 _7572_/Q VGND VGND VPWR VPWR _3636_/X
+ sky130_fd_sc_hd__a32o_2
Xplace1854 _3459_/Y VGND VGND VPWR VPWR _4613_/A3 sky130_fd_sc_hd__buf_2
Xplace1843 _3493_/X VGND VGND VPWR VPWR _4352_/C sky130_fd_sc_hd__buf_2
Xplace1832 _3952_/A1 VGND VGND VPWR VPWR _4003_/A1 sky130_fd_sc_hd__buf_2
X_3567_ _3567_/A _3567_/B _3549_/Y VGND VGND VPWR VPWR _3567_/Y sky130_fd_sc_hd__nor3b_2
XFILLER_0_318 VGND VGND VPWR VPWR sky130_fd_sc_hd__decap_3
Xplace1887 _3499_/B VGND VGND VPWR VPWR _3846_/A3 sky130_fd_sc_hd__buf_2
Xplace1876 _3462_/Y VGND VGND VPWR VPWR _3463_/C sky130_fd_sc_hd__buf_2
Xplace1865 _3508_/A VGND VGND VPWR VPWR _3826_/C sky130_fd_sc_hd__buf_4
X_6286_ _6294_/A _6286_/B VGND VGND VPWR VPWR _7349_/D sky130_fd_sc_hd__and2_2
X_5306_ _5306_/A0 _5612_/A1 _5331_/S VGND VGND VPWR VPWR _7096_/D sky130_fd_sc_hd__mux2_2
Xplace1898 _3437_/X VGND VGND VPWR VPWR _5850_/A sky130_fd_sc_hd__buf_2
Xhold2512 _6960_/Q VGND VGND VPWR VPWR _4981_/A0 sky130_fd_sc_hd__dlygate4sd3_1
Xhold2501 _7207_/Q VGND VGND VPWR VPWR _5547_/A0 sky130_fd_sc_hd__dlygate4sd3_1
X_5237_ _5237_/A0 _5564_/A1 _5255_/S VGND VGND VPWR VPWR _7074_/D sky130_fd_sc_hd__mux2_2
X_3498_ _3458_/Y _3459_/Y _3460_/Y VGND VGND VPWR VPWR _3498_/Y sky130_fd_sc_hd__a21oi_4
XFILLER_29_503 VGND VGND VPWR VPWR sky130_fd_sc_hd__fill_1
Xhold2556 _7262_/Q VGND VGND VPWR VPWR _5667_/A0 sky130_fd_sc_hd__dlygate4sd3_1
Xhold2545 _6908_/Q VGND VGND VPWR VPWR _4862_/A0 sky130_fd_sc_hd__dlygate4sd3_1
Xhold2534 _7267_/Q VGND VGND VPWR VPWR _5679_/A0 sky130_fd_sc_hd__dlygate4sd3_1
Xhold2523 _7077_/Q VGND VGND VPWR VPWR _5246_/A0 sky130_fd_sc_hd__dlygate4sd3_1
XFILLER_29_514 VGND VGND VPWR VPWR sky130_fd_sc_hd__decap_3
Xhold2589 _7252_/Q VGND VGND VPWR VPWR _5646_/A0 sky130_fd_sc_hd__dlygate4sd3_1
Xhold2578 _6965_/Q VGND VGND VPWR VPWR _4992_/A0 sky130_fd_sc_hd__dlygate4sd3_1
Xhold2567 _7115_/Q VGND VGND VPWR VPWR _5346_/A0 sky130_fd_sc_hd__dlygate4sd3_1
XFILLER_29_547 VGND VGND VPWR VPWR sky130_fd_sc_hd__decap_3
X_5099_ _5099_/A0 _5099_/A1 _5120_/S VGND VGND VPWR VPWR _7014_/D sky130_fd_sc_hd__mux2_2
X_4119_ _4119_/A VGND VGND VPWR VPWR _4119_/Y sky130_fd_sc_hd__inv_4
XFILLER_44_539 VGND VGND VPWR VPWR sky130_fd_sc_hd__decap_3
XFILLER_17_67 VGND VGND VPWR VPWR sky130_fd_sc_hd__decap_3
XFILLER_24_230 VGND VGND VPWR VPWR sky130_fd_sc_hd__decap_3
XFILLER_12_425 VGND VGND VPWR VPWR sky130_fd_sc_hd__decap_3
XTAP_TAPCELL_ROW_50_751 VGND VPWR sky130_fd_sc_hd__tapvpwrvgnd_1
XFILLER_33_88 VGND VGND VPWR VPWR sky130_fd_sc_hd__fill_1
XTAP_TAPCELL_ROW_22_453 VGND VPWR sky130_fd_sc_hd__tapvpwrvgnd_1
XFILLER_3_134 VGND VGND VPWR VPWR sky130_fd_sc_hd__decap_3
XFILLER_58_74 VGND VGND VPWR VPWR sky130_fd_sc_hd__decap_3
XFILLER_94_417 VGND VGND VPWR VPWR sky130_fd_sc_hd__decap_3
XFILLER_58_85 VGND VGND VPWR VPWR sky130_fd_sc_hd__fill_2
XFILLER_58_96 VGND VGND VPWR VPWR sky130_fd_sc_hd__fill_2
XFILLER_101_290 VGND VGND VPWR VPWR sky130_fd_sc_hd__fill_2
XFILLER_47_355 VGND VGND VPWR VPWR sky130_fd_sc_hd__decap_3
XFILLER_74_141 VGND VGND VPWR VPWR sky130_fd_sc_hd__decap_3
XFILLER_35_528 VGND VGND VPWR VPWR sky130_fd_sc_hd__fill_2
XFILLER_15_241 VGND VGND VPWR VPWR sky130_fd_sc_hd__fill_2
XFILLER_15_285 VGND VGND VPWR VPWR sky130_fd_sc_hd__decap_3
XFILLER_30_211 VGND VGND VPWR VPWR sky130_fd_sc_hd__decap_3
XFILLER_30_277 VGND VGND VPWR VPWR sky130_fd_sc_hd__decap_3
XFILLER_7_440 VGND VGND VPWR VPWR sky130_fd_sc_hd__decap_3
XFILLER_7_462 VGND VGND VPWR VPWR sky130_fd_sc_hd__decap_3
Xplace1106 _4774_/Y VGND VGND VPWR VPWR _5730_/A1 sky130_fd_sc_hd__buf_2
X_4470_ _7302_/Q _4379_/A _4470_/A3 _4430_/Y VGND VGND VPWR VPWR _4470_/X sky130_fd_sc_hd__a31o_2
Xplace1117 _4721_/X VGND VGND VPWR VPWR _5591_/A1 sky130_fd_sc_hd__buf_2
Xplace1128 _4677_/X VGND VGND VPWR VPWR _5701_/A1 sky130_fd_sc_hd__buf_2
Xplace1139 _4769_/Y VGND VGND VPWR VPWR _5728_/A1 sky130_fd_sc_hd__buf_2
Xrebuffer2118 _3444_/A VGND VGND VPWR VPWR _3470_/C1 sky130_fd_sc_hd__buf_2
X_3421_ _3462_/B _3421_/B _3421_/C VGND VGND VPWR VPWR _3421_/Y sky130_fd_sc_hd__nand3_2
Xrebuffer2129 _3509_/Y VGND VGND VPWR VPWR place1725/A sky130_fd_sc_hd__buf_6
X_6140_ _6138_/X _6139_/X _6506_/A1 _6457_/C1 VGND VGND VPWR VPWR _6141_/C sky130_fd_sc_hd__a211o_2
X_6071_ _6211_/B1 _6506_/A2 _6060_/X _6063_/X _6070_/X VGND VGND VPWR VPWR _6071_/X
+ sky130_fd_sc_hd__o311a_2
XTAP_TAPCELL_ROW_90_1168 VGND VPWR sky130_fd_sc_hd__tapvpwrvgnd_1
XFILLER_57_119 VGND VGND VPWR VPWR sky130_fd_sc_hd__fill_1
X_5022_ _5022_/A0 _4751_/Y _5028_/S VGND VGND VPWR VPWR _6979_/D sky130_fd_sc_hd__mux2_2
XFILLER_38_377 VGND VGND VPWR VPWR sky130_fd_sc_hd__decap_3
XFILLER_65_152 VGND VGND VPWR VPWR sky130_fd_sc_hd__decap_3
XFILLER_26_539 VGND VGND VPWR VPWR sky130_fd_sc_hd__decap_3
X_6973_ _7279_/CLK _6973_/D VGND VGND VPWR VPWR _6973_/Q sky130_fd_sc_hd__dfxtp_2
XFILLER_21_211 VGND VGND VPWR VPWR sky130_fd_sc_hd__decap_3
X_5855_ _7581_/Q _6565_/B _5854_/X VGND VGND VPWR VPWR _5855_/X sky130_fd_sc_hd__o21a_2
XTAP_TAPCELL_ROW_64_898 VGND VPWR sky130_fd_sc_hd__tapvpwrvgnd_1
XFILLER_21_244 VGND VGND VPWR VPWR sky130_fd_sc_hd__decap_3
XFILLER_61_391 VGND VGND VPWR VPWR sky130_fd_sc_hd__fill_1
X_4806_ _4806_/A0 _5696_/A1 _4806_/S VGND VGND VPWR VPWR _6883_/D sky130_fd_sc_hd__mux2_2
XFILLER_21_266 VGND VGND VPWR VPWR sky130_fd_sc_hd__decap_3
XFILLER_9_90 VGND VGND VPWR VPWR sky130_fd_sc_hd__decap_3
X_5786_ _5797_/A1 _7061_/Q _6865_/Q _6450_/B2 VGND VGND VPWR VPWR _5786_/X sky130_fd_sc_hd__o22a_2
X_7525_ clkload5/A _7525_/D place2061/X VGND VGND VPWR VPWR _7525_/Q sky130_fd_sc_hd__dfrtp_2
X_4737_ _4734_/X _4738_/A2 _4737_/B1 _4773_/B2 _6547_/A1 VGND VGND VPWR VPWR _4737_/X
+ sky130_fd_sc_hd__o221a_2
X_7456_ clkload2/A _7456_/D place2028/X VGND VGND VPWR VPWR _7456_/Q sky130_fd_sc_hd__dfrtp_2
X_4668_ _3842_/A _6404_/A2 _6089_/A1 _4733_/B1 _4669_/B2 VGND VGND VPWR VPWR _4668_/X
+ sky130_fd_sc_hd__a221o_2
X_6407_ _6406_/Y _7415_/Q _6407_/S VGND VGND VPWR VPWR _7415_/D sky130_fd_sc_hd__mux2_2
XFILLER_103_500 VGND VGND VPWR VPWR sky130_fd_sc_hd__decap_3
Xplace1640 _3598_/X VGND VGND VPWR VPWR _3848_/B1 sky130_fd_sc_hd__buf_2
Xplace1651 _6331_/A2 VGND VGND VPWR VPWR _6346_/A2 sky130_fd_sc_hd__buf_2
Xplace1662 _3828_/B2 VGND VGND VPWR VPWR _3812_/B1 sky130_fd_sc_hd__buf_2
X_7387_ _7514_/CLK _7387_/D place2043/X VGND VGND VPWR VPWR _7387_/Q sky130_fd_sc_hd__dfrtp_2
XFILLER_0_126 VGND VGND VPWR VPWR sky130_fd_sc_hd__decap_3
XFILLER_103_533 VGND VGND VPWR VPWR sky130_fd_sc_hd__decap_3
Xhold3010 _7431_/Q VGND VGND VPWR VPWR _6520_/A0 sky130_fd_sc_hd__dlygate4sd3_1
Xhold3021 _6358_/X VGND VGND VPWR VPWR _7391_/D sky130_fd_sc_hd__dlygate4sd3_1
Xhold3032 _7509_/Q VGND VGND VPWR VPWR _6696_/A0 sky130_fd_sc_hd__dlygate4sd3_1
Xplace1673 place1674/X VGND VGND VPWR VPWR _3947_/A2 sky130_fd_sc_hd__buf_2
Xplace1684 _6376_/A2 VGND VGND VPWR VPWR _6411_/A2 sky130_fd_sc_hd__buf_2
Xplace1695 _3582_/A VGND VGND VPWR VPWR _6088_/A sky130_fd_sc_hd__buf_2
XFILLER_103_577 VGND VGND VPWR VPWR sky130_fd_sc_hd__fill_1
Xhold3043 _7539_/Q VGND VGND VPWR VPWR _6759_/A1 sky130_fd_sc_hd__dlygate4sd3_1
X_6269_ _6298_/A _6269_/B VGND VGND VPWR VPWR _7341_/D sky130_fd_sc_hd__and2_2
XFILLER_29_311 VGND VGND VPWR VPWR sky130_fd_sc_hd__decap_3
XFILLER_28_44 VGND VGND VPWR VPWR sky130_fd_sc_hd__decap_3
XFILLER_28_66 VGND VGND VPWR VPWR sky130_fd_sc_hd__decap_3
XFILLER_29_333 VGND VGND VPWR VPWR sky130_fd_sc_hd__decap_3
Xhold2397 _7038_/Q VGND VGND VPWR VPWR _5150_/A0 sky130_fd_sc_hd__dlygate4sd3_1
Xhold2386 _7232_/Q VGND VGND VPWR VPWR _5602_/A0 sky130_fd_sc_hd__dlygate4sd3_1
Xhold2375 _7090_/Q VGND VGND VPWR VPWR _5287_/A0 sky130_fd_sc_hd__dlygate4sd3_1
XFILLER_56_141 VGND VGND VPWR VPWR sky130_fd_sc_hd__decap_3
XFILLER_56_174 VGND VGND VPWR VPWR sky130_fd_sc_hd__fill_2
XFILLER_25_561 VGND VGND VPWR VPWR sky130_fd_sc_hd__fill_1
XFILLER_32_509 VGND VGND VPWR VPWR sky130_fd_sc_hd__decap_3
XFILLER_44_369 VGND VGND VPWR VPWR sky130_fd_sc_hd__fill_2
XFILLER_12_200 VGND VGND VPWR VPWR sky130_fd_sc_hd__decap_3
XFILLER_71_188 VGND VGND VPWR VPWR sky130_fd_sc_hd__decap_3
XPHY_EDGE_ROW_4_Left_108 VGND VGND VPWR VPWR sky130_fd_sc_hd__decap_3
XFILLER_40_586 VGND VGND VPWR VPWR sky130_fd_sc_hd__fill_2
XFILLER_40_597 VGND VGND VPWR VPWR sky130_fd_sc_hd__fill_1
XFILLER_8_215 VGND VGND VPWR VPWR sky130_fd_sc_hd__fill_2
XFILLER_4_421 VGND VGND VPWR VPWR sky130_fd_sc_hd__decap_3
XFILLER_4_465 VGND VGND VPWR VPWR sky130_fd_sc_hd__decap_3
XFILLER_69_84 VGND VGND VPWR VPWR sky130_fd_sc_hd__fill_2
XTAP_TAPCELL_ROW_7_292 VGND VPWR sky130_fd_sc_hd__tapvpwrvgnd_1
XFILLER_47_130 VGND VGND VPWR VPWR sky130_fd_sc_hd__decap_3
XPHY_EDGE_ROW_13_Right_13 VGND VGND VPWR VPWR sky130_fd_sc_hd__decap_3
XFILLER_47_163 VGND VGND VPWR VPWR sky130_fd_sc_hd__decap_3
XFILLER_47_196 VGND VGND VPWR VPWR sky130_fd_sc_hd__decap_3
XFILLER_62_122 VGND VGND VPWR VPWR sky130_fd_sc_hd__fill_1
XFILLER_35_358 VGND VGND VPWR VPWR sky130_fd_sc_hd__decap_3
XFILLER_62_155 VGND VGND VPWR VPWR sky130_fd_sc_hd__decap_3
XFILLER_90_442 VGND VGND VPWR VPWR sky130_fd_sc_hd__fill_1
X_3970_ _4734_/A2 _3961_/X _4012_/A1 _3964_/Y _3972_/A VGND VGND VPWR VPWR _3970_/X
+ sky130_fd_sc_hd__o221a_4
XTAP_TAPCELL_ROW_61_868 VGND VPWR sky130_fd_sc_hd__tapvpwrvgnd_1
XFILLER_31_575 VGND VGND VPWR VPWR sky130_fd_sc_hd__decap_3
XFILLER_86_3 VGND VGND VPWR VPWR sky130_fd_sc_hd__fill_1
X_5640_ _5640_/A0 _5701_/A1 _5654_/S VGND VGND VPWR VPWR _7249_/D sky130_fd_sc_hd__mux2_2
XPHY_EDGE_ROW_22_Right_22 VGND VGND VPWR VPWR sky130_fd_sc_hd__decap_3
X_7310_ _7608_/CLK _7310_/D place2050/X VGND VGND VPWR VPWR _7310_/Q sky130_fd_sc_hd__dfrtp_2
X_4522_ _4533_/A _7603_/D _4533_/D _4521_/X VGND VGND VPWR VPWR _4522_/X sky130_fd_sc_hd__o31a_2
XFILLER_7_281 VGND VGND VPWR VPWR sky130_fd_sc_hd__decap_3
X_7241_ _7241_/CLK _7241_/D VGND VGND VPWR VPWR _7241_/Q sky130_fd_sc_hd__dfxtp_2
X_7172_ _7575_/CLK _7172_/D VGND VGND VPWR VPWR _7172_/Q sky130_fd_sc_hd__dfxtp_2
X_4384_ _4379_/A _4379_/B _4448_/B _7299_/Q VGND VGND VPWR VPWR _4411_/C sky130_fd_sc_hd__a31o_2
X_6123_ _6146_/B1 _7027_/Q _6943_/Q _6399_/B2 VGND VGND VPWR VPWR _6123_/X sky130_fd_sc_hd__o22a_2
XPHY_EDGE_ROW_31_Right_31 VGND VGND VPWR VPWR sky130_fd_sc_hd__decap_3
X_6054_ _6052_/X _6053_/X _6478_/B1 VGND VGND VPWR VPWR _6055_/D sky130_fd_sc_hd__a21oi_2
X_5005_ _5005_/A0 _5188_/A1 _5024_/S VGND VGND VPWR VPWR _6971_/D sky130_fd_sc_hd__mux2_2
XTAP_TAPCELL_ROW_69_946 VGND VPWR sky130_fd_sc_hd__tapvpwrvgnd_1
XFILLER_26_325 VGND VGND VPWR VPWR sky130_fd_sc_hd__decap_3
XFILLER_26_336 VGND VGND VPWR VPWR sky130_fd_sc_hd__decap_3
XFILLER_53_122 VGND VGND VPWR VPWR sky130_fd_sc_hd__decap_3
XFILLER_41_306 VGND VGND VPWR VPWR sky130_fd_sc_hd__decap_3
XFILLER_53_144 VGND VGND VPWR VPWR sky130_fd_sc_hd__fill_1
X_6956_ _7264_/CLK _6956_/D VGND VGND VPWR VPWR _6956_/Q sky130_fd_sc_hd__dfxtp_2
XFILLER_53_199 VGND VGND VPWR VPWR sky130_fd_sc_hd__decap_3
X_5907_ _5905_/X _5906_/X _6506_/A1 _6156_/C1 VGND VGND VPWR VPWR _5908_/C sky130_fd_sc_hd__a211o_2
XFILLER_34_380 VGND VGND VPWR VPWR sky130_fd_sc_hd__decap_3
X_6887_ _7279_/CLK _6887_/D VGND VGND VPWR VPWR _6887_/Q sky130_fd_sc_hd__dfxtp_2
XFILLER_14_68 VGND VGND VPWR VPWR sky130_fd_sc_hd__fill_2
XFILLER_22_575 VGND VGND VPWR VPWR sky130_fd_sc_hd__decap_3
XPHY_EDGE_ROW_40_Right_40 VGND VGND VPWR VPWR sky130_fd_sc_hd__decap_3
X_5838_ _5836_/X _5837_/X _5671_/B VGND VGND VPWR VPWR _5838_/Y sky130_fd_sc_hd__o21ai_2
XFILLER_22_597 VGND VGND VPWR VPWR sky130_fd_sc_hd__fill_1
X_5769_ _6449_/B1 _7229_/Q _7145_/Q _6448_/B2 VGND VGND VPWR VPWR _5769_/X sky130_fd_sc_hd__o22a_2
X_7508_ _7509_/CLK _7508_/D place2069/X VGND VGND VPWR VPWR _7508_/Q sky130_fd_sc_hd__dfrtp_2
XFILLER_5_229 VGND VGND VPWR VPWR sky130_fd_sc_hd__fill_2
X_7439_ _7610_/CLK _7439_/D place2057/X VGND VGND VPWR VPWR _7439_/Q sky130_fd_sc_hd__dfrtp_2
Xplace1470 _3583_/Y VGND VGND VPWR VPWR _3584_/C1 sky130_fd_sc_hd__buf_2
Xplace1481 _5312_/A1 VGND VGND VPWR VPWR _5679_/A1 sky130_fd_sc_hd__buf_2
XFILLER_39_54 VGND VGND VPWR VPWR sky130_fd_sc_hd__fill_2
XFILLER_39_65 VGND VGND VPWR VPWR sky130_fd_sc_hd__decap_3
XFILLER_103_396 VGND VGND VPWR VPWR sky130_fd_sc_hd__decap_3
XTAP_TAPCELL_ROW_4_262 VGND VPWR sky130_fd_sc_hd__tapvpwrvgnd_1
XPHY_EDGE_ROW_95_Left_199 VGND VGND VPWR VPWR sky130_fd_sc_hd__decap_3
XFILLER_29_196 VGND VGND VPWR VPWR sky130_fd_sc_hd__decap_3
XFILLER_44_100 VGND VGND VPWR VPWR sky130_fd_sc_hd__decap_3
XFILLER_72_464 VGND VGND VPWR VPWR sky130_fd_sc_hd__fill_1
XFILLER_32_317 VGND VGND VPWR VPWR sky130_fd_sc_hd__decap_3
XFILLER_13_564 VGND VGND VPWR VPWR sky130_fd_sc_hd__decap_3
XFILLER_9_502 VGND VGND VPWR VPWR sky130_fd_sc_hd__fill_2
XTAP_TAPCELL_ROW_78_1041 VGND VPWR sky130_fd_sc_hd__tapvpwrvgnd_1
XFILLER_99_306 VGND VGND VPWR VPWR sky130_fd_sc_hd__decap_3
XFILLER_4_273 VGND VGND VPWR VPWR sky130_fd_sc_hd__decap_3
XFILLER_67_214 VGND VGND VPWR VPWR sky130_fd_sc_hd__decap_3
XFILLER_95_501 VGND VGND VPWR VPWR sky130_fd_sc_hd__decap_3
XFILLER_67_258 VGND VGND VPWR VPWR sky130_fd_sc_hd__decap_3
XFILLER_95_578 VGND VGND VPWR VPWR sky130_fd_sc_hd__decap_3
XTAP_TAPCELL_ROW_66_916 VGND VPWR sky130_fd_sc_hd__tapvpwrvgnd_1
XTAP_TAPCELL_ROW_38_618 VGND VPWR sky130_fd_sc_hd__tapvpwrvgnd_1
XFILLER_35_155 VGND VGND VPWR VPWR sky130_fd_sc_hd__decap_3
XFILLER_63_453 VGND VGND VPWR VPWR sky130_fd_sc_hd__fill_1
XFILLER_90_261 VGND VGND VPWR VPWR sky130_fd_sc_hd__fill_2
XFILLER_35_199 VGND VGND VPWR VPWR sky130_fd_sc_hd__decap_3
X_3953_ _7423_/Q _4004_/A2 _3598_/X _7327_/Q _3952_/X VGND VGND VPWR VPWR _3955_/A
+ sky130_fd_sc_hd__a221oi_2
X_6672_ _6672_/A0 _6080_/X _6675_/S VGND VGND VPWR VPWR _7498_/D sky130_fd_sc_hd__mux2_2
X_3884_ _3884_/A _3885_/A VGND VGND VPWR VPWR _3886_/A sky130_fd_sc_hd__or2_2
XFILLER_31_383 VGND VGND VPWR VPWR sky130_fd_sc_hd__decap_3
X_5623_ _5623_/A0 _5684_/A1 _5637_/S VGND VGND VPWR VPWR _7241_/D sky130_fd_sc_hd__mux2_2
X_4505_ _4561_/A1 _4379_/B _4448_/B _4067_/A VGND VGND VPWR VPWR _4506_/C sky130_fd_sc_hd__a31o_2
X_7224_ _7282_/CLK _7224_/D VGND VGND VPWR VPWR _7224_/Q sky130_fd_sc_hd__dfxtp_2
X_4436_ _4436_/A1 _4361_/B _4408_/D _4408_/C _4401_/X VGND VGND VPWR VPWR _4436_/Y
+ sky130_fd_sc_hd__o2111ai_2
X_7155_ _7272_/CLK _7155_/D VGND VGND VPWR VPWR _7155_/Q sky130_fd_sc_hd__dfxtp_2
X_6106_ _6102_/X _6104_/X _6506_/A1 _6156_/C1 VGND VGND VPWR VPWR _6106_/X sky130_fd_sc_hd__a211o_2
X_7086_ _7279_/CLK _7086_/D VGND VGND VPWR VPWR _7086_/Q sky130_fd_sc_hd__dfxtp_2
X_4298_ _4298_/A1 _4297_/X _4289_/B _4288_/X VGND VGND VPWR VPWR _4298_/Y sky130_fd_sc_hd__a22oi_2
X_6037_ _6211_/B1 _6506_/A2 _6023_/X _6029_/X _6036_/X VGND VGND VPWR VPWR _6037_/X
+ sky130_fd_sc_hd__o311a_2
XFILLER_100_399 VGND VGND VPWR VPWR sky130_fd_sc_hd__decap_3
XFILLER_73_228 VGND VGND VPWR VPWR sky130_fd_sc_hd__decap_3
XTAP_TAPCELL_ROW_1_232 VGND VPWR sky130_fd_sc_hd__tapvpwrvgnd_1
XFILLER_26_144 VGND VGND VPWR VPWR sky130_fd_sc_hd__decap_3
XFILLER_25_45 VGND VGND VPWR VPWR sky130_fd_sc_hd__decap_3
XFILLER_26_188 VGND VGND VPWR VPWR sky130_fd_sc_hd__decap_3
XFILLER_54_486 VGND VGND VPWR VPWR sky130_fd_sc_hd__decap_3
XFILLER_25_78 VGND VGND VPWR VPWR sky130_fd_sc_hd__decap_3
XFILLER_41_147 VGND VGND VPWR VPWR sky130_fd_sc_hd__decap_3
X_6939_ _7275_/CLK _6939_/D VGND VGND VPWR VPWR _6939_/Q sky130_fd_sc_hd__dfxtp_2
XFILLER_22_350 VGND VGND VPWR VPWR sky130_fd_sc_hd__fill_1
XFILLER_41_169 VGND VGND VPWR VPWR sky130_fd_sc_hd__decap_3
XFILLER_10_545 VGND VGND VPWR VPWR sky130_fd_sc_hd__decap_3
XFILLER_6_527 VGND VGND VPWR VPWR sky130_fd_sc_hd__decap_3
XFILLER_10_589 VGND VGND VPWR VPWR sky130_fd_sc_hd__fill_2
XFILLER_6_549 VGND VGND VPWR VPWR sky130_fd_sc_hd__decap_3
XTAP_TAPCELL_ROW_9_321 VGND VPWR sky130_fd_sc_hd__tapvpwrvgnd_1
XFILLER_49_203 VGND VGND VPWR VPWR sky130_fd_sc_hd__decap_3
XFILLER_103_182 VGND VGND VPWR VPWR sky130_fd_sc_hd__decap_3
XFILLER_2_27 VGND VGND VPWR VPWR sky130_fd_sc_hd__fill_1
XFILLER_49_225 VGND VGND VPWR VPWR sky130_fd_sc_hd__fill_1
XFILLER_49_236 VGND VGND VPWR VPWR sky130_fd_sc_hd__decap_3
XFILLER_17_111 VGND VGND VPWR VPWR sky130_fd_sc_hd__fill_1
XFILLER_64_239 VGND VGND VPWR VPWR sky130_fd_sc_hd__fill_1
XFILLER_45_453 VGND VGND VPWR VPWR sky130_fd_sc_hd__decap_3
XFILLER_17_177 VGND VGND VPWR VPWR sky130_fd_sc_hd__decap_3
XFILLER_45_497 VGND VGND VPWR VPWR sky130_fd_sc_hd__decap_3
XFILLER_20_309 VGND VGND VPWR VPWR sky130_fd_sc_hd__decap_3
XTAP_TAPCELL_ROW_43_676 VGND VPWR sky130_fd_sc_hd__tapvpwrvgnd_1
XFILLER_9_332 VGND VGND VPWR VPWR sky130_fd_sc_hd__decap_3
XTAP_TAPCELL_ROW_15_378 VGND VPWR sky130_fd_sc_hd__tapvpwrvgnd_1
XFILLER_9_387 VGND VGND VPWR VPWR sky130_fd_sc_hd__decap_3
XFILLER_49_3 VGND VGND VPWR VPWR sky130_fd_sc_hd__fill_1
XFILLER_99_169 VGND VGND VPWR VPWR sky130_fd_sc_hd__decap_3
X_4221_ _4219_/Y _4221_/A2 _4220_/X VGND VGND VPWR VPWR _4221_/X sky130_fd_sc_hd__a21o_2
Xhold2908 _7481_/Q VGND VGND VPWR VPWR _6636_/A0 sky130_fd_sc_hd__dlygate4sd3_1
Xhold2919 _7498_/Q VGND VGND VPWR VPWR _6672_/A0 sky130_fd_sc_hd__dlygate4sd3_1
X_4152_ _4152_/A _4152_/B VGND VGND VPWR VPWR _4152_/X sky130_fd_sc_hd__and2_2
XFILLER_28_409 VGND VGND VPWR VPWR sky130_fd_sc_hd__fill_2
X_4083_ _4083_/A _4084_/B VGND VGND VPWR VPWR _7608_/D sky130_fd_sc_hd__nor2_2
XFILLER_36_453 VGND VGND VPWR VPWR sky130_fd_sc_hd__fill_2
XFILLER_48_291 VGND VGND VPWR VPWR sky130_fd_sc_hd__decap_3
XFILLER_24_604 VGND VGND VPWR VPWR sky130_fd_sc_hd__decap_3
XFILLER_36_497 VGND VGND VPWR VPWR sky130_fd_sc_hd__decap_3
XFILLER_91_581 VGND VGND VPWR VPWR sky130_fd_sc_hd__fill_1
X_3936_ _4767_/B2 _5839_/B1 _7363_/Q _3936_/B1 _7555_/Q VGND VGND VPWR VPWR _3936_/X
+ sky130_fd_sc_hd__a32o_2
X_6655_ _6655_/A0 _6489_/X _6658_/S VGND VGND VPWR VPWR _7490_/D sky130_fd_sc_hd__mux2_2
X_3867_ _3864_/X _3867_/B _3867_/C VGND VGND VPWR VPWR _3867_/Y sky130_fd_sc_hd__nand3b_2
X_5606_ _5606_/A0 _5606_/A1 _5606_/S VGND VGND VPWR VPWR _7234_/D sky130_fd_sc_hd__mux2_2
X_3798_ _3995_/A1 _3898_/A2 _7372_/Q _3815_/B1 _7564_/Q VGND VGND VPWR VPWR _3798_/X
+ sky130_fd_sc_hd__a32o_2
XTAP_TAPCELL_ROW_98_1247 VGND VPWR sky130_fd_sc_hd__tapvpwrvgnd_1
XFILLER_3_508 VGND VGND VPWR VPWR sky130_fd_sc_hd__decap_3
X_5537_ _5537_/A0 _5720_/A1 _5545_/S VGND VGND VPWR VPWR _7202_/D sky130_fd_sc_hd__mux2_2
XFILLER_78_309 VGND VGND VPWR VPWR sky130_fd_sc_hd__fill_1
X_7207_ _7235_/CLK _7207_/D VGND VGND VPWR VPWR _7207_/Q sky130_fd_sc_hd__dfxtp_2
X_4419_ _4468_/C1 _4410_/X _4417_/X _4418_/X VGND VGND VPWR VPWR _7300_/D sky130_fd_sc_hd__o22a_2
X_7138_ _7509_/CLK _7138_/D VGND VGND VPWR VPWR _7138_/Q sky130_fd_sc_hd__dfxtp_2
XFILLER_74_504 VGND VGND VPWR VPWR sky130_fd_sc_hd__fill_2
X_7069_ _7490_/CLK _7069_/D VGND VGND VPWR VPWR _7069_/Q sky130_fd_sc_hd__dfxtp_2
XFILLER_46_217 VGND VGND VPWR VPWR sky130_fd_sc_hd__decap_3
XFILLER_74_548 VGND VGND VPWR VPWR sky130_fd_sc_hd__decap_3
XFILLER_27_453 VGND VGND VPWR VPWR sky130_fd_sc_hd__decap_3
XFILLER_27_464 VGND VGND VPWR VPWR sky130_fd_sc_hd__decap_3
XFILLER_27_486 VGND VGND VPWR VPWR sky130_fd_sc_hd__decap_3
XFILLER_36_77 VGND VGND VPWR VPWR sky130_fd_sc_hd__decap_3
XFILLER_52_32 VGND VGND VPWR VPWR sky130_fd_sc_hd__decap_3
XFILLER_10_331 VGND VGND VPWR VPWR sky130_fd_sc_hd__decap_3
XTAP_TAPCELL_ROW_40_646 VGND VPWR sky130_fd_sc_hd__tapvpwrvgnd_1
XTAP_TAPCELL_ROW_12_348 VGND VPWR sky130_fd_sc_hd__tapvpwrvgnd_1
XFILLER_6_324 VGND VGND VPWR VPWR sky130_fd_sc_hd__decap_3
XFILLER_6_357 VGND VGND VPWR VPWR sky130_fd_sc_hd__decap_3
XTAP_TAPCELL_ROW_75_1011 VGND VPWR sky130_fd_sc_hd__tapvpwrvgnd_1
XFILLER_2_530 VGND VGND VPWR VPWR sky130_fd_sc_hd__fill_2
XFILLER_2_574 VGND VGND VPWR VPWR sky130_fd_sc_hd__decap_3
XFILLER_77_51 VGND VGND VPWR VPWR sky130_fd_sc_hd__fill_1
XTAP_TAPCELL_ROW_48_724 VGND VPWR sky130_fd_sc_hd__tapvpwrvgnd_1
XFILLER_60_253 VGND VGND VPWR VPWR sky130_fd_sc_hd__decap_3
XFILLER_60_297 VGND VGND VPWR VPWR sky130_fd_sc_hd__fill_2
X_6440_ _4842_/B _6489_/A4 _4842_/C _6440_/B1 VGND VGND VPWR VPWR _6440_/X sky130_fd_sc_hd__a31o_2
X_3652_ _3652_/A _3652_/B _3652_/C VGND VGND VPWR VPWR _3652_/X sky130_fd_sc_hd__and3_2
X_6371_ _6371_/A1 _6412_/A2 _6412_/A3 _6411_/B1 _7401_/Q VGND VGND VPWR VPWR _6371_/X
+ sky130_fd_sc_hd__a32o_2
X_3583_ _3580_/Y _3564_/Y _3539_/Y VGND VGND VPWR VPWR _3583_/Y sky130_fd_sc_hd__a21oi_4
Xoutput2079 _4204_/X VGND VGND VPWR VPWR result[18] sky130_fd_sc_hd__dlymetal6s2s_1
Xhold2705 _7008_/Q VGND VGND VPWR VPWR _5085_/A0 sky130_fd_sc_hd__dlygate4sd3_1
XTAP_TAPCELL_ROW_93_1199 VGND VPWR sky130_fd_sc_hd__tapvpwrvgnd_1
Xhold2716 _7132_/Q VGND VGND VPWR VPWR _5385_/A0 sky130_fd_sc_hd__dlygate4sd3_1
Xhold2727 _6917_/Q VGND VGND VPWR VPWR _4881_/A0 sky130_fd_sc_hd__dlygate4sd3_1
Xhold2738 _6885_/Q VGND VGND VPWR VPWR _4811_/A0 sky130_fd_sc_hd__dlygate4sd3_1
X_5184_ _5184_/A0 _5334_/A1 _5207_/S VGND VGND VPWR VPWR _7053_/D sky130_fd_sc_hd__mux2_2
X_4204_ _6163_/A _4204_/B _4204_/C VGND VGND VPWR VPWR _4204_/X sky130_fd_sc_hd__and3_2
XFILLER_3_92 VGND VGND VPWR VPWR sky130_fd_sc_hd__fill_2
Xhold2749 _6889_/Q VGND VGND VPWR VPWR _4819_/A0 sky130_fd_sc_hd__dlygate4sd3_1
X_4135_ _6183_/A _6183_/B _4300_/A3 _4132_/X _4134_/Y VGND VGND VPWR VPWR _4135_/X
+ sky130_fd_sc_hd__o311a_2
XFILLER_28_206 VGND VGND VPWR VPWR sky130_fd_sc_hd__fill_1
XFILLER_28_217 VGND VGND VPWR VPWR sky130_fd_sc_hd__decap_3
X_4066_ _4532_/A _4066_/B VGND VGND VPWR VPWR _4068_/A sky130_fd_sc_hd__nor2_2
XFILLER_36_250 VGND VGND VPWR VPWR sky130_fd_sc_hd__fill_2
XFILLER_83_378 VGND VGND VPWR VPWR sky130_fd_sc_hd__decap_3
XFILLER_36_294 VGND VGND VPWR VPWR sky130_fd_sc_hd__decap_3
X_3919_ _3919_/A _3919_/B VGND VGND VPWR VPWR _4607_/B sky130_fd_sc_hd__nand2_4
XTAP_TAPCELL_ROW_102_1295 VGND VPWR sky130_fd_sc_hd__tapvpwrvgnd_1
XFILLER_22_57 VGND VGND VPWR VPWR sky130_fd_sc_hd__decap_3
X_6638_ _6638_/A0 _6223_/Y _6638_/S VGND VGND VPWR VPWR _7482_/D sky130_fd_sc_hd__mux2_2
XFILLER_3_327 VGND VGND VPWR VPWR sky130_fd_sc_hd__decap_3
X_6569_ _6569_/A0 _6223_/Y _6569_/S VGND VGND VPWR VPWR _7450_/D sky130_fd_sc_hd__mux2_2
XFILLER_19_217 VGND VGND VPWR VPWR sky130_fd_sc_hd__fill_2
XFILLER_59_375 VGND VGND VPWR VPWR sky130_fd_sc_hd__decap_3
XFILLER_15_401 VGND VGND VPWR VPWR sky130_fd_sc_hd__fill_2
XFILLER_42_242 VGND VGND VPWR VPWR sky130_fd_sc_hd__fill_2
XFILLER_42_264 VGND VGND VPWR VPWR sky130_fd_sc_hd__fill_2
XPHY_EDGE_ROW_69_Right_69 VGND VGND VPWR VPWR sky130_fd_sc_hd__decap_3
XFILLER_42_275 VGND VGND VPWR VPWR sky130_fd_sc_hd__decap_3
XTAP_TAPCELL_ROW_53_782 VGND VPWR sky130_fd_sc_hd__tapvpwrvgnd_1
XTAP_TAPCELL_ROW_25_484 VGND VPWR sky130_fd_sc_hd__tapvpwrvgnd_1
XTAP_TAPCELL_ROW_81_1070 VGND VPWR sky130_fd_sc_hd__tapvpwrvgnd_1
XFILLER_6_110 VGND VGND VPWR VPWR sky130_fd_sc_hd__decap_3
XPHY_EDGE_ROW_78_Right_78 VGND VGND VPWR VPWR sky130_fd_sc_hd__decap_3
XFILLER_88_83 VGND VGND VPWR VPWR sky130_fd_sc_hd__fill_1
XFILLER_38_504 VGND VGND VPWR VPWR sky130_fd_sc_hd__decap_3
XFILLER_38_548 VGND VGND VPWR VPWR sky130_fd_sc_hd__fill_1
XFILLER_65_334 VGND VGND VPWR VPWR sky130_fd_sc_hd__fill_2
XFILLER_53_529 VGND VGND VPWR VPWR sky130_fd_sc_hd__decap_3
XFILLER_65_367 VGND VGND VPWR VPWR sky130_fd_sc_hd__fill_1
X_5940_ _4735_/X _5892_/Y _5923_/X _4639_/Y _5939_/X VGND VGND VPWR VPWR _5940_/X
+ sky130_fd_sc_hd__o221a_2
XFILLER_18_283 VGND VGND VPWR VPWR sky130_fd_sc_hd__decap_3
XPHY_EDGE_ROW_87_Right_87 VGND VGND VPWR VPWR sky130_fd_sc_hd__decap_3
XFILLER_33_231 VGND VGND VPWR VPWR sky130_fd_sc_hd__decap_3
X_7610_ _7610_/CLK _7610_/D place2053/X VGND VGND VPWR VPWR _7610_/Q sky130_fd_sc_hd__dfrtp_2
XFILLER_33_264 VGND VGND VPWR VPWR sky130_fd_sc_hd__decap_3
XFILLER_33_297 VGND VGND VPWR VPWR sky130_fd_sc_hd__decap_3
X_7541_ _7542_/CLK _7541_/D place2047/X VGND VGND VPWR VPWR _7541_/Q sky130_fd_sc_hd__dfrtp_2
X_4753_ _4753_/A0 _5600_/A1 _4771_/S VGND VGND VPWR VPWR _6867_/D sky130_fd_sc_hd__mux2_2
X_7472_ _7608_/CLK _7472_/D place2056/X VGND VGND VPWR VPWR _7472_/Q sky130_fd_sc_hd__dfrtp_2
X_3704_ _7544_/Q _3812_/A2 _3812_/B1 _7480_/Q VGND VGND VPWR VPWR _3704_/X sky130_fd_sc_hd__a22o_2
X_4684_ _4684_/A1 _4726_/A2 _4726_/B1 VGND VGND VPWR VPWR _4684_/Y sky130_fd_sc_hd__o21ai_2
XTAP_TAPCELL_ROW_95_1217 VGND VPWR sky130_fd_sc_hd__tapvpwrvgnd_1
Xplace1811 _3547_/A VGND VGND VPWR VPWR _4396_/A sky130_fd_sc_hd__buf_2
Xplace1800 _4003_/A2 VGND VGND VPWR VPWR _3842_/B sky130_fd_sc_hd__buf_2
XPHY_EDGE_ROW_96_Right_96 VGND VGND VPWR VPWR sky130_fd_sc_hd__decap_3
Xplace1844 _3490_/C VGND VGND VPWR VPWR _3547_/D sky130_fd_sc_hd__buf_2
Xplace1833 _3995_/A1 VGND VGND VPWR VPWR _3842_/C sky130_fd_sc_hd__buf_2
Xplace1822 _3652_/A VGND VGND VPWR VPWR _6229_/A2 sky130_fd_sc_hd__buf_2
X_3566_ _5839_/A2 _3455_/A _3975_/B _3975_/C _3566_/D1 VGND VGND VPWR VPWR _3567_/B
+ sky130_fd_sc_hd__o2111ai_2
Xplace1888 _3482_/Y VGND VGND VPWR VPWR _4437_/A2 sky130_fd_sc_hd__buf_2
Xplace1877 _4613_/A2 VGND VGND VPWR VPWR _4503_/B sky130_fd_sc_hd__buf_2
Xplace1866 _3653_/A1 VGND VGND VPWR VPWR _6180_/A2 sky130_fd_sc_hd__buf_2
Xplace1855 _3457_/B1 VGND VGND VPWR VPWR _4014_/B1 sky130_fd_sc_hd__buf_2
X_3497_ _3444_/A _3480_/B _3497_/B1 _3463_/B _3462_/Y VGND VGND VPWR VPWR _3497_/Y
+ sky130_fd_sc_hd__o2111ai_4
Xplace1899 _3436_/Y VGND VGND VPWR VPWR _3505_/A2 sky130_fd_sc_hd__buf_6
Xhold2513 _6986_/Q VGND VGND VPWR VPWR _5038_/A0 sky130_fd_sc_hd__dlygate4sd3_1
Xhold2502 _6853_/Q VGND VGND VPWR VPWR _4652_/A0 sky130_fd_sc_hd__dlygate4sd3_1
Xhold2546 _7233_/Q VGND VGND VPWR VPWR _5604_/A0 sky130_fd_sc_hd__dlygate4sd3_1
Xhold2535 _7201_/Q VGND VGND VPWR VPWR _5535_/A0 sky130_fd_sc_hd__dlygate4sd3_1
Xhold2524 _6845_/Q VGND VGND VPWR VPWR _4593_/A0 sky130_fd_sc_hd__dlygate4sd3_1
XFILLER_56_323 VGND VGND VPWR VPWR sky130_fd_sc_hd__decap_3
Xhold2579 _7246_/Q VGND VGND VPWR VPWR _5633_/A0 sky130_fd_sc_hd__dlygate4sd3_1
Xhold2568 _7157_/Q VGND VGND VPWR VPWR _5440_/A0 sky130_fd_sc_hd__dlygate4sd3_1
Xhold2557 _7199_/Q VGND VGND VPWR VPWR _5530_/A0 sky130_fd_sc_hd__dlygate4sd3_1
X_5167_ _5167_/A0 _5317_/A1 _5179_/S VGND VGND VPWR VPWR _7045_/D sky130_fd_sc_hd__mux2_2
X_4118_ _6088_/A _3802_/C _4579_/D _4117_/X VGND VGND VPWR VPWR _4119_/A sky130_fd_sc_hd__o211ai_4
XFILLER_16_209 VGND VGND VPWR VPWR sky130_fd_sc_hd__decap_3
XFILLER_17_24 VGND VGND VPWR VPWR sky130_fd_sc_hd__fill_2
X_4049_ _4051_/B _4049_/B VGND VGND VPWR VPWR _7595_/D sky130_fd_sc_hd__nor2_2
XFILLER_17_79 VGND VGND VPWR VPWR sky130_fd_sc_hd__decap_3
XFILLER_71_337 VGND VGND VPWR VPWR sky130_fd_sc_hd__decap_3
XFILLER_24_253 VGND VGND VPWR VPWR sky130_fd_sc_hd__decap_3
XFILLER_24_286 VGND VGND VPWR VPWR sky130_fd_sc_hd__decap_3
XFILLER_52_573 VGND VGND VPWR VPWR sky130_fd_sc_hd__fill_1
XTAP_TAPCELL_ROW_50_752 VGND VPWR sky130_fd_sc_hd__tapvpwrvgnd_1
XTAP_TAPCELL_ROW_22_454 VGND VPWR sky130_fd_sc_hd__tapvpwrvgnd_1
XFILLER_3_113 VGND VGND VPWR VPWR sky130_fd_sc_hd__decap_3
XFILLER_3_157 VGND VGND VPWR VPWR sky130_fd_sc_hd__decap_3
XFILLER_59_150 VGND VGND VPWR VPWR sky130_fd_sc_hd__fill_1
XFILLER_59_194 VGND VGND VPWR VPWR sky130_fd_sc_hd__decap_3
XTAP_TAPCELL_ROW_58_830 VGND VPWR sky130_fd_sc_hd__tapvpwrvgnd_1
XFILLER_15_220 VGND VGND VPWR VPWR sky130_fd_sc_hd__decap_3
XFILLER_62_337 VGND VGND VPWR VPWR sky130_fd_sc_hd__decap_3
XFILLER_74_85 VGND VGND VPWR VPWR sky130_fd_sc_hd__fill_2
XFILLER_30_223 VGND VGND VPWR VPWR sky130_fd_sc_hd__fill_1
XFILLER_90_73 VGND VGND VPWR VPWR sky130_fd_sc_hd__fill_2
XFILLER_30_256 VGND VGND VPWR VPWR sky130_fd_sc_hd__decap_3
XFILLER_90_95 VGND VGND VPWR VPWR sky130_fd_sc_hd__fill_2
Xplace1107 _4763_/Y VGND VGND VPWR VPWR _5296_/A1 sky130_fd_sc_hd__buf_2
Xplace1118 _4721_/X VGND VGND VPWR VPWR _5713_/A1 sky130_fd_sc_hd__buf_2
Xplace1129 _5698_/A1 VGND VGND VPWR VPWR _5637_/A1 sky130_fd_sc_hd__buf_2
Xrebuffer2119 _3444_/A VGND VGND VPWR VPWR _3412_/A1 sky130_fd_sc_hd__buf_2
XFILLER_31_3 VGND VGND VPWR VPWR sky130_fd_sc_hd__decap_3
X_6070_ _6505_/B1 _6070_/A2 _6066_/X _6069_/X VGND VGND VPWR VPWR _6070_/X sky130_fd_sc_hd__o31a_2
XTAP_TAPCELL_ROW_90_1169 VGND VPWR sky130_fd_sc_hd__tapvpwrvgnd_1
XFILLER_38_301 VGND VGND VPWR VPWR sky130_fd_sc_hd__decap_3
X_6972_ _7280_/CLK _6972_/D VGND VGND VPWR VPWR _6972_/Q sky130_fd_sc_hd__dfxtp_2
X_5923_ _5979_/A _5923_/A2_N _5922_/Y _4629_/S VGND VGND VPWR VPWR _5923_/X sky130_fd_sc_hd__o2bb2a_2
X_5854_ _4637_/A _6489_/A1 _4637_/B _6495_/A2 _6440_/B1 VGND VGND VPWR VPWR _5854_/X
+ sky130_fd_sc_hd__a41o_2
XTAP_TAPCELL_ROW_64_899 VGND VPWR sky130_fd_sc_hd__tapvpwrvgnd_1
XFILLER_21_223 VGND VGND VPWR VPWR sky130_fd_sc_hd__fill_1
XFILLER_21_278 VGND VGND VPWR VPWR sky130_fd_sc_hd__fill_2
X_7524_ clkload5/A _7524_/D place2062/X VGND VGND VPWR VPWR _7524_/Q sky130_fd_sc_hd__dfrtp_2
X_7455_ clkload7/A _7455_/D place2027/X VGND VGND VPWR VPWR _7455_/Q sky130_fd_sc_hd__dfrtp_2
X_4667_ _4667_/A VGND VGND VPWR VPWR _4667_/Y sky130_fd_sc_hd__inv_2
X_7386_ _7514_/CLK _7386_/D place2040/X VGND VGND VPWR VPWR _7386_/Q sky130_fd_sc_hd__dfrtp_2
X_6406_ _6389_/Y _6404_/X _6406_/A3 _6405_/Y VGND VGND VPWR VPWR _6406_/Y sky130_fd_sc_hd__a31oi_2
Xplace1630 _3858_/B1 VGND VGND VPWR VPWR _3810_/B1 sky130_fd_sc_hd__buf_2
Xplace1641 _3816_/B1 VGND VGND VPWR VPWR _3733_/A2 sky130_fd_sc_hd__buf_2
Xplace1652 _6331_/A2 VGND VGND VPWR VPWR _6344_/A2 sky130_fd_sc_hd__buf_2
Xplace1663 _3838_/A2 VGND VGND VPWR VPWR _3828_/B2 sky130_fd_sc_hd__buf_2
XFILLER_88_234 VGND VGND VPWR VPWR sky130_fd_sc_hd__fill_2
Xhold3000 _6412_/X VGND VGND VPWR VPWR _7419_/D sky130_fd_sc_hd__dlygate4sd3_1
Xhold3011 _7534_/Q VGND VGND VPWR VPWR _6748_/A1 sky130_fd_sc_hd__dlygate4sd3_1
Xhold3022 _7447_/Q VGND VGND VPWR VPWR _6557_/A0 sky130_fd_sc_hd__dlygate4sd3_1
Xhold3033 _6387_/X VGND VGND VPWR VPWR _7413_/D sky130_fd_sc_hd__dlygate4sd3_1
Xplace1674 _3527_/Y VGND VGND VPWR VPWR place1674/X sky130_fd_sc_hd__buf_6
Xplace1685 _3990_/A1 VGND VGND VPWR VPWR _6376_/A2 sky130_fd_sc_hd__buf_2
Xplace1696 _3581_/Y VGND VGND VPWR VPWR _3582_/A sky130_fd_sc_hd__buf_2
X_3549_ _3549_/A _3549_/B _3549_/C _3549_/D VGND VGND VPWR VPWR _3549_/Y sky130_fd_sc_hd__nand4_2
XFILLER_0_138 VGND VGND VPWR VPWR sky130_fd_sc_hd__fill_2
Xhold3044 _7394_/Q VGND VGND VPWR VPWR _6312_/A1 sky130_fd_sc_hd__dlygate4sd3_1
XFILLER_48_109 VGND VGND VPWR VPWR sky130_fd_sc_hd__decap_3
X_6199_ _6088_/A _6183_/C _6198_/X _6547_/B1 VGND VGND VPWR VPWR _6199_/X sky130_fd_sc_hd__o31a_2
XFILLER_29_323 VGND VGND VPWR VPWR sky130_fd_sc_hd__decap_3
Xhold2398 _7005_/Q VGND VGND VPWR VPWR _5079_/A0 sky130_fd_sc_hd__dlygate4sd3_1
Xhold2387 _7204_/Q VGND VGND VPWR VPWR _5541_/A0 sky130_fd_sc_hd__dlygate4sd3_1
Xhold2376 _6901_/Q VGND VGND VPWR VPWR _4847_/A0 sky130_fd_sc_hd__dlygate4sd3_1
XFILLER_17_529 VGND VGND VPWR VPWR sky130_fd_sc_hd__decap_3
XFILLER_29_356 VGND VGND VPWR VPWR sky130_fd_sc_hd__decap_3
XFILLER_56_153 VGND VGND VPWR VPWR sky130_fd_sc_hd__decap_3
XTAP_TAPCELL_ROW_55_800 VGND VPWR sky130_fd_sc_hd__tapvpwrvgnd_1
XFILLER_44_315 VGND VGND VPWR VPWR sky130_fd_sc_hd__decap_3
XFILLER_56_186 VGND VGND VPWR VPWR sky130_fd_sc_hd__decap_3
XFILLER_56_197 VGND VGND VPWR VPWR sky130_fd_sc_hd__decap_3
XTAP_TAPCELL_ROW_27_502 VGND VPWR sky130_fd_sc_hd__tapvpwrvgnd_1
XFILLER_25_551 VGND VGND VPWR VPWR sky130_fd_sc_hd__decap_3
XFILLER_25_573 VGND VGND VPWR VPWR sky130_fd_sc_hd__decap_3
XFILLER_12_245 VGND VGND VPWR VPWR sky130_fd_sc_hd__decap_3
XFILLER_44_88 VGND VGND VPWR VPWR sky130_fd_sc_hd__decap_3
XTAP_TAPCELL_ROW_35_590 VGND VPWR sky130_fd_sc_hd__tapvpwrvgnd_1
XFILLER_12_256 VGND VGND VPWR VPWR sky130_fd_sc_hd__decap_3
XFILLER_4_477 VGND VGND VPWR VPWR sky130_fd_sc_hd__decap_3
XFILLER_69_52 VGND VGND VPWR VPWR sky130_fd_sc_hd__decap_3
XFILLER_79_223 VGND VGND VPWR VPWR sky130_fd_sc_hd__fill_1
XTAP_TAPCELL_ROW_7_293 VGND VPWR sky130_fd_sc_hd__tapvpwrvgnd_1
XFILLER_35_315 VGND VGND VPWR VPWR sky130_fd_sc_hd__decap_3
XFILLER_47_175 VGND VGND VPWR VPWR sky130_fd_sc_hd__decap_3
XFILLER_90_410 VGND VGND VPWR VPWR sky130_fd_sc_hd__fill_2
XFILLER_90_421 VGND VGND VPWR VPWR sky130_fd_sc_hd__fill_1
XFILLER_16_551 VGND VGND VPWR VPWR sky130_fd_sc_hd__fill_2
XFILLER_35_348 VGND VGND VPWR VPWR sky130_fd_sc_hd__decap_3
XFILLER_62_145 VGND VGND VPWR VPWR sky130_fd_sc_hd__decap_3
XFILLER_16_562 VGND VGND VPWR VPWR sky130_fd_sc_hd__decap_3
XFILLER_62_167 VGND VGND VPWR VPWR sky130_fd_sc_hd__decap_3
XFILLER_31_532 VGND VGND VPWR VPWR sky130_fd_sc_hd__decap_3
XFILLER_79_3 VGND VGND VPWR VPWR sky130_fd_sc_hd__decap_3
X_5570_ _5570_/A0 _5570_/A1 _5608_/S VGND VGND VPWR VPWR _7217_/D sky130_fd_sc_hd__mux2_2
XFILLER_7_260 VGND VGND VPWR VPWR sky130_fd_sc_hd__decap_3
X_4521_ _4533_/A _4533_/D _4519_/X _4520_/Y VGND VGND VPWR VPWR _4521_/X sky130_fd_sc_hd__a2bb2o_2
X_7240_ _7264_/CLK _7240_/D VGND VGND VPWR VPWR _7240_/Q sky130_fd_sc_hd__dfxtp_2
X_4452_ _4447_/X _4450_/Y _4452_/S VGND VGND VPWR VPWR _7303_/D sky130_fd_sc_hd__mux2_2
X_7171_ _7235_/CLK _7171_/D VGND VGND VPWR VPWR _7171_/Q sky130_fd_sc_hd__dfxtp_2
X_4383_ _4503_/A _4503_/B _4503_/C _7299_/Q VGND VGND VPWR VPWR _4416_/B sky130_fd_sc_hd__or4b_2
X_6122_ _6116_/X _6395_/B1 _6392_/A _6118_/X _6121_/X VGND VGND VPWR VPWR _6122_/X
+ sky130_fd_sc_hd__o221a_2
XFILLER_39_610 VGND VGND VPWR VPWR sky130_fd_sc_hd__fill_2
X_6053_ _7188_/Q _6468_/A2 _7216_/Q _6484_/B2 VGND VGND VPWR VPWR _6053_/X sky130_fd_sc_hd__o22a_2
XTAP_TAPCELL_ROW_69_947 VGND VPWR sky130_fd_sc_hd__tapvpwrvgnd_1
XFILLER_26_315 VGND VGND VPWR VPWR sky130_fd_sc_hd__decap_3
XFILLER_38_197 VGND VGND VPWR VPWR sky130_fd_sc_hd__decap_3
XFILLER_93_281 VGND VGND VPWR VPWR sky130_fd_sc_hd__fill_1
XFILLER_26_348 VGND VGND VPWR VPWR sky130_fd_sc_hd__decap_3
X_6955_ _7565_/CLK _6955_/D VGND VGND VPWR VPWR _6955_/Q sky130_fd_sc_hd__dfxtp_2
XFILLER_22_510 VGND VGND VPWR VPWR sky130_fd_sc_hd__decap_3
X_5906_ _6139_/A1 _6890_/Q _7282_/Q _6397_/B2 VGND VGND VPWR VPWR _5906_/X sky130_fd_sc_hd__o22a_2
X_6886_ _7509_/CLK _6886_/D VGND VGND VPWR VPWR _6886_/Q sky130_fd_sc_hd__dfxtp_2
XFILLER_14_47 VGND VGND VPWR VPWR sky130_fd_sc_hd__fill_1
XFILLER_22_587 VGND VGND VPWR VPWR sky130_fd_sc_hd__fill_1
X_5837_ _7236_/Q _5610_/B _5549_/B _6900_/Q VGND VGND VPWR VPWR _5837_/X sky130_fd_sc_hd__a22o_2
XTAP_TAPCELL_ROW_32_560 VGND VPWR sky130_fd_sc_hd__tapvpwrvgnd_1
X_7507_ _7507_/CLK _7507_/D place2038/X VGND VGND VPWR VPWR _7507_/Q sky130_fd_sc_hd__dfrtp_2
X_4719_ _4719_/A1 _4726_/A2 _4719_/B1 VGND VGND VPWR VPWR _4719_/Y sky130_fd_sc_hd__o21ai_2
XFILLER_30_24 VGND VGND VPWR VPWR sky130_fd_sc_hd__decap_3
X_7438_ _7610_/CLK _7438_/D place2056/X VGND VGND VPWR VPWR _7438_/Q sky130_fd_sc_hd__dfrtp_2
XFILLER_100_6 VGND VGND VPWR VPWR sky130_fd_sc_hd__decap_3
XFILLER_30_57 VGND VGND VPWR VPWR sky130_fd_sc_hd__decap_3
Xplace1460 place1460/A VGND VGND VPWR VPWR _4298_/A1 sky130_fd_sc_hd__buf_2
Xplace1471 _6404_/B1 VGND VGND VPWR VPWR _6489_/A4 sky130_fd_sc_hd__buf_2
X_7369_ clkload8/A _7369_/D place2034/X VGND VGND VPWR VPWR _7369_/Q sky130_fd_sc_hd__dfrtp_2
XFILLER_1_447 VGND VGND VPWR VPWR sky130_fd_sc_hd__fill_1
XFILLER_89_554 VGND VGND VPWR VPWR sky130_fd_sc_hd__decap_3
Xplace1482 _5162_/A1 VGND VGND VPWR VPWR _5312_/A1 sky130_fd_sc_hd__buf_2
Xplace1493 _3915_/C VGND VGND VPWR VPWR _4641_/A1 sky130_fd_sc_hd__buf_2
XTAP_TAPCELL_ROW_4_263 VGND VPWR sky130_fd_sc_hd__tapvpwrvgnd_1
XFILLER_17_337 VGND VGND VPWR VPWR sky130_fd_sc_hd__decap_3
XFILLER_72_421 VGND VGND VPWR VPWR sky130_fd_sc_hd__decap_3
XFILLER_55_54 VGND VGND VPWR VPWR sky130_fd_sc_hd__fill_2
XFILLER_55_76 VGND VGND VPWR VPWR sky130_fd_sc_hd__decap_3
XFILLER_32_307 VGND VGND VPWR VPWR sky130_fd_sc_hd__fill_1
XFILLER_32_329 VGND VGND VPWR VPWR sky130_fd_sc_hd__decap_3
XFILLER_9_514 VGND VGND VPWR VPWR sky130_fd_sc_hd__decap_3
XFILLER_9_558 VGND VGND VPWR VPWR sky130_fd_sc_hd__fill_2
XTAP_TAPCELL_ROW_78_1042 VGND VPWR sky130_fd_sc_hd__tapvpwrvgnd_1
XFILLER_0_480 VGND VGND VPWR VPWR sky130_fd_sc_hd__fill_1
XFILLER_96_72 VGND VGND VPWR VPWR sky130_fd_sc_hd__decap_3
XFILLER_48_462 VGND VGND VPWR VPWR sky130_fd_sc_hd__fill_2
XTAP_TAPCELL_ROW_66_917 VGND VPWR sky130_fd_sc_hd__tapvpwrvgnd_1
XTAP_TAPCELL_ROW_38_619 VGND VPWR sky130_fd_sc_hd__tapvpwrvgnd_1
XTAP_TAPCELL_ROW_89_1160 VGND VPWR sky130_fd_sc_hd__tapvpwrvgnd_1
XFILLER_23_318 VGND VGND VPWR VPWR sky130_fd_sc_hd__decap_3
XFILLER_35_178 VGND VGND VPWR VPWR sky130_fd_sc_hd__decap_3
XFILLER_50_104 VGND VGND VPWR VPWR sky130_fd_sc_hd__decap_3
XFILLER_50_148 VGND VGND VPWR VPWR sky130_fd_sc_hd__decap_3
X_3952_ _3952_/A1 _4003_/A2 _7359_/Q _4312_/B _7551_/Q VGND VGND VPWR VPWR _3952_/X
+ sky130_fd_sc_hd__a32o_2
XFILLER_31_340 VGND VGND VPWR VPWR sky130_fd_sc_hd__fill_1
XFILLER_31_362 VGND VGND VPWR VPWR sky130_fd_sc_hd__decap_3
X_3883_ _7302_/Q _3920_/B _3882_/Y VGND VGND VPWR VPWR _3885_/A sky130_fd_sc_hd__a21oi_2
X_5553_ _5553_/A0 _5614_/A1 _5574_/S VGND VGND VPWR VPWR _7209_/D sky130_fd_sc_hd__mux2_2
X_4504_ _7310_/Q _4478_/B _4495_/X _4482_/B VGND VGND VPWR VPWR _4506_/B sky130_fd_sc_hd__a31o_2
X_5484_ _5484_/A0 _5606_/A1 _5486_/S VGND VGND VPWR VPWR _7178_/D sky130_fd_sc_hd__mux2_2
XFILLER_6_92 VGND VGND VPWR VPWR sky130_fd_sc_hd__decap_3
X_7223_ _7282_/CLK _7223_/D VGND VGND VPWR VPWR _7223_/Q sky130_fd_sc_hd__dfxtp_2
X_4435_ _4561_/A1 _4470_/A3 _4435_/B1 VGND VGND VPWR VPWR _4460_/A sky130_fd_sc_hd__a21oi_2
X_7154_ _7266_/CLK _7154_/D VGND VGND VPWR VPWR _7154_/Q sky130_fd_sc_hd__dfxtp_2
X_4366_ _4366_/A1 _5732_/S _4365_/X VGND VGND VPWR VPWR _7297_/D sky130_fd_sc_hd__a21o_2
XFILLER_58_215 VGND VGND VPWR VPWR sky130_fd_sc_hd__decap_3
XFILLER_98_362 VGND VGND VPWR VPWR sky130_fd_sc_hd__fill_2
XFILLER_100_334 VGND VGND VPWR VPWR sky130_fd_sc_hd__decap_3
X_7085_ _7114_/CLK _7085_/D VGND VGND VPWR VPWR _7085_/Q sky130_fd_sc_hd__dfxtp_2
X_4297_ _4297_/A _4297_/B _4297_/C _4297_/D VGND VGND VPWR VPWR _4297_/X sky130_fd_sc_hd__or4_2
XFILLER_58_259 VGND VGND VPWR VPWR sky130_fd_sc_hd__decap_3
XFILLER_86_568 VGND VGND VPWR VPWR sky130_fd_sc_hd__decap_3
X_6036_ _6505_/B1 _6070_/A2 _6032_/X _6035_/X VGND VGND VPWR VPWR _6036_/X sky130_fd_sc_hd__o31a_2
XFILLER_26_101 VGND VGND VPWR VPWR sky130_fd_sc_hd__decap_3
XFILLER_39_484 VGND VGND VPWR VPWR sky130_fd_sc_hd__decap_3
XFILLER_54_421 VGND VGND VPWR VPWR sky130_fd_sc_hd__decap_3
XTAP_TAPCELL_ROW_1_233 VGND VPWR sky130_fd_sc_hd__tapvpwrvgnd_1
XFILLER_26_123 VGND VGND VPWR VPWR sky130_fd_sc_hd__fill_2
XFILLER_54_432 VGND VGND VPWR VPWR sky130_fd_sc_hd__decap_3
XFILLER_54_454 VGND VGND VPWR VPWR sky130_fd_sc_hd__fill_1
XFILLER_14_307 VGND VGND VPWR VPWR sky130_fd_sc_hd__fill_1
XFILLER_25_24 VGND VGND VPWR VPWR sky130_fd_sc_hd__decap_3
XFILLER_54_498 VGND VGND VPWR VPWR sky130_fd_sc_hd__decap_3
XFILLER_81_262 VGND VGND VPWR VPWR sky130_fd_sc_hd__fill_1
X_6938_ _7247_/CLK _6938_/D VGND VGND VPWR VPWR _6938_/Q sky130_fd_sc_hd__dfxtp_2
XFILLER_41_159 VGND VGND VPWR VPWR sky130_fd_sc_hd__decap_3
X_6869_ _7289_/CLK _6869_/D VGND VGND VPWR VPWR _6869_/Q sky130_fd_sc_hd__dfxtp_2
XFILLER_6_506 VGND VGND VPWR VPWR sky130_fd_sc_hd__decap_3
XTAP_TAPCELL_ROW_9_322 VGND VPWR sky130_fd_sc_hd__tapvpwrvgnd_1
XFILLER_9_3 VGND VGND VPWR VPWR sky130_fd_sc_hd__decap_3
XFILLER_1_277 VGND VGND VPWR VPWR sky130_fd_sc_hd__decap_3
Xplace1290 _5905_/B2 VGND VGND VPWR VPWR _6154_/B2 sky130_fd_sc_hd__buf_2
XFILLER_103_172 VGND VGND VPWR VPWR sky130_fd_sc_hd__fill_1
XFILLER_49_215 VGND VGND VPWR VPWR sky130_fd_sc_hd__fill_1
XFILLER_64_207 VGND VGND VPWR VPWR sky130_fd_sc_hd__decap_3
XFILLER_57_281 VGND VGND VPWR VPWR sky130_fd_sc_hd__fill_2
XFILLER_17_123 VGND VGND VPWR VPWR sky130_fd_sc_hd__decap_3
XFILLER_17_189 VGND VGND VPWR VPWR sky130_fd_sc_hd__decap_3
XFILLER_32_137 VGND VGND VPWR VPWR sky130_fd_sc_hd__decap_3
XFILLER_60_457 VGND VGND VPWR VPWR sky130_fd_sc_hd__decap_3
XFILLER_82_85 VGND VGND VPWR VPWR sky130_fd_sc_hd__decap_3
XTAP_TAPCELL_ROW_71_964 VGND VPWR sky130_fd_sc_hd__tapvpwrvgnd_1
XTAP_TAPCELL_ROW_43_677 VGND VPWR sky130_fd_sc_hd__tapvpwrvgnd_1
XFILLER_15_90 VGND VGND VPWR VPWR sky130_fd_sc_hd__decap_3
XTAP_TAPCELL_ROW_15_379 VGND VPWR sky130_fd_sc_hd__tapvpwrvgnd_1
XFILLER_40_181 VGND VGND VPWR VPWR sky130_fd_sc_hd__fill_1
XFILLER_5_561 VGND VGND VPWR VPWR sky130_fd_sc_hd__decap_3
X_4220_ _4220_/A _4220_/B VGND VGND VPWR VPWR _4220_/X sky130_fd_sc_hd__or2_2
Xhold2909 _7545_/Q VGND VGND VPWR VPWR _6771_/A1 sky130_fd_sc_hd__dlygate4sd3_1
X_4151_ _4151_/A _4151_/B _4151_/C VGND VGND VPWR VPWR _4154_/B sky130_fd_sc_hd__and3_2
XFILLER_55_207 VGND VGND VPWR VPWR sky130_fd_sc_hd__decap_3
X_4082_ _4542_/B _4548_/A _4085_/D VGND VGND VPWR VPWR _4084_/B sky130_fd_sc_hd__and3_2
XFILLER_102_29 VGND VGND VPWR VPWR sky130_fd_sc_hd__decap_3
XFILLER_51_413 VGND VGND VPWR VPWR sky130_fd_sc_hd__fill_1
XFILLER_63_251 VGND VGND VPWR VPWR sky130_fd_sc_hd__decap_3
X_4984_ _4984_/A0 _5317_/A1 _4994_/S VGND VGND VPWR VPWR _6961_/D sky130_fd_sc_hd__mux2_2
XFILLER_23_148 VGND VGND VPWR VPWR sky130_fd_sc_hd__decap_3
XFILLER_23_159 VGND VGND VPWR VPWR sky130_fd_sc_hd__decap_3
X_3935_ _3935_/A _3935_/B VGND VGND VPWR VPWR _3935_/Y sky130_fd_sc_hd__nand2_2
X_3866_ _7465_/Q _3908_/B1 _3993_/B1 _7401_/Q VGND VGND VPWR VPWR _3867_/C sky130_fd_sc_hd__a22oi_2
X_6585_ _6585_/A0 _5943_/X _6590_/S VGND VGND VPWR VPWR _7457_/D sky130_fd_sc_hd__mux2_2
X_3797_ _3698_/B _4237_/C _3790_/Y _3794_/Y _3796_/Y VGND VGND VPWR VPWR _3797_/Y
+ sky130_fd_sc_hd__o41ai_2
XTAP_TAPCELL_ROW_98_1248 VGND VPWR sky130_fd_sc_hd__tapvpwrvgnd_1
X_5467_ _5467_/A0 _5711_/A1 _5471_/S VGND VGND VPWR VPWR _7170_/D sky130_fd_sc_hd__mux2_2
X_7206_ _7289_/CLK _7206_/D VGND VGND VPWR VPWR _7206_/Q sky130_fd_sc_hd__dfxtp_2
X_4418_ _7590_/D _4388_/S _4452_/S VGND VGND VPWR VPWR _4418_/X sky130_fd_sc_hd__a21o_2
X_5398_ _5398_/A0 _5703_/A1 _5410_/S VGND VGND VPWR VPWR _7138_/D sky130_fd_sc_hd__mux2_2
X_7137_ _7282_/CLK _7137_/D VGND VGND VPWR VPWR _7137_/Q sky130_fd_sc_hd__dfxtp_2
X_4349_ _4388_/S _4346_/Y _4348_/X _3561_/B VGND VGND VPWR VPWR _4349_/X sky130_fd_sc_hd__o211a_2
XFILLER_59_557 VGND VGND VPWR VPWR sky130_fd_sc_hd__decap_3
XFILLER_86_365 VGND VGND VPWR VPWR sky130_fd_sc_hd__decap_3
X_7068_ _7490_/CLK _7068_/D VGND VGND VPWR VPWR _7068_/Q sky130_fd_sc_hd__dfxtp_2
XFILLER_39_270 VGND VGND VPWR VPWR sky130_fd_sc_hd__decap_3
XFILLER_46_207 VGND VGND VPWR VPWR sky130_fd_sc_hd__fill_1
XFILLER_100_197 VGND VGND VPWR VPWR sky130_fd_sc_hd__decap_3
XFILLER_27_432 VGND VGND VPWR VPWR sky130_fd_sc_hd__decap_3
XFILLER_39_281 VGND VGND VPWR VPWR sky130_fd_sc_hd__decap_3
XFILLER_42_402 VGND VGND VPWR VPWR sky130_fd_sc_hd__decap_3
XFILLER_54_240 VGND VGND VPWR VPWR sky130_fd_sc_hd__decap_3
XFILLER_14_137 VGND VGND VPWR VPWR sky130_fd_sc_hd__decap_3
XFILLER_14_148 VGND VGND VPWR VPWR sky130_fd_sc_hd__decap_3
XFILLER_22_170 VGND VGND VPWR VPWR sky130_fd_sc_hd__fill_2
XFILLER_10_321 VGND VGND VPWR VPWR sky130_fd_sc_hd__fill_1
XFILLER_22_192 VGND VGND VPWR VPWR sky130_fd_sc_hd__decap_3
XTAP_TAPCELL_ROW_40_647 VGND VPWR sky130_fd_sc_hd__tapvpwrvgnd_1
XTAP_TAPCELL_ROW_12_349 VGND VPWR sky130_fd_sc_hd__tapvpwrvgnd_1
XTAP_TAPCELL_ROW_75_1012 VGND VPWR sky130_fd_sc_hd__tapvpwrvgnd_1
XFILLER_2_542 VGND VGND VPWR VPWR sky130_fd_sc_hd__fill_2
XFILLER_77_354 VGND VGND VPWR VPWR sky130_fd_sc_hd__fill_1
XTAP_TAPCELL_ROW_48_725 VGND VPWR sky130_fd_sc_hd__tapvpwrvgnd_1
XFILLER_18_421 VGND VGND VPWR VPWR sky130_fd_sc_hd__fill_1
XTAP_TAPCELL_ROW_86_1130 VGND VPWR sky130_fd_sc_hd__tapvpwrvgnd_1
XFILLER_45_240 VGND VGND VPWR VPWR sky130_fd_sc_hd__decap_3
XFILLER_45_251 VGND VGND VPWR VPWR sky130_fd_sc_hd__decap_3
XFILLER_45_284 VGND VGND VPWR VPWR sky130_fd_sc_hd__decap_3
XFILLER_60_243 VGND VGND VPWR VPWR sky130_fd_sc_hd__decap_3
XFILLER_60_265 VGND VGND VPWR VPWR sky130_fd_sc_hd__decap_3
XFILLER_20_107 VGND VGND VPWR VPWR sky130_fd_sc_hd__decap_3
XFILLER_20_129 VGND VGND VPWR VPWR sky130_fd_sc_hd__decap_3
XFILLER_13_192 VGND VGND VPWR VPWR sky130_fd_sc_hd__decap_3
Xclkbuf_leaf_40_clk clkbuf_leaf_0_clk/A VGND VGND VPWR VPWR _7611_/CLK sky130_fd_sc_hd__clkbuf_16
XFILLER_9_163 VGND VGND VPWR VPWR sky130_fd_sc_hd__decap_3
XFILLER_9_185 VGND VGND VPWR VPWR sky130_fd_sc_hd__decap_3
X_3651_ _4249_/A _4249_/B VGND VGND VPWR VPWR _3742_/D sky130_fd_sc_hd__and2_4
X_6370_ _6668_/A0 _6412_/A2 _6412_/A3 _6412_/B1 _7400_/Q VGND VGND VPWR VPWR _6370_/X
+ sky130_fd_sc_hd__a32o_2
X_3582_ _3582_/A _3802_/C VGND VGND VPWR VPWR _3582_/Y sky130_fd_sc_hd__nor2_2
X_5321_ _5321_/A0 _5566_/A1 _5361_/S VGND VGND VPWR VPWR _7103_/D sky130_fd_sc_hd__mux2_2
XFILLER_5_391 VGND VGND VPWR VPWR sky130_fd_sc_hd__fill_1
XFILLER_87_107 VGND VGND VPWR VPWR sky130_fd_sc_hd__fill_1
X_5252_ _5252_/A0 _5696_/A1 _5255_/S VGND VGND VPWR VPWR _7079_/D sky130_fd_sc_hd__mux2_2
Xhold2706 _7130_/Q VGND VGND VPWR VPWR _5381_/A0 sky130_fd_sc_hd__dlygate4sd3_1
Xhold2717 _7223_/Q VGND VGND VPWR VPWR _5583_/A0 sky130_fd_sc_hd__dlygate4sd3_1
Xhold2728 _6952_/Q VGND VGND VPWR VPWR _4958_/A0 sky130_fd_sc_hd__dlygate4sd3_1
X_4203_ _4202_/B _4202_/C _4202_/A VGND VGND VPWR VPWR _4204_/C sky130_fd_sc_hd__o21ai_2
Xhold2739 _7102_/Q VGND VGND VPWR VPWR _5319_/A0 sky130_fd_sc_hd__dlygate4sd3_1
X_4134_ _4134_/A _4134_/B VGND VGND VPWR VPWR _4134_/Y sky130_fd_sc_hd__nand2_2
XFILLER_28_229 VGND VGND VPWR VPWR sky130_fd_sc_hd__decap_3
XFILLER_68_376 VGND VGND VPWR VPWR sky130_fd_sc_hd__fill_1
X_4065_ _4065_/A _4066_/B VGND VGND VPWR VPWR _7602_/D sky130_fd_sc_hd__nor2_2
XFILLER_36_240 VGND VGND VPWR VPWR sky130_fd_sc_hd__fill_2
XFILLER_64_560 VGND VGND VPWR VPWR sky130_fd_sc_hd__fill_2
XFILLER_24_413 VGND VGND VPWR VPWR sky130_fd_sc_hd__decap_3
XFILLER_24_424 VGND VGND VPWR VPWR sky130_fd_sc_hd__decap_3
XFILLER_11_129 VGND VGND VPWR VPWR sky130_fd_sc_hd__decap_3
XFILLER_51_287 VGND VGND VPWR VPWR sky130_fd_sc_hd__decap_3
XFILLER_22_25 VGND VGND VPWR VPWR sky130_fd_sc_hd__decap_3
Xclkbuf_leaf_31_clk clkload0/A VGND VGND VPWR VPWR _7577_/CLK sky130_fd_sc_hd__clkbuf_16
X_6706_ _6706_/A0 _6223_/Y _6706_/S VGND VGND VPWR VPWR _7514_/D sky130_fd_sc_hd__mux2_2
X_4898_ _4898_/A0 _5296_/A1 _4900_/S VGND VGND VPWR VPWR _6925_/D sky130_fd_sc_hd__mux2_2
X_3918_ _3918_/A _3918_/B VGND VGND VPWR VPWR _4305_/A sky130_fd_sc_hd__nor2_2
XTAP_TAPCELL_ROW_102_1296 VGND VPWR sky130_fd_sc_hd__tapvpwrvgnd_1
X_3849_ _3842_/X _3848_/X _4151_/A VGND VGND VPWR VPWR _3850_/B sky130_fd_sc_hd__o21ai_2
XFILLER_22_69 VGND VGND VPWR VPWR sky130_fd_sc_hd__decap_3
XFILLER_98_29 VGND VGND VPWR VPWR sky130_fd_sc_hd__decap_3
X_6499_ _6499_/A0 _6017_/X _6569_/S VGND VGND VPWR VPWR _7428_/D sky130_fd_sc_hd__mux2_2
XFILLER_47_505 VGND VGND VPWR VPWR sky130_fd_sc_hd__decap_3
XFILLER_59_332 VGND VGND VPWR VPWR sky130_fd_sc_hd__decap_3
XFILLER_59_343 VGND VGND VPWR VPWR sky130_fd_sc_hd__decap_3
XFILLER_19_207 VGND VGND VPWR VPWR sky130_fd_sc_hd__decap_3
XFILLER_19_229 VGND VGND VPWR VPWR sky130_fd_sc_hd__decap_3
XFILLER_47_55 VGND VGND VPWR VPWR sky130_fd_sc_hd__fill_1
XFILLER_47_549 VGND VGND VPWR VPWR sky130_fd_sc_hd__decap_3
XFILLER_74_335 VGND VGND VPWR VPWR sky130_fd_sc_hd__decap_3
XFILLER_74_357 VGND VGND VPWR VPWR sky130_fd_sc_hd__decap_3
XFILLER_47_99 VGND VGND VPWR VPWR sky130_fd_sc_hd__fill_1
XFILLER_27_284 VGND VGND VPWR VPWR sky130_fd_sc_hd__decap_3
XFILLER_15_468 VGND VGND VPWR VPWR sky130_fd_sc_hd__fill_2
XFILLER_42_287 VGND VGND VPWR VPWR sky130_fd_sc_hd__decap_3
XFILLER_70_574 VGND VGND VPWR VPWR sky130_fd_sc_hd__decap_3
XTAP_TAPCELL_ROW_53_783 VGND VPWR sky130_fd_sc_hd__tapvpwrvgnd_1
XTAP_TAPCELL_ROW_25_485 VGND VPWR sky130_fd_sc_hd__tapvpwrvgnd_1
XFILLER_23_490 VGND VGND VPWR VPWR sky130_fd_sc_hd__decap_3
Xclkbuf_leaf_22_clk clkload1/A VGND VGND VPWR VPWR _7289_/CLK sky130_fd_sc_hd__clkbuf_16
XTAP_TAPCELL_ROW_81_1071 VGND VPWR sky130_fd_sc_hd__tapvpwrvgnd_1
XFILLER_10_151 VGND VGND VPWR VPWR sky130_fd_sc_hd__decap_3
XFILLER_10_195 VGND VGND VPWR VPWR sky130_fd_sc_hd__fill_1
XFILLER_6_122 VGND VGND VPWR VPWR sky130_fd_sc_hd__fill_1
XFILLER_6_133 VGND VGND VPWR VPWR sky130_fd_sc_hd__fill_1
XFILLER_6_144 VGND VGND VPWR VPWR sky130_fd_sc_hd__decap_3
XFILLER_6_177 VGND VGND VPWR VPWR sky130_fd_sc_hd__decap_3
XFILLER_12_91 VGND VGND VPWR VPWR sky130_fd_sc_hd__decap_3
XFILLER_88_62 VGND VGND VPWR VPWR sky130_fd_sc_hd__decap_3
XFILLER_97_427 VGND VGND VPWR VPWR sky130_fd_sc_hd__fill_2
XFILLER_97_449 VGND VGND VPWR VPWR sky130_fd_sc_hd__decap_3
XFILLER_26_6 VGND VGND VPWR VPWR sky130_fd_sc_hd__decap_3
XFILLER_38_527 VGND VGND VPWR VPWR sky130_fd_sc_hd__decap_3
XFILLER_65_346 VGND VGND VPWR VPWR sky130_fd_sc_hd__fill_2
XFILLER_18_295 VGND VGND VPWR VPWR sky130_fd_sc_hd__fill_1
XFILLER_33_221 VGND VGND VPWR VPWR sky130_fd_sc_hd__decap_3
XFILLER_33_243 VGND VGND VPWR VPWR sky130_fd_sc_hd__decap_3
X_4821_ _4821_/A0 _4714_/X _4834_/S VGND VGND VPWR VPWR _6890_/D sky130_fd_sc_hd__mux2_2
XFILLER_33_276 VGND VGND VPWR VPWR sky130_fd_sc_hd__decap_3
XFILLER_33_287 VGND VGND VPWR VPWR sky130_fd_sc_hd__decap_3
Xclkbuf_leaf_13_clk clkbuf_leaf_9_clk/A VGND VGND VPWR VPWR _7241_/CLK sky130_fd_sc_hd__clkbuf_16
X_7540_ _7606_/CLK _7540_/D place2047/X VGND VGND VPWR VPWR _7540_/Q sky130_fd_sc_hd__dfrtp_2
X_7471_ _7610_/CLK _7471_/D place2057/X VGND VGND VPWR VPWR _7471_/Q sky130_fd_sc_hd__dfrtp_2
X_4683_ _7405_/Q _4725_/A2 _4683_/B1 _5979_/A VGND VGND VPWR VPWR _4683_/X sky130_fd_sc_hd__a211o_2
X_6422_ _6477_/A2 _6985_/Q _6957_/Q _6476_/A1 VGND VGND VPWR VPWR _6422_/X sky130_fd_sc_hd__o22a_2
XTAP_TAPCELL_ROW_95_1218 VGND VPWR sky130_fd_sc_hd__tapvpwrvgnd_1
Xplace1812 _3490_/A VGND VGND VPWR VPWR _3547_/A sky130_fd_sc_hd__buf_2
Xplace1801 _4767_/B1 VGND VGND VPWR VPWR _6178_/A3 sky130_fd_sc_hd__buf_2
Xplace1845 _3931_/B VGND VGND VPWR VPWR _3761_/B sky130_fd_sc_hd__buf_2
Xplace1834 _4767_/B2 VGND VGND VPWR VPWR _6178_/A1 sky130_fd_sc_hd__buf_2
Xplace1823 _4464_/B VGND VGND VPWR VPWR _4482_/B sky130_fd_sc_hd__buf_2
X_3565_ _4613_/A2 _4613_/A3 _4613_/B1 _3463_/X VGND VGND VPWR VPWR _3565_/Y sky130_fd_sc_hd__a211oi_2
XFILLER_0_309 VGND VGND VPWR VPWR sky130_fd_sc_hd__fill_2
Xplace1878 _3458_/Y VGND VGND VPWR VPWR _4613_/A2 sky130_fd_sc_hd__buf_4
Xplace1867 _3519_/A VGND VGND VPWR VPWR _3653_/A1 sky130_fd_sc_hd__buf_6
Xplace1856 _3453_/X VGND VGND VPWR VPWR _3457_/B1 sky130_fd_sc_hd__buf_2
X_6284_ _6294_/A _6284_/B VGND VGND VPWR VPWR _7348_/D sky130_fd_sc_hd__and2_2
X_5304_ _5671_/A _5304_/B _5549_/B VGND VGND VPWR VPWR _5363_/S sky130_fd_sc_hd__and3_2
X_3496_ _3545_/A _3545_/B _3545_/C _7324_/Q VGND VGND VPWR VPWR _3502_/B sky130_fd_sc_hd__nand4_2
Xplace1889 _3480_/Y VGND VGND VPWR VPWR _3484_/A3 sky130_fd_sc_hd__buf_2
Xhold2503 _7101_/Q VGND VGND VPWR VPWR _5317_/A0 sky130_fd_sc_hd__dlygate4sd3_1
Xhold2547 _7274_/Q VGND VGND VPWR VPWR _5694_/A0 sky130_fd_sc_hd__dlygate4sd3_1
Xhold2536 _6909_/Q VGND VGND VPWR VPWR _4864_/A0 sky130_fd_sc_hd__dlygate4sd3_1
Xhold2525 _6940_/Q VGND VGND VPWR VPWR _4932_/A0 sky130_fd_sc_hd__dlygate4sd3_1
Xhold2514 _6912_/Q VGND VGND VPWR VPWR _4870_/A0 sky130_fd_sc_hd__dlygate4sd3_1
XFILLER_29_505 VGND VGND VPWR VPWR sky130_fd_sc_hd__decap_3
Xhold2569 _7058_/Q VGND VGND VPWR VPWR _5194_/A0 sky130_fd_sc_hd__dlygate4sd3_1
Xhold2558 _6915_/Q VGND VGND VPWR VPWR _4877_/A0 sky130_fd_sc_hd__dlygate4sd3_1
XFILLER_29_538 VGND VGND VPWR VPWR sky130_fd_sc_hd__decap_3
XFILLER_68_195 VGND VGND VPWR VPWR sky130_fd_sc_hd__fill_1
XFILLER_83_110 VGND VGND VPWR VPWR sky130_fd_sc_hd__fill_2
X_5097_ _5097_/A0 _5221_/A1 _5120_/S VGND VGND VPWR VPWR _7013_/D sky130_fd_sc_hd__mux2_2
X_4117_ _4607_/B _4117_/A2 _4579_/C _4117_/B2 _4117_/C1 VGND VGND VPWR VPWR _4117_/X
+ sky130_fd_sc_hd__a221o_2
XFILLER_17_47 VGND VGND VPWR VPWR sky130_fd_sc_hd__decap_3
X_4048_ _7304_/Q _4050_/D _7305_/Q VGND VGND VPWR VPWR _4049_/B sky130_fd_sc_hd__a21oi_2
XFILLER_24_265 VGND VGND VPWR VPWR sky130_fd_sc_hd__decap_3
X_5999_ _5999_/A1 _7011_/Q _6983_/Q _6171_/B1 VGND VGND VPWR VPWR _5999_/X sky130_fd_sc_hd__o22a_2
XFILLER_33_35 VGND VGND VPWR VPWR sky130_fd_sc_hd__fill_1
XFILLER_33_57 VGND VGND VPWR VPWR sky130_fd_sc_hd__fill_1
XFILLER_33_79 VGND VGND VPWR VPWR sky130_fd_sc_hd__decap_3
XTAP_TAPCELL_ROW_50_753 VGND VPWR sky130_fd_sc_hd__tapvpwrvgnd_1
XTAP_TAPCELL_ROW_22_455 VGND VPWR sky130_fd_sc_hd__tapvpwrvgnd_1
XFILLER_20_471 VGND VGND VPWR VPWR sky130_fd_sc_hd__decap_3
XFILLER_20_493 VGND VGND VPWR VPWR sky130_fd_sc_hd__decap_3
XFILLER_3_125 VGND VGND VPWR VPWR sky130_fd_sc_hd__decap_3
XPHY_EDGE_ROW_18_Left_122 VGND VGND VPWR VPWR sky130_fd_sc_hd__decap_3
XFILLER_3_147 VGND VGND VPWR VPWR sky130_fd_sc_hd__decap_3
XFILLER_3_169 VGND VGND VPWR VPWR sky130_fd_sc_hd__decap_3
XFILLER_47_324 VGND VGND VPWR VPWR sky130_fd_sc_hd__decap_3
XFILLER_47_346 VGND VGND VPWR VPWR sky130_fd_sc_hd__decap_3
XTAP_TAPCELL_ROW_58_831 VGND VPWR sky130_fd_sc_hd__tapvpwrvgnd_1
XFILLER_28_560 VGND VGND VPWR VPWR sky130_fd_sc_hd__decap_3
XFILLER_35_508 VGND VGND VPWR VPWR sky130_fd_sc_hd__fill_2
XFILLER_35_519 VGND VGND VPWR VPWR sky130_fd_sc_hd__decap_3
XFILLER_47_379 VGND VGND VPWR VPWR sky130_fd_sc_hd__fill_1
XFILLER_62_305 VGND VGND VPWR VPWR sky130_fd_sc_hd__decap_3
XPHY_EDGE_ROW_27_Left_131 VGND VGND VPWR VPWR sky130_fd_sc_hd__decap_3
XFILLER_28_571 VGND VGND VPWR VPWR sky130_fd_sc_hd__decap_3
XFILLER_28_582 VGND VGND VPWR VPWR sky130_fd_sc_hd__decap_3
XFILLER_90_85 VGND VGND VPWR VPWR sky130_fd_sc_hd__fill_2
XPHY_EDGE_ROW_36_Left_140 VGND VGND VPWR VPWR sky130_fd_sc_hd__decap_3
Xplace1108 _4763_/Y VGND VGND VPWR VPWR _5726_/A1 sky130_fd_sc_hd__buf_2
Xplace1119 _4714_/X VGND VGND VPWR VPWR _5711_/A1 sky130_fd_sc_hd__buf_2
X_5020_ _5020_/A0 _4745_/Y _5028_/S VGND VGND VPWR VPWR _6978_/D sky130_fd_sc_hd__mux2_2
XFILLER_24_3 VGND VGND VPWR VPWR sky130_fd_sc_hd__decap_3
Xclkbuf_leaf_2_clk clkbuf_leaf_3_clk/A VGND VGND VPWR VPWR clkload8/A sky130_fd_sc_hd__clkbuf_16
XFILLER_38_324 VGND VGND VPWR VPWR sky130_fd_sc_hd__decap_3
XFILLER_26_519 VGND VGND VPWR VPWR sky130_fd_sc_hd__fill_2
XFILLER_65_143 VGND VGND VPWR VPWR sky130_fd_sc_hd__decap_3
X_6971_ _7114_/CLK _6971_/D VGND VGND VPWR VPWR _6971_/Q sky130_fd_sc_hd__dfxtp_2
XFILLER_0_72 VGND VGND VPWR VPWR sky130_fd_sc_hd__decap_3
XFILLER_0_94 VGND VGND VPWR VPWR sky130_fd_sc_hd__decap_3
XFILLER_34_530 VGND VGND VPWR VPWR sky130_fd_sc_hd__fill_2
X_5922_ _6048_/A _5911_/X _5921_/X VGND VGND VPWR VPWR _5922_/Y sky130_fd_sc_hd__o21ai_2
XFILLER_21_202 VGND VGND VPWR VPWR sky130_fd_sc_hd__decap_3
XFILLER_21_235 VGND VGND VPWR VPWR sky130_fd_sc_hd__decap_3
XFILLER_61_393 VGND VGND VPWR VPWR sky130_fd_sc_hd__fill_1
X_4804_ _4804_/A0 _5694_/A1 _4806_/S VGND VGND VPWR VPWR _6882_/D sky130_fd_sc_hd__mux2_2
XFILLER_21_257 VGND VGND VPWR VPWR sky130_fd_sc_hd__decap_3
X_7523_ clkload6/A _7523_/D place2030/X VGND VGND VPWR VPWR _7523_/Q sky130_fd_sc_hd__dfrtp_2
X_4735_ _6436_/A _6436_/B _4735_/C _4735_/D VGND VGND VPWR VPWR _4735_/X sky130_fd_sc_hd__or4_4
X_7454_ clkload7/A _7454_/D place2027/X VGND VGND VPWR VPWR _7454_/Q sky130_fd_sc_hd__dfrtp_2
Xplace1620 _4970_/A VGND VGND VPWR VPWR _6559_/B1 sky130_fd_sc_hd__buf_2
X_7385_ _7577_/CLK _7385_/D place2036/X VGND VGND VPWR VPWR _7385_/Q sky130_fd_sc_hd__dfrtp_2
X_6405_ _7607_/Q _6179_/B _6180_/X VGND VGND VPWR VPWR _6405_/Y sky130_fd_sc_hd__o21ai_2
X_4597_ _4597_/A0 _5310_/A1 _4665_/S VGND VGND VPWR VPWR _6846_/D sky130_fd_sc_hd__mux2_2
X_3617_ _3440_/X _3571_/Y _3529_/Y VGND VGND VPWR VPWR _3617_/Y sky130_fd_sc_hd__a21oi_4
Xplace1631 _3617_/Y VGND VGND VPWR VPWR _3858_/B1 sky130_fd_sc_hd__buf_4
Xplace1642 _3816_/B1 VGND VGND VPWR VPWR _3781_/B1 sky130_fd_sc_hd__buf_2
Xplace1653 _3901_/B VGND VGND VPWR VPWR _6331_/A2 sky130_fd_sc_hd__buf_2
X_3548_ _3548_/A1 _3498_/Y _7357_/Q _3548_/B1 _7549_/Q VGND VGND VPWR VPWR _3549_/D
+ sky130_fd_sc_hd__a32oi_2
XFILLER_103_513 VGND VGND VPWR VPWR sky130_fd_sc_hd__fill_2
Xhold3001 _7488_/Q VGND VGND VPWR VPWR _6651_/A0 sky130_fd_sc_hd__dlygate4sd3_1
Xhold3012 _7421_/Q VGND VGND VPWR VPWR _6418_/A0 sky130_fd_sc_hd__dlygate4sd3_1
Xhold3023 _7393_/Q VGND VGND VPWR VPWR _6311_/A1 sky130_fd_sc_hd__dlygate4sd3_1
Xplace1664 _4595_/A3 VGND VGND VPWR VPWR _6313_/A3 sky130_fd_sc_hd__buf_2
Xplace1675 _6388_/A3 VGND VGND VPWR VPWR _6410_/A3 sky130_fd_sc_hd__buf_2
Xplace1686 _3515_/Y VGND VGND VPWR VPWR _3990_/A1 sky130_fd_sc_hd__buf_2
XFILLER_103_557 VGND VGND VPWR VPWR sky130_fd_sc_hd__decap_3
Xhold3034 _7443_/Q VGND VGND VPWR VPWR _6549_/A0 sky130_fd_sc_hd__dlygate4sd3_1
Xhold3045 _7492_/Q VGND VGND VPWR VPWR _6660_/A0 sky130_fd_sc_hd__dlygate4sd3_1
Xplace1697 _3577_/Y VGND VGND VPWR VPWR _3578_/A2 sky130_fd_sc_hd__buf_6
X_6267_ _6292_/A _6267_/B VGND VGND VPWR VPWR _7340_/D sky130_fd_sc_hd__and2_2
XFILLER_29_302 VGND VGND VPWR VPWR sky130_fd_sc_hd__decap_3
X_6198_ _6198_/A _6198_/B _6198_/C VGND VGND VPWR VPWR _6198_/X sky130_fd_sc_hd__and3_2
X_5218_ _5218_/A0 _4576_/X _5230_/S VGND VGND VPWR VPWR _7068_/D sky130_fd_sc_hd__mux2_2
XFILLER_28_35 VGND VGND VPWR VPWR sky130_fd_sc_hd__fill_2
XFILLER_96_290 VGND VGND VPWR VPWR sky130_fd_sc_hd__fill_1
Xhold2388 _6871_/Q VGND VGND VPWR VPWR _4776_/A0 sky130_fd_sc_hd__dlygate4sd3_1
Xhold2377 _7203_/Q VGND VGND VPWR VPWR _5539_/A0 sky130_fd_sc_hd__dlygate4sd3_1
XFILLER_28_79 VGND VGND VPWR VPWR sky130_fd_sc_hd__decap_3
XFILLER_56_132 VGND VGND VPWR VPWR sky130_fd_sc_hd__decap_3
XFILLER_84_463 VGND VGND VPWR VPWR sky130_fd_sc_hd__decap_3
Xhold2399 _6947_/Q VGND VGND VPWR VPWR _4947_/A0 sky130_fd_sc_hd__dlygate4sd3_1
XTAP_TAPCELL_ROW_55_801 VGND VPWR sky130_fd_sc_hd__tapvpwrvgnd_1
XFILLER_44_327 VGND VGND VPWR VPWR sky130_fd_sc_hd__decap_3
XTAP_TAPCELL_ROW_27_503 VGND VPWR sky130_fd_sc_hd__tapvpwrvgnd_1
XFILLER_44_349 VGND VGND VPWR VPWR sky130_fd_sc_hd__decap_3
XFILLER_44_67 VGND VGND VPWR VPWR sky130_fd_sc_hd__decap_3
XFILLER_52_360 VGND VGND VPWR VPWR sky130_fd_sc_hd__decap_3
XFILLER_40_533 VGND VGND VPWR VPWR sky130_fd_sc_hd__decap_3
XTAP_TAPCELL_ROW_35_591 VGND VPWR sky130_fd_sc_hd__tapvpwrvgnd_1
XFILLER_100_62 VGND VGND VPWR VPWR sky130_fd_sc_hd__fill_2
XFILLER_100_73 VGND VGND VPWR VPWR sky130_fd_sc_hd__fill_2
XFILLER_40_555 VGND VGND VPWR VPWR sky130_fd_sc_hd__decap_3
XFILLER_40_577 VGND VGND VPWR VPWR sky130_fd_sc_hd__decap_3
XFILLER_8_206 VGND VGND VPWR VPWR sky130_fd_sc_hd__decap_3
XFILLER_8_228 VGND VGND VPWR VPWR sky130_fd_sc_hd__fill_2
XFILLER_79_279 VGND VGND VPWR VPWR sky130_fd_sc_hd__fill_1
XFILLER_87_290 VGND VGND VPWR VPWR sky130_fd_sc_hd__fill_1
XTAP_TAPCELL_ROW_7_294 VGND VPWR sky130_fd_sc_hd__tapvpwrvgnd_1
XFILLER_47_154 VGND VGND VPWR VPWR sky130_fd_sc_hd__decap_3
XFILLER_47_187 VGND VGND VPWR VPWR sky130_fd_sc_hd__decap_3
XFILLER_31_511 VGND VGND VPWR VPWR sky130_fd_sc_hd__decap_3
XFILLER_90_499 VGND VGND VPWR VPWR sky130_fd_sc_hd__fill_1
XFILLER_31_544 VGND VGND VPWR VPWR sky130_fd_sc_hd__decap_3
XFILLER_70_190 VGND VGND VPWR VPWR sky130_fd_sc_hd__fill_2
XTAP_TAPCELL_ROW_61_859 VGND VPWR sky130_fd_sc_hd__tapvpwrvgnd_1
XFILLER_11_290 VGND VGND VPWR VPWR sky130_fd_sc_hd__fill_2
X_4520_ _4532_/A _4532_/D VGND VGND VPWR VPWR _4520_/Y sky130_fd_sc_hd__nand2_2
XFILLER_7_272 VGND VGND VPWR VPWR sky130_fd_sc_hd__decap_3
XFILLER_7_294 VGND VGND VPWR VPWR sky130_fd_sc_hd__decap_3
X_7170_ _7407_/CLK _7170_/D VGND VGND VPWR VPWR _7170_/Q sky130_fd_sc_hd__dfxtp_2
X_6121_ _6119_/X _6120_/X _6506_/A1 _6156_/C1 VGND VGND VPWR VPWR _6121_/X sky130_fd_sc_hd__a211o_2
X_4382_ _4036_/A _4420_/B _4411_/A VGND VGND VPWR VPWR _4385_/A sky130_fd_sc_hd__a21oi_2
XPHY_EDGE_ROW_7_Right_7 VGND VGND VPWR VPWR sky130_fd_sc_hd__decap_3
X_6052_ _6480_/B2 _7160_/Q _7132_/Q _6483_/B2 VGND VGND VPWR VPWR _6052_/X sky130_fd_sc_hd__o22a_2
X_5003_ _5003_/A0 _5336_/A1 _5024_/S VGND VGND VPWR VPWR _6970_/D sky130_fd_sc_hd__mux2_2
XTAP_TAPCELL_ROW_69_948 VGND VPWR sky130_fd_sc_hd__tapvpwrvgnd_1
XFILLER_26_305 VGND VGND VPWR VPWR sky130_fd_sc_hd__decap_3
XFILLER_53_113 VGND VGND VPWR VPWR sky130_fd_sc_hd__fill_1
XFILLER_53_135 VGND VGND VPWR VPWR sky130_fd_sc_hd__fill_2
X_6954_ _7287_/CLK _6954_/D VGND VGND VPWR VPWR _6954_/Q sky130_fd_sc_hd__dfxtp_2
X_5905_ _6138_/A1 _6918_/Q _7254_/Q _5905_/B2 VGND VGND VPWR VPWR _5905_/X sky130_fd_sc_hd__o22a_2
XFILLER_22_533 VGND VGND VPWR VPWR sky130_fd_sc_hd__fill_2
XFILLER_34_371 VGND VGND VPWR VPWR sky130_fd_sc_hd__decap_3
X_6885_ _7291_/CLK _6885_/D VGND VGND VPWR VPWR _6885_/Q sky130_fd_sc_hd__dfxtp_2
XFILLER_14_59 VGND VGND VPWR VPWR sky130_fd_sc_hd__decap_3
X_5836_ _6872_/Q _5488_/B _5671_/C _7264_/Q VGND VGND VPWR VPWR _5836_/X sky130_fd_sc_hd__a22o_2
X_5767_ _5754_/X _5763_/X _6458_/B2 VGND VGND VPWR VPWR _5789_/A sky130_fd_sc_hd__a21oi_2
XTAP_TAPCELL_ROW_32_561 VGND VPWR sky130_fd_sc_hd__tapvpwrvgnd_1
X_7506_ _7542_/CLK _7506_/D place2047/X VGND VGND VPWR VPWR _7506_/Q sky130_fd_sc_hd__dfrtp_2
X_5698_ _5698_/A0 _5698_/A1 _5698_/S VGND VGND VPWR VPWR _7276_/D sky130_fd_sc_hd__mux2_2
X_4718_ _7410_/Q _4725_/A2 _4718_/B1 _5979_/A VGND VGND VPWR VPWR _4718_/X sky130_fd_sc_hd__a211o_2
X_7437_ clkload3/A _7437_/D place2059/X VGND VGND VPWR VPWR _7437_/Q sky130_fd_sc_hd__dfrtp_2
X_4649_ _4675_/B _6437_/B1 _4595_/X _6226_/B1 _4648_/Y VGND VGND VPWR VPWR _4649_/X
+ sky130_fd_sc_hd__o311a_2
XFILLER_30_69 VGND VGND VPWR VPWR sky130_fd_sc_hd__fill_2
Xplace1450 _3862_/A3 VGND VGND VPWR VPWR _4184_/C sky130_fd_sc_hd__buf_2
Xplace1461 _3688_/Y VGND VGND VPWR VPWR _4774_/A2 sky130_fd_sc_hd__buf_2
X_7368_ clkload9/A _7368_/D place2018/X VGND VGND VPWR VPWR _7368_/Q sky130_fd_sc_hd__dfrtp_2
XFILLER_103_332 VGND VGND VPWR VPWR sky130_fd_sc_hd__decap_3
Xplace1472 _6495_/A2 VGND VGND VPWR VPWR _6404_/B1 sky130_fd_sc_hd__buf_2
Xplace1483 _4720_/C VGND VGND VPWR VPWR _5162_/A1 sky130_fd_sc_hd__buf_2
Xplace1494 _3904_/Y VGND VGND VPWR VPWR _4403_/B1 sky130_fd_sc_hd__buf_2
X_7299_ clkload5/A _7299_/D place2061/X VGND VGND VPWR VPWR _7299_/Q sky130_fd_sc_hd__dfrtp_2
X_6319_ _6319_/A1 _6331_/A2 _6322_/A3 _6324_/B1 _6319_/B2 VGND VGND VPWR VPWR _7366_/D
+ sky130_fd_sc_hd__a32o_2
XFILLER_76_205 VGND VGND VPWR VPWR sky130_fd_sc_hd__fill_2
XFILLER_39_89 VGND VGND VPWR VPWR sky130_fd_sc_hd__decap_3
XFILLER_76_249 VGND VGND VPWR VPWR sky130_fd_sc_hd__decap_3
XFILLER_29_143 VGND VGND VPWR VPWR sky130_fd_sc_hd__decap_3
XFILLER_69_290 VGND VGND VPWR VPWR sky130_fd_sc_hd__decap_3
XTAP_TAPCELL_ROW_4_264 VGND VPWR sky130_fd_sc_hd__tapvpwrvgnd_1
XFILLER_17_305 VGND VGND VPWR VPWR sky130_fd_sc_hd__fill_2
XFILLER_29_187 VGND VGND VPWR VPWR sky130_fd_sc_hd__decap_3
XFILLER_25_360 VGND VGND VPWR VPWR sky130_fd_sc_hd__fill_1
XFILLER_13_522 VGND VGND VPWR VPWR sky130_fd_sc_hd__decap_3
XFILLER_25_371 VGND VGND VPWR VPWR sky130_fd_sc_hd__fill_1
XFILLER_25_382 VGND VGND VPWR VPWR sky130_fd_sc_hd__fill_2
XFILLER_25_393 VGND VGND VPWR VPWR sky130_fd_sc_hd__decap_3
XFILLER_40_374 VGND VGND VPWR VPWR sky130_fd_sc_hd__decap_3
XTAP_TAPCELL_ROW_78_1043 VGND VPWR sky130_fd_sc_hd__tapvpwrvgnd_1
XFILLER_96_62 VGND VGND VPWR VPWR sky130_fd_sc_hd__fill_1
XFILLER_0_470 VGND VGND VPWR VPWR sky130_fd_sc_hd__decap_3
XFILLER_0_492 VGND VGND VPWR VPWR sky130_fd_sc_hd__decap_3
XFILLER_48_430 VGND VGND VPWR VPWR sky130_fd_sc_hd__fill_2
XTAP_TAPCELL_ROW_66_918 VGND VPWR sky130_fd_sc_hd__tapvpwrvgnd_1
XFILLER_35_113 VGND VGND VPWR VPWR sky130_fd_sc_hd__fill_1
XTAP_TAPCELL_ROW_89_1161 VGND VPWR sky130_fd_sc_hd__tapvpwrvgnd_1
X_3951_ _3951_/A _3951_/B _3951_/C VGND VGND VPWR VPWR _3951_/Y sky130_fd_sc_hd__nand3_4
XFILLER_50_116 VGND VGND VPWR VPWR sky130_fd_sc_hd__decap_3
XFILLER_50_138 VGND VGND VPWR VPWR sky130_fd_sc_hd__fill_2
XFILLER_63_499 VGND VGND VPWR VPWR sky130_fd_sc_hd__fill_1
XTAP_TAPCELL_ROW_74_995 VGND VPWR sky130_fd_sc_hd__tapvpwrvgnd_1
XFILLER_43_190 VGND VGND VPWR VPWR sky130_fd_sc_hd__decap_3
XFILLER_91_3 VGND VGND VPWR VPWR sky130_fd_sc_hd__decap_3
X_6670_ _6670_/A0 _6078_/X _6675_/S VGND VGND VPWR VPWR _7497_/D sky130_fd_sc_hd__mux2_2
X_3882_ _3882_/A _3882_/B _3882_/C VGND VGND VPWR VPWR _3882_/Y sky130_fd_sc_hd__nand3_2
XFILLER_31_374 VGND VGND VPWR VPWR sky130_fd_sc_hd__decap_3
XFILLER_8_592 VGND VGND VPWR VPWR sky130_fd_sc_hd__fill_1
X_4503_ _4503_/A _4503_/B _4503_/C _4067_/A VGND VGND VPWR VPWR _4506_/A sky130_fd_sc_hd__or4b_2
X_7222_ _7407_/CLK _7222_/D VGND VGND VPWR VPWR _7222_/Q sky130_fd_sc_hd__dfxtp_2
X_4434_ _4508_/A _4044_/B _4042_/B _4508_/B _3561_/B VGND VGND VPWR VPWR _4434_/X
+ sky130_fd_sc_hd__o41a_2
X_7153_ _7393_/CLK _7153_/D VGND VGND VPWR VPWR _7153_/Q sky130_fd_sc_hd__dfxtp_2
X_4365_ _4388_/S _4362_/X _4363_/Y _4364_/X _4468_/C1 VGND VGND VPWR VPWR _4365_/X
+ sky130_fd_sc_hd__o311a_2
X_7084_ _7282_/CLK _7084_/D VGND VGND VPWR VPWR _7084_/Q sky130_fd_sc_hd__dfxtp_2
X_6104_ _6175_/A2 _6886_/Q _7278_/Q _6165_/A1 VGND VGND VPWR VPWR _6104_/X sky130_fd_sc_hd__o22a_2
X_6035_ _6033_/X _6034_/X _6506_/A1 _6070_/A2 VGND VGND VPWR VPWR _6035_/X sky130_fd_sc_hd__a211o_2
X_4296_ _4296_/A _4296_/B VGND VGND VPWR VPWR _4296_/Y sky130_fd_sc_hd__nor2_2
XFILLER_100_368 VGND VGND VPWR VPWR sky130_fd_sc_hd__decap_3
XTAP_TAPCELL_ROW_1_234 VGND VPWR sky130_fd_sc_hd__tapvpwrvgnd_1
XFILLER_66_293 VGND VGND VPWR VPWR sky130_fd_sc_hd__decap_3
XFILLER_25_36 VGND VGND VPWR VPWR sky130_fd_sc_hd__fill_2
XFILLER_26_168 VGND VGND VPWR VPWR sky130_fd_sc_hd__fill_1
X_6937_ _7273_/CLK _6937_/D VGND VGND VPWR VPWR _6937_/Q sky130_fd_sc_hd__dfxtp_2
XFILLER_34_190 VGND VGND VPWR VPWR sky130_fd_sc_hd__decap_3
X_6868_ _7280_/CLK _6868_/D VGND VGND VPWR VPWR _6868_/Q sky130_fd_sc_hd__dfxtp_2
XFILLER_10_525 VGND VGND VPWR VPWR sky130_fd_sc_hd__decap_3
XFILLER_22_385 VGND VGND VPWR VPWR sky130_fd_sc_hd__fill_1
X_5819_ _5817_/X _5818_/X _6458_/B2 VGND VGND VPWR VPWR _5820_/D sky130_fd_sc_hd__a21oi_2
XFILLER_41_57 VGND VGND VPWR VPWR sky130_fd_sc_hd__decap_3
XFILLER_1_212 VGND VGND VPWR VPWR sky130_fd_sc_hd__fill_1
XFILLER_1_223 VGND VGND VPWR VPWR sky130_fd_sc_hd__fill_1
XFILLER_77_503 VGND VGND VPWR VPWR sky130_fd_sc_hd__fill_1
Xplace1280 _6424_/B2 VGND VGND VPWR VPWR _6476_/B2 sky130_fd_sc_hd__buf_2
Xplace1291 _6455_/B2 VGND VGND VPWR VPWR _6138_/B2 sky130_fd_sc_hd__buf_8
XFILLER_2_29 VGND VGND VPWR VPWR sky130_fd_sc_hd__decap_3
XFILLER_77_558 VGND VGND VPWR VPWR sky130_fd_sc_hd__fill_2
XFILLER_72_230 VGND VGND VPWR VPWR sky130_fd_sc_hd__decap_3
XFILLER_45_466 VGND VGND VPWR VPWR sky130_fd_sc_hd__decap_3
XFILLER_32_116 VGND VGND VPWR VPWR sky130_fd_sc_hd__fill_1
XTAP_TAPCELL_ROW_71_965 VGND VPWR sky130_fd_sc_hd__tapvpwrvgnd_1
XFILLER_9_312 VGND VGND VPWR VPWR sky130_fd_sc_hd__decap_3
XTAP_TAPCELL_ROW_43_678 VGND VPWR sky130_fd_sc_hd__tapvpwrvgnd_1
X_4150_ _7396_/Q _4150_/A2 _3922_/X _3923_/X VGND VGND VPWR VPWR _4151_/C sky130_fd_sc_hd__a211o_2
XFILLER_95_333 VGND VGND VPWR VPWR sky130_fd_sc_hd__decap_3
XFILLER_68_569 VGND VGND VPWR VPWR sky130_fd_sc_hd__fill_2
X_4081_ _4542_/B _4085_/D _4548_/A VGND VGND VPWR VPWR _4083_/A sky130_fd_sc_hd__a21oi_2
XFILLER_36_444 VGND VGND VPWR VPWR sky130_fd_sc_hd__decap_3
XFILLER_36_477 VGND VGND VPWR VPWR sky130_fd_sc_hd__decap_3
XFILLER_36_488 VGND VGND VPWR VPWR sky130_fd_sc_hd__decap_3
XFILLER_63_241 VGND VGND VPWR VPWR sky130_fd_sc_hd__fill_2
XFILLER_63_263 VGND VGND VPWR VPWR sky130_fd_sc_hd__decap_3
XFILLER_91_561 VGND VGND VPWR VPWR sky130_fd_sc_hd__fill_1
XFILLER_51_447 VGND VGND VPWR VPWR sky130_fd_sc_hd__fill_1
XFILLER_51_458 VGND VGND VPWR VPWR sky130_fd_sc_hd__decap_3
X_6722_ _5944_/X _6722_/A1 _6769_/S VGND VGND VPWR VPWR _7522_/D sky130_fd_sc_hd__mux2_2
X_3934_ _7491_/Q _3968_/B _3934_/B1 _7427_/Q VGND VGND VPWR VPWR _3935_/B sky130_fd_sc_hd__a22oi_2
XFILLER_31_160 VGND VGND VPWR VPWR sky130_fd_sc_hd__decap_3
X_6653_ _6653_/A0 _5943_/X _6653_/S VGND VGND VPWR VPWR _7489_/D sky130_fd_sc_hd__mux2_2
X_3865_ _7497_/Q _3865_/B VGND VGND VPWR VPWR _3867_/B sky130_fd_sc_hd__nand2_2
X_5604_ _5604_/A0 _4763_/Y _5606_/S VGND VGND VPWR VPWR _7233_/D sky130_fd_sc_hd__mux2_2
X_3796_ _4225_/A1 _3794_/Y _3795_/Y VGND VGND VPWR VPWR _3796_/Y sky130_fd_sc_hd__o21bai_2
XTAP_TAPCELL_ROW_98_1249 VGND VPWR sky130_fd_sc_hd__tapvpwrvgnd_1
X_5535_ _5535_/A0 _5718_/A1 _5545_/S VGND VGND VPWR VPWR _7201_/D sky130_fd_sc_hd__mux2_2
X_7205_ _7289_/CLK _7205_/D VGND VGND VPWR VPWR _7205_/Q sky130_fd_sc_hd__dfxtp_2
X_4417_ _4508_/A _4325_/B _4422_/B _4416_/Y VGND VGND VPWR VPWR _4417_/X sky130_fd_sc_hd__o211a_2
X_7136_ _7276_/CLK _7136_/D VGND VGND VPWR VPWR _7136_/Q sky130_fd_sc_hd__dfxtp_2
X_4348_ _7585_/D _5843_/B _4348_/C VGND VGND VPWR VPWR _4348_/X sky130_fd_sc_hd__or3_2
X_7067_ _7287_/CLK _7067_/D VGND VGND VPWR VPWR _7067_/Q sky130_fd_sc_hd__dfxtp_2
X_4279_ _3704_/X _4279_/B _4279_/C _4279_/D VGND VGND VPWR VPWR _4283_/A sky130_fd_sc_hd__and4b_2
X_6018_ _6229_/A1 _6229_/A2 _6229_/B1 _6018_/B2 VGND VGND VPWR VPWR _6018_/X sky130_fd_sc_hd__o22a_2
XFILLER_100_187 VGND VGND VPWR VPWR sky130_fd_sc_hd__fill_1
XFILLER_82_572 VGND VGND VPWR VPWR sky130_fd_sc_hd__decap_3
XFILLER_14_105 VGND VGND VPWR VPWR sky130_fd_sc_hd__decap_3
XFILLER_14_127 VGND VGND VPWR VPWR sky130_fd_sc_hd__decap_3
XFILLER_42_436 VGND VGND VPWR VPWR sky130_fd_sc_hd__fill_2
XFILLER_30_609 VGND VGND VPWR VPWR sky130_fd_sc_hd__decap_3
XFILLER_42_469 VGND VGND VPWR VPWR sky130_fd_sc_hd__decap_3
XFILLER_10_300 VGND VGND VPWR VPWR sky130_fd_sc_hd__decap_3
XFILLER_10_344 VGND VGND VPWR VPWR sky130_fd_sc_hd__decap_3
XFILLER_50_491 VGND VGND VPWR VPWR sky130_fd_sc_hd__fill_1
XFILLER_52_67 VGND VGND VPWR VPWR sky130_fd_sc_hd__fill_1
XTAP_TAPCELL_ROW_40_648 VGND VPWR sky130_fd_sc_hd__tapvpwrvgnd_1
XFILLER_6_304 VGND VGND VPWR VPWR sky130_fd_sc_hd__decap_3
XFILLER_6_315 VGND VGND VPWR VPWR sky130_fd_sc_hd__decap_3
XFILLER_6_348 VGND VGND VPWR VPWR sky130_fd_sc_hd__decap_3
XTAP_TAPCELL_ROW_75_1013 VGND VPWR sky130_fd_sc_hd__tapvpwrvgnd_1
XFILLER_77_20 VGND VGND VPWR VPWR sky130_fd_sc_hd__fill_1
XFILLER_77_333 VGND VGND VPWR VPWR sky130_fd_sc_hd__decap_3
XTAP_TAPCELL_ROW_48_726 VGND VPWR sky130_fd_sc_hd__tapvpwrvgnd_1
XFILLER_18_477 VGND VGND VPWR VPWR sky130_fd_sc_hd__decap_3
XFILLER_33_403 VGND VGND VPWR VPWR sky130_fd_sc_hd__decap_3
XTAP_TAPCELL_ROW_86_1131 VGND VPWR sky130_fd_sc_hd__tapvpwrvgnd_1
XFILLER_18_499 VGND VGND VPWR VPWR sky130_fd_sc_hd__decap_3
XFILLER_21_609 VGND VGND VPWR VPWR sky130_fd_sc_hd__decap_3
XFILLER_33_458 VGND VGND VPWR VPWR sky130_fd_sc_hd__decap_3
XFILLER_13_160 VGND VGND VPWR VPWR sky130_fd_sc_hd__decap_3
X_3650_ _4253_/A _4247_/B _4247_/C VGND VGND VPWR VPWR _4249_/B sky130_fd_sc_hd__o21ai_2
X_3581_ _3581_/A _3581_/B VGND VGND VPWR VPWR _3581_/Y sky130_fd_sc_hd__nand2_2
X_4202_ _4202_/A _4202_/B _4202_/C VGND VGND VPWR VPWR _4204_/B sky130_fd_sc_hd__or3_4
Xhold2707 _6938_/Q VGND VGND VPWR VPWR _4928_/A0 sky130_fd_sc_hd__dlygate4sd3_1
Xhold2718 _6884_/Q VGND VGND VPWR VPWR _4808_/A0 sky130_fd_sc_hd__dlygate4sd3_1
Xhold2729 _6969_/Q VGND VGND VPWR VPWR _5001_/A0 sky130_fd_sc_hd__dlygate4sd3_1
XFILLER_3_83 VGND VGND VPWR VPWR sky130_fd_sc_hd__decap_3
X_4133_ _4133_/A _4133_/B VGND VGND VPWR VPWR _4133_/X sky130_fd_sc_hd__and2_2
XFILLER_56_539 VGND VGND VPWR VPWR sky130_fd_sc_hd__fill_1
X_4064_ _4067_/A _7312_/Q _4499_/C VGND VGND VPWR VPWR _4066_/B sky130_fd_sc_hd__and3_2
XFILLER_36_285 VGND VGND VPWR VPWR sky130_fd_sc_hd__decap_3
XFILLER_91_391 VGND VGND VPWR VPWR sky130_fd_sc_hd__fill_1
XFILLER_51_277 VGND VGND VPWR VPWR sky130_fd_sc_hd__decap_3
XFILLER_32_480 VGND VGND VPWR VPWR sky130_fd_sc_hd__decap_3
X_3917_ _4157_/A _4157_/B _3917_/B1 _4166_/A1 VGND VGND VPWR VPWR _3918_/B sky130_fd_sc_hd__o211ai_2
XTAP_TAPCELL_ROW_102_1297 VGND VPWR sky130_fd_sc_hd__tapvpwrvgnd_1
X_6636_ _6636_/A0 _6566_/Y _6638_/S VGND VGND VPWR VPWR _7481_/D sky130_fd_sc_hd__mux2_2
X_3848_ _6373_/B2 _3904_/A2 _3848_/B1 _7339_/Q _3847_/X VGND VGND VPWR VPWR _3848_/X
+ sky130_fd_sc_hd__a221o_2
X_6567_ _6567_/A0 _6566_/Y _6567_/S VGND VGND VPWR VPWR _7449_/D sky130_fd_sc_hd__mux2_2
X_3779_ _7310_/Q _4211_/A VGND VGND VPWR VPWR _3779_/Y sky130_fd_sc_hd__nand2_2
XFILLER_3_318 VGND VGND VPWR VPWR sky130_fd_sc_hd__decap_3
X_5518_ _5518_/A0 _4677_/X _5532_/S VGND VGND VPWR VPWR _7193_/D sky130_fd_sc_hd__mux2_2
XFILLER_59_355 VGND VGND VPWR VPWR sky130_fd_sc_hd__fill_2
X_7119_ _7289_/CLK _7119_/D VGND VGND VPWR VPWR _7119_/Q sky130_fd_sc_hd__dfxtp_2
XFILLER_59_366 VGND VGND VPWR VPWR sky130_fd_sc_hd__decap_3
XFILLER_15_436 VGND VGND VPWR VPWR sky130_fd_sc_hd__decap_3
XFILLER_42_233 VGND VGND VPWR VPWR sky130_fd_sc_hd__decap_3
XFILLER_63_55 VGND VGND VPWR VPWR sky130_fd_sc_hd__fill_1
XFILLER_30_417 VGND VGND VPWR VPWR sky130_fd_sc_hd__decap_3
XFILLER_70_586 VGND VGND VPWR VPWR sky130_fd_sc_hd__fill_2
XTAP_TAPCELL_ROW_53_784 VGND VPWR sky130_fd_sc_hd__tapvpwrvgnd_1
XFILLER_23_480 VGND VGND VPWR VPWR sky130_fd_sc_hd__decap_3
XTAP_TAPCELL_ROW_81_1072 VGND VPWR sky130_fd_sc_hd__tapvpwrvgnd_1
XTAP_TAPCELL_ROW_25_486 VGND VPWR sky130_fd_sc_hd__tapvpwrvgnd_1
XFILLER_6_101 VGND VGND VPWR VPWR sky130_fd_sc_hd__decap_3
XFILLER_10_163 VGND VGND VPWR VPWR sky130_fd_sc_hd__decap_3
XFILLER_6_156 VGND VGND VPWR VPWR sky130_fd_sc_hd__decap_3
XFILLER_2_362 VGND VGND VPWR VPWR sky130_fd_sc_hd__fill_2
XTAP_TAPCELL_ROW_92_1190 VGND VPWR sky130_fd_sc_hd__tapvpwrvgnd_1
XFILLER_77_163 VGND VGND VPWR VPWR sky130_fd_sc_hd__fill_1
XFILLER_18_230 VGND VGND VPWR VPWR sky130_fd_sc_hd__decap_3
XFILLER_65_358 VGND VGND VPWR VPWR sky130_fd_sc_hd__decap_3
XFILLER_92_166 VGND VGND VPWR VPWR sky130_fd_sc_hd__fill_2
XFILLER_33_200 VGND VGND VPWR VPWR sky130_fd_sc_hd__decap_3
XFILLER_73_391 VGND VGND VPWR VPWR sky130_fd_sc_hd__fill_1
XFILLER_33_255 VGND VGND VPWR VPWR sky130_fd_sc_hd__decap_3
X_4751_ _6404_/A2 _4751_/A2 _4750_/Y VGND VGND VPWR VPWR _4751_/Y sky130_fd_sc_hd__a21oi_2
X_7470_ _7608_/CLK _7470_/D place2056/X VGND VGND VPWR VPWR _7470_/Q sky130_fd_sc_hd__dfrtp_2
Xplace1802 _4003_/A2 VGND VGND VPWR VPWR _4767_/B1 sky130_fd_sc_hd__buf_2
XTAP_TAPCELL_ROW_95_1219 VGND VPWR sky130_fd_sc_hd__tapvpwrvgnd_1
Xplace1835 _3995_/A1 VGND VGND VPWR VPWR _4767_/B2 sky130_fd_sc_hd__buf_2
Xplace1824 _4420_/B VGND VGND VPWR VPWR _4464_/B sky130_fd_sc_hd__buf_2
Xplace1813 _3543_/A VGND VGND VPWR VPWR _6708_/A2 sky130_fd_sc_hd__buf_2
X_3564_ _7323_/Q _3969_/D _3552_/Y _3563_/Y VGND VGND VPWR VPWR _3564_/Y sky130_fd_sc_hd__o211ai_4
Xplace1879 _3446_/B VGND VGND VPWR VPWR _3571_/A2 sky130_fd_sc_hd__buf_2
Xplace1868 _3519_/A VGND VGND VPWR VPWR _3581_/A sky130_fd_sc_hd__buf_2
Xplace1857 _4278_/A2 VGND VGND VPWR VPWR _6183_/B sky130_fd_sc_hd__buf_2
Xplace1846 _3490_/C VGND VGND VPWR VPWR _3931_/B sky130_fd_sc_hd__buf_2
X_3495_ _3495_/A1 _4473_/C _3490_/B VGND VGND VPWR VPWR _3598_/B sky130_fd_sc_hd__o21a_2
Xhold2504 _7065_/Q VGND VGND VPWR VPWR _5209_/A0 sky130_fd_sc_hd__dlygate4sd3_1
X_5234_ _5234_/A0 _4614_/X _5255_/S VGND VGND VPWR VPWR _7073_/D sky130_fd_sc_hd__mux2_2
Xhold2537 _6973_/Q VGND VGND VPWR VPWR _5009_/A0 sky130_fd_sc_hd__dlygate4sd3_1
Xhold2526 _6919_/Q VGND VGND VPWR VPWR _4885_/A0 sky130_fd_sc_hd__dlygate4sd3_1
Xhold2515 _6983_/Q VGND VGND VPWR VPWR _5030_/A0 sky130_fd_sc_hd__dlygate4sd3_1
XFILLER_29_517 VGND VGND VPWR VPWR sky130_fd_sc_hd__decap_3
Xhold2559 _7089_/Q VGND VGND VPWR VPWR _5284_/A0 sky130_fd_sc_hd__dlygate4sd3_1
Xhold2548 _7035_/Q VGND VGND VPWR VPWR _5144_/A0 sky130_fd_sc_hd__dlygate4sd3_1
XFILLER_83_166 VGND VGND VPWR VPWR sky130_fd_sc_hd__fill_2
X_4047_ _7304_/Q _7305_/Q _4050_/D VGND VGND VPWR VPWR _4051_/B sky130_fd_sc_hd__and3_2
XFILLER_24_211 VGND VGND VPWR VPWR sky130_fd_sc_hd__fill_1
XFILLER_24_233 VGND VGND VPWR VPWR sky130_fd_sc_hd__decap_3
XFILLER_24_244 VGND VGND VPWR VPWR sky130_fd_sc_hd__decap_3
X_5998_ _5998_/A VGND VGND VPWR VPWR _6010_/C sky130_fd_sc_hd__inv_2
X_4949_ _4949_/A0 _5532_/A1 _4964_/S VGND VGND VPWR VPWR _6948_/D sky130_fd_sc_hd__mux2_2
XTAP_TAPCELL_ROW_50_743 VGND VPWR sky130_fd_sc_hd__tapvpwrvgnd_1
XTAP_TAPCELL_ROW_22_456 VGND VPWR sky130_fd_sc_hd__tapvpwrvgnd_1
XFILLER_20_461 VGND VGND VPWR VPWR sky130_fd_sc_hd__decap_3
X_6619_ _6619_/A0 _6162_/X _6634_/S VGND VGND VPWR VPWR _7473_/D sky130_fd_sc_hd__mux2_4
X_7599_ _7606_/CLK _7599_/D place2050/X VGND VGND VPWR VPWR _7599_/Q sky130_fd_sc_hd__dfrtp_2
XFILLER_3_137 VGND VGND VPWR VPWR sky130_fd_sc_hd__fill_1
XFILLER_58_77 VGND VGND VPWR VPWR sky130_fd_sc_hd__decap_3
XFILLER_59_141 VGND VGND VPWR VPWR sky130_fd_sc_hd__fill_2
XFILLER_59_185 VGND VGND VPWR VPWR sky130_fd_sc_hd__decap_3
XFILLER_87_483 VGND VGND VPWR VPWR sky130_fd_sc_hd__fill_2
XTAP_TAPCELL_ROW_58_832 VGND VPWR sky130_fd_sc_hd__tapvpwrvgnd_1
XFILLER_47_358 VGND VGND VPWR VPWR sky130_fd_sc_hd__decap_3
XFILLER_74_144 VGND VGND VPWR VPWR sky130_fd_sc_hd__decap_3
XFILLER_15_288 VGND VGND VPWR VPWR sky130_fd_sc_hd__decap_3
XFILLER_30_214 VGND VGND VPWR VPWR sky130_fd_sc_hd__decap_3
XFILLER_7_443 VGND VGND VPWR VPWR sky130_fd_sc_hd__decap_3
XFILLER_7_465 VGND VGND VPWR VPWR sky130_fd_sc_hd__decap_3
Xplace1109 _5724_/A1 VGND VGND VPWR VPWR _5357_/A1 sky130_fd_sc_hd__buf_2
XFILLER_38_358 VGND VGND VPWR VPWR sky130_fd_sc_hd__decap_3
XFILLER_38_369 VGND VGND VPWR VPWR sky130_fd_sc_hd__decap_3
XFILLER_65_155 VGND VGND VPWR VPWR sky130_fd_sc_hd__decap_3
X_6970_ _7279_/CLK _6970_/D VGND VGND VPWR VPWR _6970_/Q sky130_fd_sc_hd__dfxtp_2
X_5921_ _6509_/B1 _6512_/C1 _5914_/X _5917_/X _5920_/X VGND VGND VPWR VPWR _5921_/X
+ sky130_fd_sc_hd__o311a_2
XFILLER_34_542 VGND VGND VPWR VPWR sky130_fd_sc_hd__decap_3
XFILLER_34_586 VGND VGND VPWR VPWR sky130_fd_sc_hd__fill_2
XFILLER_61_361 VGND VGND VPWR VPWR sky130_fd_sc_hd__decap_3
XFILLER_21_214 VGND VGND VPWR VPWR sky130_fd_sc_hd__decap_3
XFILLER_21_225 VGND VGND VPWR VPWR sky130_fd_sc_hd__decap_3
XFILLER_21_247 VGND VGND VPWR VPWR sky130_fd_sc_hd__fill_2
XFILLER_21_269 VGND VGND VPWR VPWR sky130_fd_sc_hd__decap_3
X_7522_ clkload6/A _7522_/D place2030/X VGND VGND VPWR VPWR _7522_/Q sky130_fd_sc_hd__dfrtp_2
X_4734_ _3508_/C _4734_/A2 _4734_/A3 _5839_/B1 _6010_/D VGND VGND VPWR VPWR _4734_/X
+ sky130_fd_sc_hd__a311o_2
XFILLER_9_93 VGND VGND VPWR VPWR sky130_fd_sc_hd__decap_3
X_7453_ clkload2/A _7453_/D place2027/X VGND VGND VPWR VPWR _7453_/Q sky130_fd_sc_hd__dfrtp_2
X_4665_ _4665_/A0 _5635_/A1 _4665_/S VGND VGND VPWR VPWR _6855_/D sky130_fd_sc_hd__mux2_2
Xplace1610 _3981_/A VGND VGND VPWR VPWR _4012_/A1 sky130_fd_sc_hd__buf_2
X_7384_ _7507_/CLK _7384_/D place2045/X VGND VGND VPWR VPWR _7384_/Q sky130_fd_sc_hd__dfrtp_2
X_6404_ _6403_/X _6404_/A2 _6404_/B1 _6083_/Y VGND VGND VPWR VPWR _6404_/X sky130_fd_sc_hd__a211o_2
Xplace1621 _6489_/A1 VGND VGND VPWR VPWR _4970_/A sky130_fd_sc_hd__buf_2
Xplace1632 _3881_/B VGND VGND VPWR VPWR _3865_/B sky130_fd_sc_hd__buf_2
Xplace1643 _3598_/X VGND VGND VPWR VPWR _3816_/B1 sky130_fd_sc_hd__buf_2
Xplace1654 _3576_/B VGND VGND VPWR VPWR _3949_/A2 sky130_fd_sc_hd__buf_6
X_6335_ _7411_/Q _6344_/A2 _6335_/A3 _6344_/B1 _6335_/B2 VGND VGND VPWR VPWR _7379_/D
+ sky130_fd_sc_hd__a32o_2
X_3547_ _3547_/A _3547_/B _7421_/Q _3547_/D VGND VGND VPWR VPWR _3549_/C sky130_fd_sc_hd__nand4_2
XFILLER_103_503 VGND VGND VPWR VPWR sky130_fd_sc_hd__fill_1
Xhold3002 _6359_/X VGND VGND VPWR VPWR _7392_/D sky130_fd_sc_hd__dlygate4sd3_1
Xhold3013 _7563_/Q VGND VGND VPWR VPWR _6809_/B sky130_fd_sc_hd__dlygate4sd3_1
Xhold3024 _7536_/Q VGND VGND VPWR VPWR _4501_/A1 sky130_fd_sc_hd__dlygate4sd3_1
Xplace1665 _3817_/A3 VGND VGND VPWR VPWR _6346_/A3 sky130_fd_sc_hd__buf_2
Xplace1676 _6411_/A3 VGND VGND VPWR VPWR _6388_/A3 sky130_fd_sc_hd__buf_2
Xplace1687 _3441_/X VGND VGND VPWR VPWR _4313_/B sky130_fd_sc_hd__buf_2
XFILLER_0_129 VGND VGND VPWR VPWR sky130_fd_sc_hd__decap_3
XFILLER_103_536 VGND VGND VPWR VPWR sky130_fd_sc_hd__decap_3
Xhold3035 _7519_/Q VGND VGND VPWR VPWR _4329_/A1 sky130_fd_sc_hd__dlygate4sd3_1
Xhold3046 _7503_/Q VGND VGND VPWR VPWR _6683_/A0 sky130_fd_sc_hd__dlygate4sd3_1
Xplace1698 _3574_/Y VGND VGND VPWR VPWR _3578_/A1 sky130_fd_sc_hd__buf_2
X_3478_ _3543_/B _3478_/B _3478_/C VGND VGND VPWR VPWR _3478_/Y sky130_fd_sc_hd__nor3_4
X_6197_ _6195_/X _6196_/X _6457_/B1 _4114_/Y VGND VGND VPWR VPWR _6198_/C sky130_fd_sc_hd__a211o_2
XFILLER_28_47 VGND VGND VPWR VPWR sky130_fd_sc_hd__decap_3
XFILLER_29_314 VGND VGND VPWR VPWR sky130_fd_sc_hd__decap_3
XFILLER_56_111 VGND VGND VPWR VPWR sky130_fd_sc_hd__decap_3
Xhold2389 _7114_/Q VGND VGND VPWR VPWR _5344_/A0 sky130_fd_sc_hd__dlygate4sd3_1
Xhold2378 _7148_/Q VGND VGND VPWR VPWR _5419_/A0 sky130_fd_sc_hd__dlygate4sd3_1
X_5148_ _5148_/A0 _5296_/A1 _5152_/S VGND VGND VPWR VPWR _7037_/D sky130_fd_sc_hd__mux2_2
XFILLER_28_69 VGND VGND VPWR VPWR sky130_fd_sc_hd__decap_3
XFILLER_56_144 VGND VGND VPWR VPWR sky130_fd_sc_hd__decap_3
X_5079_ _5079_/A0 _5351_/A1 _5089_/S VGND VGND VPWR VPWR _7005_/D sky130_fd_sc_hd__mux2_2
XFILLER_84_475 VGND VGND VPWR VPWR sky130_fd_sc_hd__fill_1
XTAP_TAPCELL_ROW_55_802 VGND VPWR sky130_fd_sc_hd__tapvpwrvgnd_1
XTAP_TAPCELL_ROW_27_504 VGND VPWR sky130_fd_sc_hd__tapvpwrvgnd_1
XFILLER_44_24 VGND VGND VPWR VPWR sky130_fd_sc_hd__decap_3
XFILLER_12_203 VGND VGND VPWR VPWR sky130_fd_sc_hd__decap_3
XTAP_TAPCELL_ROW_35_592 VGND VPWR sky130_fd_sc_hd__tapvpwrvgnd_1
XFILLER_100_85 VGND VGND VPWR VPWR sky130_fd_sc_hd__decap_3
XFILLER_40_589 VGND VGND VPWR VPWR sky130_fd_sc_hd__fill_1
XFILLER_4_402 VGND VGND VPWR VPWR sky130_fd_sc_hd__fill_1
XFILLER_4_424 VGND VGND VPWR VPWR sky130_fd_sc_hd__fill_1
XFILLER_4_468 VGND VGND VPWR VPWR sky130_fd_sc_hd__decap_3
XFILLER_69_32 VGND VGND VPWR VPWR sky130_fd_sc_hd__decap_3
XFILLER_69_65 VGND VGND VPWR VPWR sky130_fd_sc_hd__fill_2
XFILLER_79_247 VGND VGND VPWR VPWR sky130_fd_sc_hd__fill_2
XTAP_TAPCELL_ROW_7_295 VGND VPWR sky130_fd_sc_hd__tapvpwrvgnd_1
XFILLER_47_133 VGND VGND VPWR VPWR sky130_fd_sc_hd__decap_3
XFILLER_85_75 VGND VGND VPWR VPWR sky130_fd_sc_hd__fill_1
Xhold2890 _7385_/Q VGND VGND VPWR VPWR _6344_/B2 sky130_fd_sc_hd__dlygate4sd3_1
XFILLER_35_306 VGND VGND VPWR VPWR sky130_fd_sc_hd__decap_3
XFILLER_47_166 VGND VGND VPWR VPWR sky130_fd_sc_hd__fill_2
XFILLER_47_199 VGND VGND VPWR VPWR sky130_fd_sc_hd__decap_3
XFILLER_62_125 VGND VGND VPWR VPWR sky130_fd_sc_hd__decap_3
XFILLER_31_501 VGND VGND VPWR VPWR sky130_fd_sc_hd__decap_3
XFILLER_50_309 VGND VGND VPWR VPWR sky130_fd_sc_hd__decap_3
XFILLER_31_523 VGND VGND VPWR VPWR sky130_fd_sc_hd__decap_3
XFILLER_31_578 VGND VGND VPWR VPWR sky130_fd_sc_hd__decap_3
XFILLER_7_251 VGND VGND VPWR VPWR sky130_fd_sc_hd__decap_3
XFILLER_7_284 VGND VGND VPWR VPWR sky130_fd_sc_hd__decap_3
X_4450_ _4450_/A _4460_/B VGND VGND VPWR VPWR _4450_/Y sky130_fd_sc_hd__xnor2_2
XFILLER_98_501 VGND VGND VPWR VPWR sky130_fd_sc_hd__decap_3
X_6120_ _6139_/A1 _6887_/Q _7279_/Q _6397_/B2 VGND VGND VPWR VPWR _6120_/X sky130_fd_sc_hd__o22a_2
XPHY_EDGE_ROW_0_Left_104 VGND VGND VPWR VPWR sky130_fd_sc_hd__decap_3
X_6051_ _6049_/X _6050_/X _5765_/X VGND VGND VPWR VPWR _6055_/C sky130_fd_sc_hd__a21oi_2
XTAP_TAPCELL_ROW_69_949 VGND VPWR sky130_fd_sc_hd__tapvpwrvgnd_1
XFILLER_38_133 VGND VGND VPWR VPWR sky130_fd_sc_hd__decap_3
XFILLER_78_291 VGND VGND VPWR VPWR sky130_fd_sc_hd__decap_3
XFILLER_26_328 VGND VGND VPWR VPWR sky130_fd_sc_hd__decap_3
XFILLER_26_339 VGND VGND VPWR VPWR sky130_fd_sc_hd__decap_3
XFILLER_53_125 VGND VGND VPWR VPWR sky130_fd_sc_hd__decap_3
X_6953_ _7287_/CLK _6953_/D VGND VGND VPWR VPWR _6953_/Q sky130_fd_sc_hd__dfxtp_2
XFILLER_22_501 VGND VGND VPWR VPWR sky130_fd_sc_hd__decap_3
XFILLER_34_361 VGND VGND VPWR VPWR sky130_fd_sc_hd__decap_3
XFILLER_41_309 VGND VGND VPWR VPWR sky130_fd_sc_hd__decap_3
Xclkbuf_3_5__f_clk clkbuf_0_clk/X VGND VGND VPWR VPWR clkbuf_leaf_9_clk/A sky130_fd_sc_hd__clkbuf_8
X_6884_ _7276_/CLK _6884_/D VGND VGND VPWR VPWR _6884_/Q sky130_fd_sc_hd__dfxtp_2
X_5904_ _5900_/X _5899_/X _6153_/B1 _6156_/C1 VGND VGND VPWR VPWR _5908_/A sky130_fd_sc_hd__a211o_4
XFILLER_34_383 VGND VGND VPWR VPWR sky130_fd_sc_hd__decap_3
X_5835_ _5833_/X _5834_/X _5093_/C VGND VGND VPWR VPWR _5835_/Y sky130_fd_sc_hd__o21ai_2
XFILLER_22_545 VGND VGND VPWR VPWR sky130_fd_sc_hd__decap_3
XFILLER_22_578 VGND VGND VPWR VPWR sky130_fd_sc_hd__decap_3
XFILLER_22_589 VGND VGND VPWR VPWR sky130_fd_sc_hd__fill_1
XTAP_TAPCELL_ROW_32_562 VGND VPWR sky130_fd_sc_hd__tapvpwrvgnd_1
X_7505_ clkload3/A _7505_/D place2057/X VGND VGND VPWR VPWR _7505_/Q sky130_fd_sc_hd__dfrtp_2
XFILLER_30_37 VGND VGND VPWR VPWR sky130_fd_sc_hd__decap_3
X_7436_ _7610_/CLK _7436_/D place2057/X VGND VGND VPWR VPWR _7436_/Q sky130_fd_sc_hd__dfrtp_2
X_4648_ _4675_/B _6437_/B1 _4648_/B1 VGND VGND VPWR VPWR _4648_/Y sky130_fd_sc_hd__o21ai_2
Xplace1440 _3928_/Y VGND VGND VPWR VPWR _4404_/B1 sky130_fd_sc_hd__buf_2
Xplace1451 _3821_/B VGND VGND VPWR VPWR _4201_/B sky130_fd_sc_hd__buf_2
Xplace1462 _4261_/C VGND VGND VPWR VPWR _4751_/A2 sky130_fd_sc_hd__buf_2
X_7367_ clkload9/A _7367_/D place2018/X VGND VGND VPWR VPWR _7367_/Q sky130_fd_sc_hd__dfrtp_2
X_4579_ _4579_/A _4579_/B _4579_/C _4579_/D VGND VGND VPWR VPWR _4842_/C sky130_fd_sc_hd__nand4_4
XPHY_EDGE_ROW_55_Left_159 VGND VGND VPWR VPWR sky130_fd_sc_hd__decap_3
Xplace1473 _5841_/X VGND VGND VPWR VPWR _6495_/A2 sky130_fd_sc_hd__buf_2
Xplace1484 _3998_/Y VGND VGND VPWR VPWR _4720_/C sky130_fd_sc_hd__buf_2
Xplace1495 _3896_/B VGND VGND VPWR VPWR _4437_/B1 sky130_fd_sc_hd__buf_2
X_7298_ clkload5/A _7298_/D place2062/X VGND VGND VPWR VPWR _7298_/Q sky130_fd_sc_hd__dfrtp_2
X_6318_ _6367_/B2 _6324_/A2 _6322_/A3 _6324_/B1 _6318_/B2 VGND VGND VPWR VPWR _7365_/D
+ sky130_fd_sc_hd__a32o_2
XFILLER_89_578 VGND VGND VPWR VPWR sky130_fd_sc_hd__fill_2
XFILLER_103_399 VGND VGND VPWR VPWR sky130_fd_sc_hd__fill_1
XFILLER_39_68 VGND VGND VPWR VPWR sky130_fd_sc_hd__decap_3
XTAP_TAPCELL_ROW_4_265 VGND VPWR sky130_fd_sc_hd__tapvpwrvgnd_1
XFILLER_29_177 VGND VGND VPWR VPWR sky130_fd_sc_hd__decap_3
XFILLER_44_103 VGND VGND VPWR VPWR sky130_fd_sc_hd__fill_1
XFILLER_29_199 VGND VGND VPWR VPWR sky130_fd_sc_hd__decap_3
XFILLER_55_45 VGND VGND VPWR VPWR sky130_fd_sc_hd__decap_3
XFILLER_72_434 VGND VGND VPWR VPWR sky130_fd_sc_hd__fill_1
XPHY_EDGE_ROW_64_Left_168 VGND VGND VPWR VPWR sky130_fd_sc_hd__decap_3
XFILLER_40_353 VGND VGND VPWR VPWR sky130_fd_sc_hd__fill_2
XFILLER_52_191 VGND VGND VPWR VPWR sky130_fd_sc_hd__decap_3
XFILLER_71_55 VGND VGND VPWR VPWR sky130_fd_sc_hd__fill_1
XFILLER_9_505 VGND VGND VPWR VPWR sky130_fd_sc_hd__decap_3
XTAP_TAPCELL_ROW_78_1044 VGND VPWR sky130_fd_sc_hd__tapvpwrvgnd_1
XFILLER_4_276 VGND VGND VPWR VPWR sky130_fd_sc_hd__decap_3
XPHY_EDGE_ROW_73_Left_177 VGND VGND VPWR VPWR sky130_fd_sc_hd__decap_3
XFILLER_4_287 VGND VGND VPWR VPWR sky130_fd_sc_hd__decap_3
XFILLER_67_217 VGND VGND VPWR VPWR sky130_fd_sc_hd__decap_3
XFILLER_96_85 VGND VGND VPWR VPWR sky130_fd_sc_hd__decap_3
XFILLER_48_453 VGND VGND VPWR VPWR sky130_fd_sc_hd__decap_3
XTAP_TAPCELL_ROW_66_919 VGND VPWR sky130_fd_sc_hd__tapvpwrvgnd_1
XFILLER_75_261 VGND VGND VPWR VPWR sky130_fd_sc_hd__fill_2
XTAP_TAPCELL_ROW_89_1162 VGND VPWR sky130_fd_sc_hd__tapvpwrvgnd_1
XFILLER_23_309 VGND VGND VPWR VPWR sky130_fd_sc_hd__decap_3
XFILLER_35_169 VGND VGND VPWR VPWR sky130_fd_sc_hd__decap_3
XPHY_EDGE_ROW_82_Left_186 VGND VGND VPWR VPWR sky130_fd_sc_hd__decap_3
X_3950_ _7519_/Q _3950_/A2 _3965_/B1 _7455_/Q VGND VGND VPWR VPWR _3951_/C sky130_fd_sc_hd__a22oi_2
XTAP_TAPCELL_ROW_74_996 VGND VPWR sky130_fd_sc_hd__tapvpwrvgnd_1
X_3881_ _7496_/Q _3881_/B VGND VGND VPWR VPWR _3882_/C sky130_fd_sc_hd__nand2_2
XFILLER_31_386 VGND VGND VPWR VPWR sky130_fd_sc_hd__decap_3
X_5620_ _5620_/A0 _5681_/A1 _5637_/S VGND VGND VPWR VPWR _7240_/D sky130_fd_sc_hd__mux2_2
XFILLER_31_397 VGND VGND VPWR VPWR sky130_fd_sc_hd__decap_3
X_5551_ _5551_/A0 _5612_/A1 _5574_/S VGND VGND VPWR VPWR _7208_/D sky130_fd_sc_hd__mux2_2
XPHY_EDGE_ROW_91_Left_195 VGND VGND VPWR VPWR sky130_fd_sc_hd__decap_3
X_7221_ _7407_/CLK _7221_/D VGND VGND VPWR VPWR _7221_/Q sky130_fd_sc_hd__dfxtp_2
X_5482_ _5482_/A0 _5726_/A1 _5486_/S VGND VGND VPWR VPWR _7177_/D sky130_fd_sc_hd__mux2_2
XFILLER_6_83 VGND VGND VPWR VPWR sky130_fd_sc_hd__fill_1
X_4433_ _4475_/S _4433_/B _4433_/C VGND VGND VPWR VPWR _4433_/X sky130_fd_sc_hd__or3_2
X_7152_ _7264_/CLK _7152_/D VGND VGND VPWR VPWR _7152_/Q sky130_fd_sc_hd__dfxtp_2
X_4364_ _4306_/A _4306_/B _4306_/C _7587_/D _4325_/B VGND VGND VPWR VPWR _4364_/X
+ sky130_fd_sc_hd__a311o_2
X_7083_ _7114_/CLK _7083_/D VGND VGND VPWR VPWR _7083_/Q sky130_fd_sc_hd__dfxtp_2
X_4295_ _4296_/A _4295_/A2 _4295_/B1 _4292_/Y VGND VGND VPWR VPWR _4295_/Y sky130_fd_sc_hd__o211ai_2
X_6034_ _6504_/A2 _6879_/Q _7271_/Q _6501_/A1 VGND VGND VPWR VPWR _6034_/X sky130_fd_sc_hd__o22a_2
XFILLER_66_272 VGND VGND VPWR VPWR sky130_fd_sc_hd__decap_3
XFILLER_94_592 VGND VGND VPWR VPWR sky130_fd_sc_hd__fill_2
XTAP_TAPCELL_ROW_37_610 VGND VPWR sky130_fd_sc_hd__tapvpwrvgnd_1
XTAP_TAPCELL_ROW_1_235 VGND VPWR sky130_fd_sc_hd__tapvpwrvgnd_1
XFILLER_26_147 VGND VGND VPWR VPWR sky130_fd_sc_hd__fill_1
X_6936_ _7272_/CLK _6936_/D VGND VGND VPWR VPWR _6936_/Q sky130_fd_sc_hd__dfxtp_2
XFILLER_25_48 VGND VGND VPWR VPWR sky130_fd_sc_hd__decap_3
XFILLER_41_106 VGND VGND VPWR VPWR sky130_fd_sc_hd__fill_2
X_6867_ _7289_/CLK _6867_/D VGND VGND VPWR VPWR _6867_/Q sky130_fd_sc_hd__dfxtp_2
X_6798_ _6840_/A _6798_/B VGND VGND VPWR VPWR _7557_/D sky130_fd_sc_hd__and2_2
X_5818_ _6397_/A1 _6885_/Q _7277_/Q _6397_/B2 VGND VGND VPWR VPWR _5818_/X sky130_fd_sc_hd__o22a_2
XFILLER_10_548 VGND VGND VPWR VPWR sky130_fd_sc_hd__fill_1
X_7419_ _7514_/CLK _7419_/D place2044/X VGND VGND VPWR VPWR _7419_/Q sky130_fd_sc_hd__dfrtp_2
XTAP_TAPCELL_ROW_9_313 VGND VPWR sky130_fd_sc_hd__tapvpwrvgnd_1
Xplace1270 _6396_/A1 VGND VGND VPWR VPWR _6146_/B1 sky130_fd_sc_hd__buf_4
XFILLER_1_246 VGND VGND VPWR VPWR sky130_fd_sc_hd__decap_3
Xplace1281 _6483_/B2 VGND VGND VPWR VPWR _6510_/B2 sky130_fd_sc_hd__buf_2
Xplace1292 _6171_/A2 VGND VGND VPWR VPWR _6455_/B2 sky130_fd_sc_hd__buf_8
XFILLER_103_185 VGND VGND VPWR VPWR sky130_fd_sc_hd__decap_3
XFILLER_49_206 VGND VGND VPWR VPWR sky130_fd_sc_hd__fill_1
XFILLER_49_239 VGND VGND VPWR VPWR sky130_fd_sc_hd__decap_3
XFILLER_89_397 VGND VGND VPWR VPWR sky130_fd_sc_hd__fill_1
XFILLER_66_55 VGND VGND VPWR VPWR sky130_fd_sc_hd__decap_3
XFILLER_45_434 VGND VGND VPWR VPWR sky130_fd_sc_hd__fill_2
XFILLER_45_445 VGND VGND VPWR VPWR sky130_fd_sc_hd__decap_3
XFILLER_17_169 VGND VGND VPWR VPWR sky130_fd_sc_hd__fill_1
XFILLER_45_478 VGND VGND VPWR VPWR sky130_fd_sc_hd__decap_3
XFILLER_72_253 VGND VGND VPWR VPWR sky130_fd_sc_hd__decap_3
XFILLER_82_32 VGND VGND VPWR VPWR sky130_fd_sc_hd__fill_1
XFILLER_13_331 VGND VGND VPWR VPWR sky130_fd_sc_hd__decap_3
XFILLER_25_180 VGND VGND VPWR VPWR sky130_fd_sc_hd__decap_3
XTAP_TAPCELL_ROW_71_966 VGND VPWR sky130_fd_sc_hd__tapvpwrvgnd_1
XTAP_TAPCELL_ROW_43_679 VGND VPWR sky130_fd_sc_hd__tapvpwrvgnd_1
XFILLER_9_335 VGND VGND VPWR VPWR sky130_fd_sc_hd__fill_1
X_4080_ _4542_/B _4085_/D VGND VGND VPWR VPWR _7607_/D sky130_fd_sc_hd__xor2_2
XFILLER_48_294 VGND VGND VPWR VPWR sky130_fd_sc_hd__decap_3
XFILLER_76_592 VGND VGND VPWR VPWR sky130_fd_sc_hd__decap_3
XFILLER_24_607 VGND VGND VPWR VPWR sky130_fd_sc_hd__decap_3
XFILLER_16_191 VGND VGND VPWR VPWR sky130_fd_sc_hd__decap_3
X_3933_ _6313_/B2 _4150_/A2 _3993_/B1 _7395_/Q _3932_/X VGND VGND VPWR VPWR _3935_/A
+ sky130_fd_sc_hd__a221oi_2
X_3864_ _7529_/Q _3909_/A2 _3863_/X VGND VGND VPWR VPWR _3864_/X sky130_fd_sc_hd__a21o_2
XFILLER_31_172 VGND VGND VPWR VPWR sky130_fd_sc_hd__decap_3
XTAP_TAPCELL_ROW_14_370 VGND VPWR sky130_fd_sc_hd__tapvpwrvgnd_1
X_6583_ _6583_/A0 _5863_/X _6590_/S VGND VGND VPWR VPWR _7456_/D sky130_fd_sc_hd__mux2_2
X_3795_ _7309_/Q _4211_/A _3790_/Y VGND VGND VPWR VPWR _3795_/Y sky130_fd_sc_hd__a21oi_2
X_5465_ _5465_/A0 _4707_/X _5471_/S VGND VGND VPWR VPWR _7169_/D sky130_fd_sc_hd__mux2_2
X_7204_ _7288_/CLK _7204_/D VGND VGND VPWR VPWR _7204_/Q sky130_fd_sc_hd__dfxtp_2
X_4416_ _4416_/A _4416_/B _4430_/A _4430_/B VGND VGND VPWR VPWR _4416_/Y sky130_fd_sc_hd__nand4_2
X_7135_ _7247_/CLK _7135_/D VGND VGND VPWR VPWR _7135_/Q sky130_fd_sc_hd__dfxtp_2
X_5396_ _5396_/A0 _5701_/A1 _5410_/S VGND VGND VPWR VPWR _7137_/D sky130_fd_sc_hd__mux2_2
XFILLER_86_334 VGND VGND VPWR VPWR sky130_fd_sc_hd__decap_3
X_7066_ _7290_/CLK _7066_/D VGND VGND VPWR VPWR _7066_/Q sky130_fd_sc_hd__dfxtp_2
X_4278_ _6183_/A _4278_/A2 _4300_/A3 _4276_/X _6559_/D1 VGND VGND VPWR VPWR _4278_/X
+ sky130_fd_sc_hd__o311a_4
X_6017_ _6229_/A1 _6229_/A2 _6229_/B1 _7588_/Q _6016_/X VGND VGND VPWR VPWR _6017_/X
+ sky130_fd_sc_hd__o221a_2
XFILLER_27_456 VGND VGND VPWR VPWR sky130_fd_sc_hd__decap_3
XFILLER_27_489 VGND VGND VPWR VPWR sky130_fd_sc_hd__decap_3
XFILLER_54_297 VGND VGND VPWR VPWR sky130_fd_sc_hd__decap_3
X_6919_ _7577_/CLK _6919_/D VGND VGND VPWR VPWR _6919_/Q sky130_fd_sc_hd__dfxtp_2
XFILLER_22_161 VGND VGND VPWR VPWR sky130_fd_sc_hd__decap_3
XFILLER_52_35 VGND VGND VPWR VPWR sky130_fd_sc_hd__decap_3
XFILLER_10_334 VGND VGND VPWR VPWR sky130_fd_sc_hd__fill_1
XTAP_TAPCELL_ROW_40_638 VGND VPWR sky130_fd_sc_hd__tapvpwrvgnd_1
XTAP_TAPCELL_ROW_75_1014 VGND VPWR sky130_fd_sc_hd__tapvpwrvgnd_1
XFILLER_2_533 VGND VGND VPWR VPWR sky130_fd_sc_hd__decap_3
XFILLER_2_577 VGND VGND VPWR VPWR sky130_fd_sc_hd__decap_3
XFILLER_77_32 VGND VGND VPWR VPWR sky130_fd_sc_hd__fill_2
XFILLER_37_209 VGND VGND VPWR VPWR sky130_fd_sc_hd__decap_3
XTAP_TAPCELL_ROW_48_727 VGND VPWR sky130_fd_sc_hd__tapvpwrvgnd_1
XFILLER_93_20 VGND VGND VPWR VPWR sky130_fd_sc_hd__fill_2
XTAP_TAPCELL_ROW_86_1121 VGND VPWR sky130_fd_sc_hd__tapvpwrvgnd_1
XFILLER_45_231 VGND VGND VPWR VPWR sky130_fd_sc_hd__decap_3
XFILLER_33_437 VGND VGND VPWR VPWR sky130_fd_sc_hd__fill_2
XFILLER_45_275 VGND VGND VPWR VPWR sky130_fd_sc_hd__decap_3
XFILLER_60_212 VGND VGND VPWR VPWR sky130_fd_sc_hd__decap_3
XFILLER_26_91 VGND VGND VPWR VPWR sky130_fd_sc_hd__fill_1
XFILLER_60_256 VGND VGND VPWR VPWR sky130_fd_sc_hd__decap_3
XFILLER_60_278 VGND VGND VPWR VPWR sky130_fd_sc_hd__decap_3
XFILLER_13_183 VGND VGND VPWR VPWR sky130_fd_sc_hd__decap_3
XFILLER_9_132 VGND VGND VPWR VPWR sky130_fd_sc_hd__decap_3
XTAP_TAPCELL_ROW_11_340 VGND VPWR sky130_fd_sc_hd__tapvpwrvgnd_1
X_3580_ _4395_/A1 _3567_/Y _3563_/B _3568_/Y _3579_/X VGND VGND VPWR VPWR _3580_/Y
+ sky130_fd_sc_hd__o2111ai_4
X_4201_ _4201_/A _4201_/B VGND VGND VPWR VPWR _4202_/A sky130_fd_sc_hd__and2_2
XFILLER_68_312 VGND VGND VPWR VPWR sky130_fd_sc_hd__decap_3
Xhold2708 _7084_/Q VGND VGND VPWR VPWR _5268_/A0 sky130_fd_sc_hd__dlygate4sd3_1
Xhold2719 _6899_/Q VGND VGND VPWR VPWR _4840_/A0 sky130_fd_sc_hd__dlygate4sd3_1
X_5181_ _5181_/A0 _4670_/X _5181_/S VGND VGND VPWR VPWR _7052_/D sky130_fd_sc_hd__mux2_2
X_4132_ _4002_/A _4002_/B _4134_/A _4110_/A VGND VGND VPWR VPWR _4132_/X sky130_fd_sc_hd__a2bb2o_2
X_4063_ _4067_/A _4499_/C _7312_/Q VGND VGND VPWR VPWR _4065_/A sky130_fd_sc_hd__a21oi_2
XFILLER_95_197 VGND VGND VPWR VPWR sky130_fd_sc_hd__fill_2
XFILLER_36_253 VGND VGND VPWR VPWR sky130_fd_sc_hd__decap_3
XFILLER_51_212 VGND VGND VPWR VPWR sky130_fd_sc_hd__decap_3
XFILLER_36_297 VGND VGND VPWR VPWR sky130_fd_sc_hd__decap_3
X_6704_ _6704_/A0 _6566_/Y _6704_/S VGND VGND VPWR VPWR _7513_/D sky130_fd_sc_hd__mux2_2
X_3916_ _3916_/A _3916_/B VGND VGND VPWR VPWR _3916_/Y sky130_fd_sc_hd__xnor2_2
XFILLER_32_492 VGND VGND VPWR VPWR sky130_fd_sc_hd__decap_3
X_4896_ _4896_/A0 _4757_/Y _4896_/S VGND VGND VPWR VPWR _6924_/D sky130_fd_sc_hd__mux2_2
X_3847_ _7563_/Q _3846_/X _3844_/A _3490_/X _7435_/Q VGND VGND VPWR VPWR _3847_/X
+ sky130_fd_sc_hd__a32o_2
XTAP_TAPCELL_ROW_102_1298 VGND VPWR sky130_fd_sc_hd__tapvpwrvgnd_1
X_6566_ _6564_/Y _6566_/A2 _6565_/Y VGND VGND VPWR VPWR _6566_/Y sky130_fd_sc_hd__a21oi_2
X_3778_ _7504_/Q _3810_/A2 _3810_/B1 _7440_/Q _3777_/X VGND VGND VPWR VPWR _3778_/Y
+ sky130_fd_sc_hd__a221oi_2
X_6497_ _6497_/A0 _6496_/X _6497_/S VGND VGND VPWR VPWR _7427_/D sky130_fd_sc_hd__mux2_2
X_5448_ _5448_/A0 _5570_/A1 _5452_/S VGND VGND VPWR VPWR _7161_/D sky130_fd_sc_hd__mux2_2
X_5379_ _5379_/A0 _5684_/A1 _5425_/S VGND VGND VPWR VPWR _7129_/D sky130_fd_sc_hd__mux2_2
X_7118_ _7291_/CLK _7118_/D VGND VGND VPWR VPWR _7118_/Q sky130_fd_sc_hd__dfxtp_2
XFILLER_47_24 VGND VGND VPWR VPWR sky130_fd_sc_hd__fill_2
XFILLER_59_378 VGND VGND VPWR VPWR sky130_fd_sc_hd__decap_3
X_7049_ _7273_/CLK _7049_/D VGND VGND VPWR VPWR _7049_/Q sky130_fd_sc_hd__dfxtp_2
XFILLER_47_57 VGND VGND VPWR VPWR sky130_fd_sc_hd__fill_2
XFILLER_86_197 VGND VGND VPWR VPWR sky130_fd_sc_hd__fill_1
XPHY_EDGE_ROW_29_Right_29 VGND VGND VPWR VPWR sky130_fd_sc_hd__decap_3
XFILLER_103_85 VGND VGND VPWR VPWR sky130_fd_sc_hd__fill_2
XFILLER_42_212 VGND VGND VPWR VPWR sky130_fd_sc_hd__decap_3
XFILLER_42_278 VGND VGND VPWR VPWR sky130_fd_sc_hd__decap_3
XFILLER_8_29 VGND VGND VPWR VPWR sky130_fd_sc_hd__fill_2
XTAP_TAPCELL_ROW_81_1073 VGND VPWR sky130_fd_sc_hd__tapvpwrvgnd_1
XTAP_TAPCELL_ROW_25_487 VGND VPWR sky130_fd_sc_hd__tapvpwrvgnd_1
XPHY_EDGE_ROW_38_Right_38 VGND VGND VPWR VPWR sky130_fd_sc_hd__decap_3
XFILLER_6_113 VGND VGND VPWR VPWR sky130_fd_sc_hd__decap_3
XFILLER_10_197 VGND VGND VPWR VPWR sky130_fd_sc_hd__fill_2
XFILLER_12_71 VGND VGND VPWR VPWR sky130_fd_sc_hd__decap_3
XFILLER_12_82 VGND VGND VPWR VPWR sky130_fd_sc_hd__fill_2
XTAP_TAPCELL_ROW_92_1191 VGND VPWR sky130_fd_sc_hd__tapvpwrvgnd_1
XFILLER_38_507 VGND VGND VPWR VPWR sky130_fd_sc_hd__decap_3
XFILLER_77_142 VGND VGND VPWR VPWR sky130_fd_sc_hd__decap_3
XPHY_EDGE_ROW_47_Right_47 VGND VGND VPWR VPWR sky130_fd_sc_hd__decap_3
XFILLER_18_242 VGND VGND VPWR VPWR sky130_fd_sc_hd__decap_3
XFILLER_18_253 VGND VGND VPWR VPWR sky130_fd_sc_hd__decap_3
XFILLER_18_286 VGND VGND VPWR VPWR sky130_fd_sc_hd__decap_3
XFILLER_33_212 VGND VGND VPWR VPWR sky130_fd_sc_hd__decap_3
XFILLER_37_90 VGND VGND VPWR VPWR sky130_fd_sc_hd__decap_3
XFILLER_33_234 VGND VGND VPWR VPWR sky130_fd_sc_hd__decap_3
XPHY_EDGE_ROW_56_Right_56 VGND VGND VPWR VPWR sky130_fd_sc_hd__decap_3
X_4750_ _4750_/A1 _4613_/X _6010_/D _4749_/X VGND VGND VPWR VPWR _4750_/Y sky130_fd_sc_hd__a31oi_2
X_3701_ _3701_/A _3701_/B VGND VGND VPWR VPWR _3741_/A sky130_fd_sc_hd__nor2_2
X_6420_ _7422_/Q _5857_/X _6497_/S VGND VGND VPWR VPWR _7422_/D sky130_fd_sc_hd__mux2_2
X_3632_ _4745_/A2 _4253_/A _4244_/B1 _4567_/B VGND VGND VPWR VPWR _3742_/A sky130_fd_sc_hd__o22a_2
Xplace1803 _4707_/A3 VGND VGND VPWR VPWR _3815_/A2 sky130_fd_sc_hd__buf_2
Xplace1836 _3815_/A1 VGND VGND VPWR VPWR _4707_/A2 sky130_fd_sc_hd__buf_2
Xplace1825 _3939_/X VGND VGND VPWR VPWR _4352_/A sky130_fd_sc_hd__buf_2
Xplace1814 _3478_/B VGND VGND VPWR VPWR _3543_/A sky130_fd_sc_hd__buf_2
X_5302_ _5302_/A0 _5730_/A1 _5302_/S VGND VGND VPWR VPWR _7095_/D sky130_fd_sc_hd__mux2_2
X_3563_ _3563_/A _3563_/B _3563_/C _3969_/D VGND VGND VPWR VPWR _3563_/Y sky130_fd_sc_hd__nand4_4
Xplace1869 _3430_/Y VGND VGND VPWR VPWR _3440_/B1 sky130_fd_sc_hd__buf_2
Xplace1858 _5839_/A2 VGND VGND VPWR VPWR _4278_/A2 sky130_fd_sc_hd__buf_2
Xplace1847 _3490_/B VGND VGND VPWR VPWR _4362_/A sky130_fd_sc_hd__buf_2
X_3494_ _3844_/A _3843_/B _3499_/B _4352_/B _3493_/X VGND VGND VPWR VPWR _3598_/C
+ sky130_fd_sc_hd__o2111ai_2
XFILLER_88_418 VGND VGND VPWR VPWR sky130_fd_sc_hd__fill_2
XPHY_EDGE_ROW_65_Right_65 VGND VGND VPWR VPWR sky130_fd_sc_hd__decap_3
Xhold2538 _7219_/Q VGND VGND VPWR VPWR _5574_/A0 sky130_fd_sc_hd__dlygate4sd3_1
Xhold2527 _6875_/Q VGND VGND VPWR VPWR _4789_/A0 sky130_fd_sc_hd__dlygate4sd3_1
Xhold2516 _6895_/Q VGND VGND VPWR VPWR _4832_/A0 sky130_fd_sc_hd__dlygate4sd3_1
Xhold2505 _6906_/Q VGND VGND VPWR VPWR _4858_/A0 sky130_fd_sc_hd__dlygate4sd3_1
X_5164_ _5164_/A0 _5681_/A1 _5181_/S VGND VGND VPWR VPWR _7044_/D sky130_fd_sc_hd__mux2_2
Xhold2549 _7100_/Q VGND VGND VPWR VPWR _5314_/A0 sky130_fd_sc_hd__dlygate4sd3_1
XFILLER_56_326 VGND VGND VPWR VPWR sky130_fd_sc_hd__decap_3
XFILLER_68_197 VGND VGND VPWR VPWR sky130_fd_sc_hd__fill_2
X_5095_ _5095_/A0 _5673_/A1 _5095_/S VGND VGND VPWR VPWR _7012_/D sky130_fd_sc_hd__mux2_2
X_4046_ _7304_/Q _4050_/D VGND VGND VPWR VPWR _7594_/D sky130_fd_sc_hd__xor2_2
XFILLER_12_418 VGND VGND VPWR VPWR sky130_fd_sc_hd__fill_2
XFILLER_24_256 VGND VGND VPWR VPWR sky130_fd_sc_hd__decap_3
XPHY_EDGE_ROW_74_Right_74 VGND VGND VPWR VPWR sky130_fd_sc_hd__decap_3
X_5997_ _5995_/X _5996_/X _5772_/Y VGND VGND VPWR VPWR _5998_/A sky130_fd_sc_hd__a21oi_2
XFILLER_24_289 VGND VGND VPWR VPWR sky130_fd_sc_hd__fill_2
X_4879_ _4879_/A0 _4700_/X _4896_/S VGND VGND VPWR VPWR _6916_/D sky130_fd_sc_hd__mux2_2
XTAP_TAPCELL_ROW_50_744 VGND VPWR sky130_fd_sc_hd__tapvpwrvgnd_1
XTAP_TAPCELL_ROW_22_457 VGND VPWR sky130_fd_sc_hd__tapvpwrvgnd_1
X_7598_ _7606_/CLK _7598_/D place2050/X VGND VGND VPWR VPWR _7598_/Q sky130_fd_sc_hd__dfrtp_2
XFILLER_3_116 VGND VGND VPWR VPWR sky130_fd_sc_hd__decap_3
X_6549_ _6549_/A0 _6548_/Y _6569_/S VGND VGND VPWR VPWR _7443_/D sky130_fd_sc_hd__mux2_2
XPHY_EDGE_ROW_83_Right_83 VGND VGND VPWR VPWR sky130_fd_sc_hd__decap_3
XFILLER_59_131 VGND VGND VPWR VPWR sky130_fd_sc_hd__fill_2
XFILLER_59_164 VGND VGND VPWR VPWR sky130_fd_sc_hd__decap_3
XFILLER_47_337 VGND VGND VPWR VPWR sky130_fd_sc_hd__decap_3
XFILLER_59_197 VGND VGND VPWR VPWR sky130_fd_sc_hd__decap_3
XTAP_TAPCELL_ROW_58_833 VGND VPWR sky130_fd_sc_hd__tapvpwrvgnd_1
XFILLER_28_551 VGND VGND VPWR VPWR sky130_fd_sc_hd__fill_2
XFILLER_74_189 VGND VGND VPWR VPWR sky130_fd_sc_hd__decap_3
XFILLER_15_223 VGND VGND VPWR VPWR sky130_fd_sc_hd__fill_1
XFILLER_28_595 VGND VGND VPWR VPWR sky130_fd_sc_hd__fill_2
XFILLER_43_532 VGND VGND VPWR VPWR sky130_fd_sc_hd__fill_1
XPHY_EDGE_ROW_92_Right_92 VGND VGND VPWR VPWR sky130_fd_sc_hd__decap_3
XFILLER_43_565 VGND VGND VPWR VPWR sky130_fd_sc_hd__decap_3
XFILLER_43_576 VGND VGND VPWR VPWR sky130_fd_sc_hd__decap_3
XFILLER_30_237 VGND VGND VPWR VPWR sky130_fd_sc_hd__fill_1
XFILLER_90_54 VGND VGND VPWR VPWR sky130_fd_sc_hd__fill_2
XFILLER_30_259 VGND VGND VPWR VPWR sky130_fd_sc_hd__fill_1
XFILLER_23_92 VGND VGND VPWR VPWR sky130_fd_sc_hd__decap_3
XFILLER_31_6 VGND VGND VPWR VPWR sky130_fd_sc_hd__fill_2
XFILLER_38_304 VGND VGND VPWR VPWR sky130_fd_sc_hd__decap_3
XFILLER_93_410 VGND VGND VPWR VPWR sky130_fd_sc_hd__decap_3
XFILLER_34_510 VGND VGND VPWR VPWR sky130_fd_sc_hd__decap_3
XFILLER_53_307 VGND VGND VPWR VPWR sky130_fd_sc_hd__fill_2
XFILLER_65_167 VGND VGND VPWR VPWR sky130_fd_sc_hd__fill_1
X_5920_ _5918_/X _5919_/X _6509_/B1 _6506_/A2 VGND VGND VPWR VPWR _5920_/X sky130_fd_sc_hd__a211o_2
XFILLER_0_85 VGND VGND VPWR VPWR sky130_fd_sc_hd__decap_3
XFILLER_34_521 VGND VGND VPWR VPWR sky130_fd_sc_hd__decap_3
XFILLER_80_137 VGND VGND VPWR VPWR sky130_fd_sc_hd__decap_3
XFILLER_34_554 VGND VGND VPWR VPWR sky130_fd_sc_hd__decap_3
XPHY_EDGE_ROW_100_Right_100 VGND VGND VPWR VPWR sky130_fd_sc_hd__decap_3
X_4802_ _4802_/A0 _5692_/A1 _4808_/S VGND VGND VPWR VPWR _6881_/D sky130_fd_sc_hd__mux2_2
X_7521_ clkload2/A _7521_/D place2029/X VGND VGND VPWR VPWR _7521_/Q sky130_fd_sc_hd__dfrtp_2
X_4733_ _4675_/C _4675_/A _4733_/B1 VGND VGND VPWR VPWR _6010_/D sky130_fd_sc_hd__a21oi_2
X_7452_ clkload2/A _7452_/D place2028/X VGND VGND VPWR VPWR _7452_/Q sky130_fd_sc_hd__dfrtp_2
X_6403_ _6403_/A _6403_/B _6403_/C _6403_/D VGND VGND VPWR VPWR _6403_/X sky130_fd_sc_hd__or4_4
Xplace1600 _3549_/Y VGND VGND VPWR VPWR _4743_/A sky130_fd_sc_hd__buf_2
Xplace1611 _6600_/S VGND VGND VPWR VPWR _6590_/S sky130_fd_sc_hd__buf_2
X_7383_ _7507_/CLK _7383_/D place2045/X VGND VGND VPWR VPWR _7383_/Q sky130_fd_sc_hd__dfrtp_2
X_4595_ _7392_/Q _6362_/A2 _4595_/A3 _4595_/B1 VGND VGND VPWR VPWR _4595_/X sky130_fd_sc_hd__a31o_2
Xplace1622 _6064_/A1 VGND VGND VPWR VPWR _6489_/A1 sky130_fd_sc_hd__buf_2
Xplace1633 _3788_/B1 VGND VGND VPWR VPWR _3810_/A2 sky130_fd_sc_hd__buf_2
Xplace1644 _3598_/X VGND VGND VPWR VPWR _3996_/B1 sky130_fd_sc_hd__buf_2
X_6334_ _6334_/A1 _6344_/A2 _6335_/A3 _6345_/B1 _6334_/B2 VGND VGND VPWR VPWR _7378_/D
+ sky130_fd_sc_hd__a32o_2
Xhold3003 _7446_/Q VGND VGND VPWR VPWR _6555_/A0 sky130_fd_sc_hd__dlygate4sd3_1
Xhold3014 _7523_/Q VGND VGND VPWR VPWR _4366_/A1 sky130_fd_sc_hd__dlygate4sd3_1
Xplace1655 _3576_/B VGND VGND VPWR VPWR _6313_/A2 sky130_fd_sc_hd__buf_2
Xplace1666 _6335_/A3 VGND VGND VPWR VPWR _6344_/A3 sky130_fd_sc_hd__buf_2
Xplace1677 _6412_/A3 VGND VGND VPWR VPWR _6411_/A3 sky130_fd_sc_hd__buf_2
Xhold3025 _7516_/Q VGND VGND VPWR VPWR _6710_/A1 sky130_fd_sc_hd__dlygate4sd3_1
Xhold3036 _7525_/Q VGND VGND VPWR VPWR _6729_/A1 sky130_fd_sc_hd__dlygate4sd3_1
Xhold3047 _7497_/Q VGND VGND VPWR VPWR _6670_/A0 sky130_fd_sc_hd__dlygate4sd3_1
Xplace1688 _4325_/B VGND VGND VPWR VPWR _6514_/B1 sky130_fd_sc_hd__buf_2
Xplace1699 _5427_/A VGND VGND VPWR VPWR _5671_/A sky130_fd_sc_hd__buf_2
X_5216_ _5427_/A _5304_/B _5488_/B VGND VGND VPWR VPWR _5302_/S sky130_fd_sc_hd__and3_2
X_3477_ _4473_/D _3542_/B _3845_/C _3542_/D VGND VGND VPWR VPWR _3478_/C sky130_fd_sc_hd__nand4_2
X_6196_ _6394_/A1 _7202_/Q _7174_/Q _6401_/B2 VGND VGND VPWR VPWR _6196_/X sky130_fd_sc_hd__o22a_2
XFILLER_28_26 VGND VGND VPWR VPWR sky130_fd_sc_hd__fill_2
XFILLER_29_337 VGND VGND VPWR VPWR sky130_fd_sc_hd__decap_3
XFILLER_84_421 VGND VGND VPWR VPWR sky130_fd_sc_hd__fill_1
Xhold2379 _7288_/Q VGND VGND VPWR VPWR _5724_/A0 sky130_fd_sc_hd__dlygate4sd3_1
Xhold2368 rst VGND VGND VPWR VPWR hold2368/X sky130_fd_sc_hd__dlygate4sd3_1
XFILLER_56_156 VGND VGND VPWR VPWR sky130_fd_sc_hd__decap_3
XFILLER_44_318 VGND VGND VPWR VPWR sky130_fd_sc_hd__decap_3
XFILLER_56_189 VGND VGND VPWR VPWR sky130_fd_sc_hd__decap_3
X_4029_ _4028_/B _4028_/C _4361_/A VGND VGND VPWR VPWR _4030_/B sky130_fd_sc_hd__a21oi_2
XTAP_TAPCELL_ROW_55_803 VGND VPWR sky130_fd_sc_hd__tapvpwrvgnd_1
XTAP_TAPCELL_ROW_27_505 VGND VPWR sky130_fd_sc_hd__tapvpwrvgnd_1
XFILLER_25_532 VGND VGND VPWR VPWR sky130_fd_sc_hd__decap_3
XFILLER_37_370 VGND VGND VPWR VPWR sky130_fd_sc_hd__fill_1
XFILLER_25_554 VGND VGND VPWR VPWR sky130_fd_sc_hd__decap_3
XFILLER_25_576 VGND VGND VPWR VPWR sky130_fd_sc_hd__decap_3
XTAP_TAPCELL_ROW_63_880 VGND VPWR sky130_fd_sc_hd__tapvpwrvgnd_1
XFILLER_12_248 VGND VGND VPWR VPWR sky130_fd_sc_hd__decap_3
XFILLER_12_259 VGND VGND VPWR VPWR sky130_fd_sc_hd__decap_3
XFILLER_40_546 VGND VGND VPWR VPWR sky130_fd_sc_hd__decap_3
XTAP_TAPCELL_ROW_35_593 VGND VPWR sky130_fd_sc_hd__tapvpwrvgnd_1
XFILLER_20_292 VGND VGND VPWR VPWR sky130_fd_sc_hd__fill_2
XFILLER_69_55 VGND VGND VPWR VPWR sky130_fd_sc_hd__fill_1
XTAP_TAPCELL_ROW_7_296 VGND VPWR sky130_fd_sc_hd__tapvpwrvgnd_1
Xhold2880 _6388_/X VGND VGND VPWR VPWR _7414_/D sky130_fd_sc_hd__dlygate4sd3_1
Xhold2891 _6344_/X VGND VGND VPWR VPWR _7385_/D sky130_fd_sc_hd__dlygate4sd3_1
XFILLER_18_70 VGND VGND VPWR VPWR sky130_fd_sc_hd__decap_3
XFILLER_35_318 VGND VGND VPWR VPWR sky130_fd_sc_hd__decap_3
XFILLER_47_178 VGND VGND VPWR VPWR sky130_fd_sc_hd__decap_3
XFILLER_62_148 VGND VGND VPWR VPWR sky130_fd_sc_hd__decap_3
XFILLER_16_565 VGND VGND VPWR VPWR sky130_fd_sc_hd__fill_1
XFILLER_31_535 VGND VGND VPWR VPWR sky130_fd_sc_hd__decap_3
XFILLER_70_181 VGND VGND VPWR VPWR sky130_fd_sc_hd__decap_3
XFILLER_34_91 VGND VGND VPWR VPWR sky130_fd_sc_hd__decap_3
XFILLER_79_6 VGND VGND VPWR VPWR sky130_fd_sc_hd__fill_1
XFILLER_7_263 VGND VGND VPWR VPWR sky130_fd_sc_hd__decap_3
XFILLER_50_90 VGND VGND VPWR VPWR sky130_fd_sc_hd__decap_3
X_6050_ _6468_/A2 _6880_/Q _7272_/Q _6480_/B2 VGND VGND VPWR VPWR _6050_/X sky130_fd_sc_hd__o22a_2
X_5001_ _5001_/A0 _5334_/A1 _5024_/S VGND VGND VPWR VPWR _6969_/D sky130_fd_sc_hd__mux2_2
XFILLER_38_145 VGND VGND VPWR VPWR sky130_fd_sc_hd__decap_3
XFILLER_26_318 VGND VGND VPWR VPWR sky130_fd_sc_hd__decap_3
XFILLER_38_156 VGND VGND VPWR VPWR sky130_fd_sc_hd__decap_3
XFILLER_53_104 VGND VGND VPWR VPWR sky130_fd_sc_hd__decap_3
XFILLER_93_251 VGND VGND VPWR VPWR sky130_fd_sc_hd__fill_1
XFILLER_93_273 VGND VGND VPWR VPWR sky130_fd_sc_hd__fill_1
XFILLER_19_370 VGND VGND VPWR VPWR sky130_fd_sc_hd__decap_3
X_6952_ _7291_/CLK _6952_/D VGND VGND VPWR VPWR _6952_/Q sky130_fd_sc_hd__dfxtp_2
X_6883_ _7275_/CLK _6883_/D VGND VGND VPWR VPWR _6883_/Q sky130_fd_sc_hd__dfxtp_2
XFILLER_22_513 VGND VGND VPWR VPWR sky130_fd_sc_hd__decap_3
X_5834_ _6928_/Q _5610_/B _5549_/B _7012_/Q VGND VGND VPWR VPWR _5834_/X sky130_fd_sc_hd__a22o_2
XFILLER_61_181 VGND VGND VPWR VPWR sky130_fd_sc_hd__fill_2
XFILLER_61_192 VGND VGND VPWR VPWR sky130_fd_sc_hd__decap_3
XPHY_EDGE_ROW_101_Left_205 VGND VGND VPWR VPWR sky130_fd_sc_hd__decap_3
XTAP_TAPCELL_ROW_60_850 VGND VPWR sky130_fd_sc_hd__tapvpwrvgnd_1
X_5765_ _5764_/Y _5778_/A1 _5941_/A3 _4904_/A VGND VGND VPWR VPWR _5765_/X sky130_fd_sc_hd__a211o_4
XTAP_TAPCELL_ROW_32_563 VGND VPWR sky130_fd_sc_hd__tapvpwrvgnd_1
X_7504_ _7608_/CLK _7504_/D place2056/X VGND VGND VPWR VPWR _7504_/Q sky130_fd_sc_hd__dfrtp_2
X_5696_ _5696_/A0 _5696_/A1 _5696_/S VGND VGND VPWR VPWR _7275_/D sky130_fd_sc_hd__mux2_2
X_4716_ _4716_/A0 _5344_/A1 _4759_/S VGND VGND VPWR VPWR _6862_/D sky130_fd_sc_hd__mux2_2
XFILLER_30_27 VGND VGND VPWR VPWR sky130_fd_sc_hd__fill_1
X_7435_ clkload3/A _7435_/D place2059/X VGND VGND VPWR VPWR _7435_/Q sky130_fd_sc_hd__dfrtp_2
X_7366_ clkload8/A _7366_/D place2018/X VGND VGND VPWR VPWR _7366_/Q sky130_fd_sc_hd__dfrtp_2
XFILLER_100_9 VGND VGND VPWR VPWR sky130_fd_sc_hd__fill_1
Xplace1430 _4012_/Y VGND VGND VPWR VPWR _4110_/B sky130_fd_sc_hd__buf_6
Xplace1441 _3910_/Y VGND VGND VPWR VPWR _4437_/B2 sky130_fd_sc_hd__buf_2
Xplace1452 _3819_/A VGND VGND VPWR VPWR _4206_/A sky130_fd_sc_hd__buf_2
X_6317_ _7396_/Q _6331_/A2 _6322_/A3 _6324_/B1 _6317_/B2 VGND VGND VPWR VPWR _7364_/D
+ sky130_fd_sc_hd__a32o_2
XFILLER_89_557 VGND VGND VPWR VPWR sky130_fd_sc_hd__decap_3
Xplace1463 _3667_/Y VGND VGND VPWR VPWR _4272_/A2 sky130_fd_sc_hd__buf_2
Xplace1474 _5841_/X VGND VGND VPWR VPWR _6161_/A2 sky130_fd_sc_hd__buf_2
Xplace1485 _3989_/Y VGND VGND VPWR VPWR _4117_/B2 sky130_fd_sc_hd__buf_6
Xplace1496 _3896_/C VGND VGND VPWR VPWR _3895_/B2 sky130_fd_sc_hd__buf_2
X_7297_ clkload6/A _7297_/D place2030/X VGND VGND VPWR VPWR _7297_/Q sky130_fd_sc_hd__dfrtp_2
X_3529_ _3529_/A _3529_/B _3529_/C VGND VGND VPWR VPWR _3529_/Y sky130_fd_sc_hd__nand3_2
XFILLER_103_389 VGND VGND VPWR VPWR sky130_fd_sc_hd__decap_3
XFILLER_57_421 VGND VGND VPWR VPWR sky130_fd_sc_hd__decap_3
X_6179_ _6179_/A _6179_/B VGND VGND VPWR VPWR _6179_/Y sky130_fd_sc_hd__nand2_2
XFILLER_57_432 VGND VGND VPWR VPWR sky130_fd_sc_hd__decap_3
XFILLER_69_281 VGND VGND VPWR VPWR sky130_fd_sc_hd__decap_3
XTAP_TAPCELL_ROW_4_266 VGND VPWR sky130_fd_sc_hd__tapvpwrvgnd_1
XFILLER_29_156 VGND VGND VPWR VPWR sky130_fd_sc_hd__decap_3
XFILLER_44_148 VGND VGND VPWR VPWR sky130_fd_sc_hd__decap_3
XFILLER_44_159 VGND VGND VPWR VPWR sky130_fd_sc_hd__decap_3
XFILLER_13_546 VGND VGND VPWR VPWR sky130_fd_sc_hd__fill_1
XFILLER_9_517 VGND VGND VPWR VPWR sky130_fd_sc_hd__decap_3
XFILLER_40_365 VGND VGND VPWR VPWR sky130_fd_sc_hd__decap_3
XTAP_TAPCELL_ROW_78_1045 VGND VPWR sky130_fd_sc_hd__tapvpwrvgnd_1
XFILLER_20_71 VGND VGND VPWR VPWR sky130_fd_sc_hd__decap_3
XFILLER_95_538 VGND VGND VPWR VPWR sky130_fd_sc_hd__fill_2
XFILLER_29_80 VGND VGND VPWR VPWR sky130_fd_sc_hd__decap_3
XFILLER_48_421 VGND VGND VPWR VPWR sky130_fd_sc_hd__decap_3
XFILLER_50_107 VGND VGND VPWR VPWR sky130_fd_sc_hd__decap_3
XFILLER_50_129 VGND VGND VPWR VPWR sky130_fd_sc_hd__decap_3
XTAP_TAPCELL_ROW_74_997 VGND VPWR sky130_fd_sc_hd__tapvpwrvgnd_1
X_3880_ _7432_/Q _3907_/A2 _3880_/B1 _7400_/Q VGND VGND VPWR VPWR _3882_/B sky130_fd_sc_hd__a22oi_2
XFILLER_31_365 VGND VGND VPWR VPWR sky130_fd_sc_hd__decap_3
X_4501_ _4500_/Y _4501_/A1 _4539_/S VGND VGND VPWR VPWR _7310_/D sky130_fd_sc_hd__mux2_2
X_7220_ _7276_/CLK _7220_/D VGND VGND VPWR VPWR _7220_/Q sky130_fd_sc_hd__dfxtp_2
X_4432_ _4429_/X _4430_/Y _4428_/X _4427_/X VGND VGND VPWR VPWR _4433_/C sky130_fd_sc_hd__o211a_2
XFILLER_6_95 VGND VGND VPWR VPWR sky130_fd_sc_hd__decap_3
X_7151_ _7565_/CLK _7151_/D VGND VGND VPWR VPWR _7151_/Q sky130_fd_sc_hd__dfxtp_2
X_4363_ _4362_/A _4362_/B _4362_/C _4362_/D VGND VGND VPWR VPWR _4363_/Y sky130_fd_sc_hd__a22oi_2
XFILLER_98_365 VGND VGND VPWR VPWR sky130_fd_sc_hd__decap_3
X_7082_ _7279_/CLK _7082_/D VGND VGND VPWR VPWR _7082_/Q sky130_fd_sc_hd__dfxtp_2
X_6102_ _6154_/A1 _6914_/Q _7250_/Q _6154_/B2 VGND VGND VPWR VPWR _6102_/X sky130_fd_sc_hd__o22a_2
X_4294_ _7320_/Q _4294_/A2 _4569_/B1 VGND VGND VPWR VPWR _4296_/B sky130_fd_sc_hd__a21oi_2
XFILLER_58_218 VGND VGND VPWR VPWR sky130_fd_sc_hd__decap_3
X_6033_ _6507_/A1 _6907_/Q _7243_/Q _6507_/B2 VGND VGND VPWR VPWR _6033_/X sky130_fd_sc_hd__o22a_2
XFILLER_100_337 VGND VGND VPWR VPWR sky130_fd_sc_hd__fill_2
XFILLER_100_348 VGND VGND VPWR VPWR sky130_fd_sc_hd__decap_3
XFILLER_39_421 VGND VGND VPWR VPWR sky130_fd_sc_hd__decap_3
XFILLER_39_487 VGND VGND VPWR VPWR sky130_fd_sc_hd__decap_3
XFILLER_54_402 VGND VGND VPWR VPWR sky130_fd_sc_hd__decap_3
XFILLER_66_251 VGND VGND VPWR VPWR sky130_fd_sc_hd__fill_1
XFILLER_26_104 VGND VGND VPWR VPWR sky130_fd_sc_hd__fill_2
XFILLER_54_424 VGND VGND VPWR VPWR sky130_fd_sc_hd__fill_1
XFILLER_54_435 VGND VGND VPWR VPWR sky130_fd_sc_hd__decap_3
XFILLER_94_582 VGND VGND VPWR VPWR sky130_fd_sc_hd__decap_3
XTAP_TAPCELL_ROW_37_611 VGND VPWR sky130_fd_sc_hd__tapvpwrvgnd_1
XTAP_TAPCELL_ROW_1_236 VGND VPWR sky130_fd_sc_hd__tapvpwrvgnd_1
XFILLER_25_27 VGND VGND VPWR VPWR sky130_fd_sc_hd__decap_3
XFILLER_42_608 VGND VGND VPWR VPWR sky130_fd_sc_hd__decap_3
X_6935_ _7243_/CLK _6935_/D VGND VGND VPWR VPWR _6935_/Q sky130_fd_sc_hd__dfxtp_2
XFILLER_22_332 VGND VGND VPWR VPWR sky130_fd_sc_hd__decap_3
X_6866_ _7288_/CLK _6866_/D VGND VGND VPWR VPWR _6866_/Q sky130_fd_sc_hd__dfxtp_2
XFILLER_22_365 VGND VGND VPWR VPWR sky130_fd_sc_hd__decap_3
X_5817_ _6396_/A1 _6913_/Q _7249_/Q _6165_/B2 VGND VGND VPWR VPWR _5817_/X sky130_fd_sc_hd__o22a_2
XFILLER_6_509 VGND VGND VPWR VPWR sky130_fd_sc_hd__fill_1
X_5679_ _5679_/A0 _5679_/A1 _5696_/S VGND VGND VPWR VPWR _7267_/D sky130_fd_sc_hd__mux2_2
X_7418_ _7514_/CLK _7418_/D place2040/X VGND VGND VPWR VPWR _7418_/Q sky130_fd_sc_hd__dfrtp_2
XTAP_TAPCELL_ROW_9_314 VGND VPWR sky130_fd_sc_hd__tapvpwrvgnd_1
XFILLER_1_225 VGND VGND VPWR VPWR sky130_fd_sc_hd__decap_3
XFILLER_9_6 VGND VGND VPWR VPWR sky130_fd_sc_hd__decap_3
Xplace1260 _6506_/A1 VGND VGND VPWR VPWR _6211_/B1 sky130_fd_sc_hd__buf_2
X_7349_ _7577_/CLK _7349_/D place2046/X VGND VGND VPWR VPWR _7349_/Q sky130_fd_sc_hd__dfrtp_2
XFILLER_89_365 VGND VGND VPWR VPWR sky130_fd_sc_hd__fill_1
Xplace1271 _6451_/B1 VGND VGND VPWR VPWR _6396_/A1 sky130_fd_sc_hd__buf_2
Xplace1282 _6424_/B2 VGND VGND VPWR VPWR _6483_/B2 sky130_fd_sc_hd__buf_2
Xplace1293 _6171_/A2 VGND VGND VPWR VPWR _6173_/B2 sky130_fd_sc_hd__buf_2
XFILLER_103_197 VGND VGND VPWR VPWR sky130_fd_sc_hd__fill_2
XFILLER_66_78 VGND VGND VPWR VPWR sky130_fd_sc_hd__decap_3
XFILLER_17_126 VGND VGND VPWR VPWR sky130_fd_sc_hd__decap_3
XFILLER_72_210 VGND VGND VPWR VPWR sky130_fd_sc_hd__decap_3
XFILLER_17_159 VGND VGND VPWR VPWR sky130_fd_sc_hd__decap_3
XFILLER_60_427 VGND VGND VPWR VPWR sky130_fd_sc_hd__decap_3
XFILLER_72_265 VGND VGND VPWR VPWR sky130_fd_sc_hd__decap_3
XFILLER_13_310 VGND VGND VPWR VPWR sky130_fd_sc_hd__decap_3
XFILLER_25_192 VGND VGND VPWR VPWR sky130_fd_sc_hd__decap_3
XFILLER_82_88 VGND VGND VPWR VPWR sky130_fd_sc_hd__fill_2
XFILLER_82_99 VGND VGND VPWR VPWR sky130_fd_sc_hd__fill_1
XTAP_TAPCELL_ROW_71_967 VGND VPWR sky130_fd_sc_hd__tapvpwrvgnd_1
XFILLER_15_93 VGND VGND VPWR VPWR sky130_fd_sc_hd__decap_3
XFILLER_40_162 VGND VGND VPWR VPWR sky130_fd_sc_hd__decap_3
XFILLER_5_564 VGND VGND VPWR VPWR sky130_fd_sc_hd__fill_1
XFILLER_48_251 VGND VGND VPWR VPWR sky130_fd_sc_hd__fill_1
XFILLER_48_262 VGND VGND VPWR VPWR sky130_fd_sc_hd__fill_1
XFILLER_63_254 VGND VGND VPWR VPWR sky130_fd_sc_hd__fill_2
XFILLER_91_541 VGND VGND VPWR VPWR sky130_fd_sc_hd__fill_2
X_4981_ _4981_/A0 _5376_/A1 _4998_/S VGND VGND VPWR VPWR _6960_/D sky130_fd_sc_hd__mux2_2
XFILLER_51_449 VGND VGND VPWR VPWR sky130_fd_sc_hd__decap_3
Xclkbuf_leaf_43_clk clkbuf_leaf_0_clk/A VGND VGND VPWR VPWR clkload4/A sky130_fd_sc_hd__clkbuf_16
X_6720_ _5943_/X _7521_/Q _6720_/S VGND VGND VPWR VPWR _7521_/D sky130_fd_sc_hd__mux2_2
X_3932_ _7523_/Q _5734_/A _3965_/B1 _7459_/Q VGND VGND VPWR VPWR _3932_/X sky130_fd_sc_hd__a22o_2
XFILLER_31_151 VGND VGND VPWR VPWR sky130_fd_sc_hd__decap_3
X_6651_ _6651_/A0 _5863_/X _6653_/S VGND VGND VPWR VPWR _7488_/D sky130_fd_sc_hd__mux2_2
X_3863_ _7369_/Q _3863_/A2 _3617_/Y _7433_/Q VGND VGND VPWR VPWR _3863_/X sky130_fd_sc_hd__a22o_2
XFILLER_31_195 VGND VGND VPWR VPWR sky130_fd_sc_hd__decap_3
X_5602_ _5602_/A0 _5724_/A1 _5606_/S VGND VGND VPWR VPWR _7232_/D sky130_fd_sc_hd__mux2_2
XTAP_TAPCELL_ROW_14_371 VGND VPWR sky130_fd_sc_hd__tapvpwrvgnd_1
X_3794_ _7407_/Q _6706_/S _3793_/X VGND VGND VPWR VPWR _3794_/Y sky130_fd_sc_hd__a21oi_2
X_7203_ _7288_/CLK _7203_/D VGND VGND VPWR VPWR _7203_/Q sky130_fd_sc_hd__dfxtp_2
X_4415_ _4416_/A _4416_/B _4430_/A _4430_/B VGND VGND VPWR VPWR _4422_/B sky130_fd_sc_hd__a31o_2
X_7134_ _7247_/CLK _7134_/D VGND VGND VPWR VPWR _7134_/Q sky130_fd_sc_hd__dfxtp_2
X_4346_ _4346_/A _4346_/B VGND VGND VPWR VPWR _4346_/Y sky130_fd_sc_hd__nor2_2
XFILLER_59_505 VGND VGND VPWR VPWR sky130_fd_sc_hd__decap_3
Xwire2109 _3500_/Y VGND VGND VPWR VPWR _3548_/B1 sky130_fd_sc_hd__buf_2
X_7065_ _7289_/CLK _7065_/D VGND VGND VPWR VPWR _7065_/Q sky130_fd_sc_hd__dfxtp_2
X_4277_ _4276_/C _4276_/B _4277_/B1 VGND VGND VPWR VPWR _4277_/Y sky130_fd_sc_hd__o21ai_2
XFILLER_39_240 VGND VGND VPWR VPWR sky130_fd_sc_hd__decap_3
XFILLER_86_368 VGND VGND VPWR VPWR sky130_fd_sc_hd__decap_3
X_6016_ _6016_/A1 _5841_/X _6515_/A1 _6014_/Y _5843_/X VGND VGND VPWR VPWR _6016_/X
+ sky130_fd_sc_hd__a221o_2
XFILLER_39_273 VGND VGND VPWR VPWR sky130_fd_sc_hd__decap_3
XFILLER_39_284 VGND VGND VPWR VPWR sky130_fd_sc_hd__decap_3
XFILLER_54_221 VGND VGND VPWR VPWR sky130_fd_sc_hd__decap_3
XFILLER_54_243 VGND VGND VPWR VPWR sky130_fd_sc_hd__decap_3
Xclkbuf_leaf_34_clk clkbuf_leaf_3_clk/A VGND VGND VPWR VPWR _7514_/CLK sky130_fd_sc_hd__clkbuf_16
X_6918_ _7282_/CLK _6918_/D VGND VGND VPWR VPWR _6918_/Q sky130_fd_sc_hd__dfxtp_2
XFILLER_52_25 VGND VGND VPWR VPWR sky130_fd_sc_hd__decap_3
X_6849_ _7241_/CLK _6849_/D VGND VGND VPWR VPWR _6849_/Q sky130_fd_sc_hd__dfxtp_2
XTAP_TAPCELL_ROW_40_639 VGND VPWR sky130_fd_sc_hd__tapvpwrvgnd_1
XFILLER_22_195 VGND VGND VPWR VPWR sky130_fd_sc_hd__fill_1
XTAP_TAPCELL_ROW_75_1015 VGND VPWR sky130_fd_sc_hd__tapvpwrvgnd_1
XFILLER_7_3 VGND VGND VPWR VPWR sky130_fd_sc_hd__decap_3
XFILLER_2_589 VGND VGND VPWR VPWR sky130_fd_sc_hd__fill_2
Xplace1090 _4269_/A VGND VGND VPWR VPWR _6389_/A sky130_fd_sc_hd__buf_2
XFILLER_92_305 VGND VGND VPWR VPWR sky130_fd_sc_hd__decap_3
XTAP_TAPCELL_ROW_48_728 VGND VPWR sky130_fd_sc_hd__tapvpwrvgnd_1
XFILLER_45_221 VGND VGND VPWR VPWR sky130_fd_sc_hd__decap_3
XFILLER_45_254 VGND VGND VPWR VPWR sky130_fd_sc_hd__decap_3
XTAP_TAPCELL_ROW_86_1122 VGND VPWR sky130_fd_sc_hd__tapvpwrvgnd_1
XFILLER_45_287 VGND VGND VPWR VPWR sky130_fd_sc_hd__decap_3
XFILLER_33_449 VGND VGND VPWR VPWR sky130_fd_sc_hd__decap_3
XFILLER_60_246 VGND VGND VPWR VPWR sky130_fd_sc_hd__decap_3
Xclkbuf_leaf_25_clk clkbuf_3_6__f_clk/X VGND VGND VPWR VPWR _7280_/CLK sky130_fd_sc_hd__clkbuf_16
XFILLER_13_151 VGND VGND VPWR VPWR sky130_fd_sc_hd__decap_3
XFILLER_60_268 VGND VGND VPWR VPWR sky130_fd_sc_hd__decap_3
XFILLER_9_111 VGND VGND VPWR VPWR sky130_fd_sc_hd__fill_1
XFILLER_13_195 VGND VGND VPWR VPWR sky130_fd_sc_hd__decap_3
XFILLER_9_144 VGND VGND VPWR VPWR sky130_fd_sc_hd__decap_3
XFILLER_9_166 VGND VGND VPWR VPWR sky130_fd_sc_hd__fill_2
XTAP_TAPCELL_ROW_11_341 VGND VPWR sky130_fd_sc_hd__tapvpwrvgnd_1
XFILLER_42_91 VGND VGND VPWR VPWR sky130_fd_sc_hd__decap_3
XFILLER_9_188 VGND VGND VPWR VPWR sky130_fd_sc_hd__decap_3
XTAP_TAPCELL_ROW_97_1240 VGND VPWR sky130_fd_sc_hd__tapvpwrvgnd_1
X_4200_ _4235_/A _4200_/B _4200_/C VGND VGND VPWR VPWR _4200_/Y sky130_fd_sc_hd__nor3_4
Xhold2709 _7001_/Q VGND VGND VPWR VPWR _5070_/A0 sky130_fd_sc_hd__dlygate4sd3_1
X_4131_ _4108_/Y _4131_/A2 _4012_/Y _4103_/Y VGND VGND VPWR VPWR _4131_/Y sky130_fd_sc_hd__o211ai_2
XFILLER_56_519 VGND VGND VPWR VPWR sky130_fd_sc_hd__decap_3
XFILLER_95_165 VGND VGND VPWR VPWR sky130_fd_sc_hd__decap_3
X_4062_ _4067_/A _4499_/C VGND VGND VPWR VPWR _7601_/D sky130_fd_sc_hd__xor2_2
XFILLER_24_416 VGND VGND VPWR VPWR sky130_fd_sc_hd__decap_3
XFILLER_24_427 VGND VGND VPWR VPWR sky130_fd_sc_hd__decap_3
XFILLER_51_202 VGND VGND VPWR VPWR sky130_fd_sc_hd__fill_1
XFILLER_91_371 VGND VGND VPWR VPWR sky130_fd_sc_hd__decap_3
Xclkbuf_leaf_16_clk clkbuf_leaf_9_clk/A VGND VGND VPWR VPWR _7276_/CLK sky130_fd_sc_hd__clkbuf_16
X_4964_ _4964_/A0 _5608_/A1 _4964_/S VGND VGND VPWR VPWR _6955_/D sky130_fd_sc_hd__mux2_2
XFILLER_32_460 VGND VGND VPWR VPWR sky130_fd_sc_hd__decap_3
X_3915_ _3920_/B _3946_/B _3915_/C VGND VGND VPWR VPWR _3916_/B sky130_fd_sc_hd__or3_4
XFILLER_20_611 VGND VGND VPWR VPWR sky130_fd_sc_hd__fill_1
XFILLER_22_17 VGND VGND VPWR VPWR sky130_fd_sc_hd__decap_3
X_6634_ _6634_/A0 _6561_/Y _6634_/S VGND VGND VPWR VPWR _7480_/D sky130_fd_sc_hd__mux2_2
X_3846_ _4352_/B _6230_/A1 _3846_/A3 _3845_/X VGND VGND VPWR VPWR _3846_/X sky130_fd_sc_hd__a31o_2
XTAP_TAPCELL_ROW_102_1299 VGND VPWR sky130_fd_sc_hd__tapvpwrvgnd_1
X_6565_ _7609_/Q _6565_/B VGND VGND VPWR VPWR _6565_/Y sky130_fd_sc_hd__nor2_2
X_3777_ _7472_/Q _3812_/B1 _3907_/B1 _7408_/Q _3776_/X VGND VGND VPWR VPWR _3777_/X
+ sky130_fd_sc_hd__a221o_2
XFILLER_3_309 VGND VGND VPWR VPWR sky130_fd_sc_hd__decap_3
X_6496_ _6515_/A1 _6494_/X _6515_/A3 _6495_/X VGND VGND VPWR VPWR _6496_/X sky130_fd_sc_hd__a31o_2
XFILLER_87_611 VGND VGND VPWR VPWR sky130_fd_sc_hd__fill_1
Xfanout101 hold2368/X VGND VGND VPWR VPWR place2069/A sky130_fd_sc_hd__clkdlybuf4s25_1
XFILLER_59_335 VGND VGND VPWR VPWR sky130_fd_sc_hd__fill_1
XFILLER_59_346 VGND VGND VPWR VPWR sky130_fd_sc_hd__decap_3
X_7117_ _7217_/CLK _7117_/D VGND VGND VPWR VPWR _7117_/Q sky130_fd_sc_hd__dfxtp_2
X_4329_ _4329_/A1 _5732_/S _4328_/X VGND VGND VPWR VPWR _7293_/D sky130_fd_sc_hd__a21o_2
XFILLER_74_305 VGND VGND VPWR VPWR sky130_fd_sc_hd__decap_3
X_7048_ _7247_/CLK _7048_/D VGND VGND VPWR VPWR _7048_/Q sky130_fd_sc_hd__dfxtp_2
XFILLER_74_338 VGND VGND VPWR VPWR sky130_fd_sc_hd__decap_3
XFILLER_27_221 VGND VGND VPWR VPWR sky130_fd_sc_hd__decap_3
XFILLER_82_371 VGND VGND VPWR VPWR sky130_fd_sc_hd__fill_1
XFILLER_27_287 VGND VGND VPWR VPWR sky130_fd_sc_hd__fill_2
XTAP_TAPCELL_ROW_53_775 VGND VPWR sky130_fd_sc_hd__tapvpwrvgnd_1
XFILLER_23_471 VGND VGND VPWR VPWR sky130_fd_sc_hd__decap_3
XFILLER_23_493 VGND VGND VPWR VPWR sky130_fd_sc_hd__decap_3
XFILLER_8_19 VGND VGND VPWR VPWR sky130_fd_sc_hd__fill_2
XTAP_TAPCELL_ROW_81_1074 VGND VPWR sky130_fd_sc_hd__tapvpwrvgnd_1
XTAP_TAPCELL_ROW_25_488 VGND VPWR sky130_fd_sc_hd__tapvpwrvgnd_1
XFILLER_10_132 VGND VGND VPWR VPWR sky130_fd_sc_hd__decap_3
XFILLER_10_154 VGND VGND VPWR VPWR sky130_fd_sc_hd__decap_3
XFILLER_6_147 VGND VGND VPWR VPWR sky130_fd_sc_hd__decap_3
XFILLER_12_94 VGND VGND VPWR VPWR sky130_fd_sc_hd__decap_3
XFILLER_2_320 VGND VGND VPWR VPWR sky130_fd_sc_hd__decap_3
XFILLER_88_65 VGND VGND VPWR VPWR sky130_fd_sc_hd__fill_1
XTAP_TAPCELL_ROW_92_1192 VGND VPWR sky130_fd_sc_hd__tapvpwrvgnd_1
XFILLER_26_9 VGND VGND VPWR VPWR sky130_fd_sc_hd__decap_3
XFILLER_77_132 VGND VGND VPWR VPWR sky130_fd_sc_hd__fill_2
XFILLER_21_408 VGND VGND VPWR VPWR sky130_fd_sc_hd__decap_3
XFILLER_33_246 VGND VGND VPWR VPWR sky130_fd_sc_hd__decap_3
XFILLER_33_279 VGND VGND VPWR VPWR sky130_fd_sc_hd__fill_1
X_3700_ _3699_/D _3699_/B _3670_/A _3688_/Y VGND VGND VPWR VPWR _3701_/B sky130_fd_sc_hd__o2bb2a_2
XFILLER_41_290 VGND VGND VPWR VPWR sky130_fd_sc_hd__decap_3
X_4680_ _4680_/A0 _5334_/A1 _4759_/S VGND VGND VPWR VPWR _6857_/D sky130_fd_sc_hd__mux2_2
X_3631_ _3631_/A _3631_/B _3631_/C VGND VGND VPWR VPWR _3670_/D sky130_fd_sc_hd__nand3_2
X_3562_ _3576_/A _3576_/C _3559_/X _3562_/A4 _3561_/Y VGND VGND VPWR VPWR _3563_/C
+ sky130_fd_sc_hd__a41oi_4
Xplace1826 _3845_/B VGND VGND VPWR VPWR _4028_/B sky130_fd_sc_hd__buf_2
Xplace1815 _3975_/B VGND VGND VPWR VPWR _3969_/D sky130_fd_sc_hd__buf_2
Xplace1804 _4707_/A3 VGND VGND VPWR VPWR _3792_/A2 sky130_fd_sc_hd__buf_2
XFILLER_5_180 VGND VGND VPWR VPWR sky130_fd_sc_hd__decap_3
Xplace1859 _3509_/B VGND VGND VPWR VPWR _5839_/A2 sky130_fd_sc_hd__buf_2
Xplace1848 _3490_/B VGND VGND VPWR VPWR _3547_/B sky130_fd_sc_hd__buf_2
Xplace1837 _3815_/A1 VGND VGND VPWR VPWR _3717_/A1 sky130_fd_sc_hd__buf_2
X_6281_ _6294_/A _6281_/B VGND VGND VPWR VPWR _7347_/D sky130_fd_sc_hd__and2_2
X_3493_ _3459_/A _3516_/A2 _6231_/A2 VGND VGND VPWR VPWR _3493_/X sky130_fd_sc_hd__a21o_2
Xclkbuf_leaf_5_clk clkbuf_leaf_8_clk/A VGND VGND VPWR VPWR _7581_/CLK sky130_fd_sc_hd__clkbuf_16
Xhold2528 _6937_/Q VGND VGND VPWR VPWR _4926_/A0 sky130_fd_sc_hd__dlygate4sd3_1
Xhold2517 _6992_/Q VGND VGND VPWR VPWR _5051_/A0 sky130_fd_sc_hd__dlygate4sd3_1
Xhold2506 _6914_/Q VGND VGND VPWR VPWR _4875_/A0 sky130_fd_sc_hd__dlygate4sd3_1
XFILLER_29_508 VGND VGND VPWR VPWR sky130_fd_sc_hd__decap_3
Xhold2539 _7044_/Q VGND VGND VPWR VPWR _5164_/A0 sky130_fd_sc_hd__dlygate4sd3_1
X_4114_ _4114_/A VGND VGND VPWR VPWR _4114_/Y sky130_fd_sc_hd__inv_2
XFILLER_83_113 VGND VGND VPWR VPWR sky130_fd_sc_hd__fill_2
XFILLER_96_474 VGND VGND VPWR VPWR sky130_fd_sc_hd__fill_2
X_4045_ _4050_/D _4045_/B VGND VGND VPWR VPWR _7593_/D sky130_fd_sc_hd__nor2_2
XFILLER_52_500 VGND VGND VPWR VPWR sky130_fd_sc_hd__fill_2
XFILLER_52_533 VGND VGND VPWR VPWR sky130_fd_sc_hd__decap_3
XFILLER_24_268 VGND VGND VPWR VPWR sky130_fd_sc_hd__fill_2
X_5996_ _5999_/A1 _7207_/Q _7151_/Q _6171_/A2 VGND VGND VPWR VPWR _5996_/X sky130_fd_sc_hd__o22a_2
XFILLER_52_599 VGND VGND VPWR VPWR sky130_fd_sc_hd__fill_2
X_4947_ _4947_/A0 _5591_/A1 _4964_/S VGND VGND VPWR VPWR _6947_/D sky130_fd_sc_hd__mux2_2
XFILLER_20_430 VGND VGND VPWR VPWR sky130_fd_sc_hd__decap_3
XTAP_TAPCELL_ROW_50_745 VGND VPWR sky130_fd_sc_hd__tapvpwrvgnd_1
XTAP_TAPCELL_ROW_22_458 VGND VPWR sky130_fd_sc_hd__tapvpwrvgnd_1
XFILLER_20_474 VGND VGND VPWR VPWR sky130_fd_sc_hd__fill_2
X_6617_ _6617_/A0 _6159_/X _6634_/S VGND VGND VPWR VPWR _7472_/D sky130_fd_sc_hd__mux2_2
X_3829_ _3825_/X _3829_/B _3829_/C _3829_/D VGND VGND VPWR VPWR _3829_/Y sky130_fd_sc_hd__nand4b_4
X_7597_ _7608_/CLK _7597_/D place2049/X VGND VGND VPWR VPWR _7597_/Q sky130_fd_sc_hd__dfrtp_2
X_6548_ _6546_/X _6547_/Y _6182_/X VGND VGND VPWR VPWR _6548_/Y sky130_fd_sc_hd__a21boi_2
XFILLER_3_128 VGND VGND VPWR VPWR sky130_fd_sc_hd__decap_3
X_6479_ _6484_/B2 _6903_/Q _7239_/Q _6483_/B2 VGND VGND VPWR VPWR _6479_/X sky130_fd_sc_hd__o22a_2
XTAP_TAPCELL_ROW_58_834 VGND VPWR sky130_fd_sc_hd__tapvpwrvgnd_1
XFILLER_47_349 VGND VGND VPWR VPWR sky130_fd_sc_hd__decap_3
XFILLER_28_563 VGND VGND VPWR VPWR sky130_fd_sc_hd__decap_3
XFILLER_28_574 VGND VGND VPWR VPWR sky130_fd_sc_hd__decap_3
XFILLER_55_393 VGND VGND VPWR VPWR sky130_fd_sc_hd__decap_3
XFILLER_70_352 VGND VGND VPWR VPWR sky130_fd_sc_hd__decap_3
XFILLER_11_452 VGND VGND VPWR VPWR sky130_fd_sc_hd__fill_1
XFILLER_7_434 VGND VGND VPWR VPWR sky130_fd_sc_hd__decap_3
XTAP_TAPCELL_ROW_94_1210 VGND VPWR sky130_fd_sc_hd__tapvpwrvgnd_1
XFILLER_2_150 VGND VGND VPWR VPWR sky130_fd_sc_hd__decap_3
XFILLER_24_6 VGND VGND VPWR VPWR sky130_fd_sc_hd__decap_3
XFILLER_2_194 VGND VGND VPWR VPWR sky130_fd_sc_hd__fill_2
XFILLER_38_327 VGND VGND VPWR VPWR sky130_fd_sc_hd__fill_2
XFILLER_65_146 VGND VGND VPWR VPWR sky130_fd_sc_hd__decap_3
XFILLER_34_500 VGND VGND VPWR VPWR sky130_fd_sc_hd__decap_3
XFILLER_0_75 VGND VGND VPWR VPWR sky130_fd_sc_hd__fill_1
XFILLER_34_533 VGND VGND VPWR VPWR sky130_fd_sc_hd__decap_3
XFILLER_0_97 VGND VGND VPWR VPWR sky130_fd_sc_hd__decap_3
X_5850_ _5850_/A _5850_/B _5850_/C _6347_/A VGND VGND VPWR VPWR _5850_/X sky130_fd_sc_hd__or4_2
XFILLER_21_205 VGND VGND VPWR VPWR sky130_fd_sc_hd__decap_3
X_5781_ _5771_/Y _5941_/A3 _4778_/A VGND VGND VPWR VPWR _5781_/Y sky130_fd_sc_hd__o21ai_2
XFILLER_21_238 VGND VGND VPWR VPWR sky130_fd_sc_hd__decap_3
X_7520_ clkload2/A _7520_/D place2028/X VGND VGND VPWR VPWR _7520_/Q sky130_fd_sc_hd__dfrtp_2
X_7451_ clkload3/A _7451_/D place2063/X VGND VGND VPWR VPWR _7451_/Q sky130_fd_sc_hd__dfrtp_2
X_4663_ _6226_/B1 _4661_/X _4662_/Y _4663_/B1 VGND VGND VPWR VPWR _4663_/X sky130_fd_sc_hd__a31o_2
X_6402_ _6399_/X _6401_/X _6458_/B2 VGND VGND VPWR VPWR _6403_/D sky130_fd_sc_hd__a21oi_2
X_3614_ _3535_/Y _3614_/A2 _3574_/Y _3577_/Y _3554_/X VGND VGND VPWR VPWR _3614_/X
+ sky130_fd_sc_hd__o221a_4
Xplace1601 _3541_/X VGND VGND VPWR VPWR _4151_/A sky130_fd_sc_hd__buf_2
X_7382_ _7507_/CLK _7382_/D place2045/X VGND VGND VPWR VPWR _7382_/Q sky130_fd_sc_hd__dfrtp_2
Xplace1612 _6600_/S VGND VGND VPWR VPWR _6607_/S sky130_fd_sc_hd__buf_2
Xplace1623 _5750_/A1 VGND VGND VPWR VPWR _6064_/A1 sky130_fd_sc_hd__buf_2
Xplace1634 _3788_/B1 VGND VGND VPWR VPWR _3725_/A2 sky130_fd_sc_hd__buf_6
Xplace1645 _3598_/X VGND VGND VPWR VPWR _4004_/B1 sky130_fd_sc_hd__buf_2
X_6333_ _6383_/B2 _6346_/A2 _6346_/A3 _6345_/B1 _6333_/B2 VGND VGND VPWR VPWR _7377_/D
+ sky130_fd_sc_hd__a32o_2
X_3545_ _3545_/A _3545_/B _3545_/C _7325_/Q VGND VGND VPWR VPWR _3549_/B sky130_fd_sc_hd__nand4_2
Xhold3004 _7535_/Q VGND VGND VPWR VPWR _6750_/A1 sky130_fd_sc_hd__dlygate4sd3_1
Xhold3015 _7426_/Q VGND VGND VPWR VPWR _6492_/A0 sky130_fd_sc_hd__dlygate4sd3_1
Xplace1656 _3567_/B VGND VGND VPWR VPWR _4142_/B2 sky130_fd_sc_hd__buf_2
Xplace1667 _3817_/A3 VGND VGND VPWR VPWR _6335_/A3 sky130_fd_sc_hd__buf_2
Xplace1678 _3903_/A2 VGND VGND VPWR VPWR _6412_/A3 sky130_fd_sc_hd__buf_2
X_6264_ _6292_/A _6264_/B VGND VGND VPWR VPWR _7339_/D sky130_fd_sc_hd__and2_2
X_3476_ _3429_/B _3459_/B _3468_/A _3476_/C1 VGND VGND VPWR VPWR _3542_/D sky130_fd_sc_hd__o211ai_2
Xhold3026 _7410_/Q VGND VGND VPWR VPWR _6334_/A1 sky130_fd_sc_hd__dlygate4sd3_1
Xhold3037 _7439_/Q VGND VGND VPWR VPWR _6537_/A0 sky130_fd_sc_hd__dlygate4sd3_1
Xhold3048 _7536_/Q VGND VGND VPWR VPWR _6752_/A1 sky130_fd_sc_hd__dlygate4sd3_1
Xplace1689 _4508_/B VGND VGND VPWR VPWR _4533_/D sky130_fd_sc_hd__buf_2
X_6195_ _6399_/A1 _7230_/Q _7146_/Q _6393_/B2 VGND VGND VPWR VPWR _6195_/X sky130_fd_sc_hd__o22a_2
XFILLER_29_305 VGND VGND VPWR VPWR sky130_fd_sc_hd__decap_3
Xhold2369 _7170_/Q VGND VGND VPWR VPWR _5467_/A0 sky130_fd_sc_hd__dlygate4sd3_1
X_5146_ _5146_/A0 _4757_/Y _5146_/S VGND VGND VPWR VPWR _7036_/D sky130_fd_sc_hd__mux2_2
XFILLER_56_135 VGND VGND VPWR VPWR sky130_fd_sc_hd__decap_3
XFILLER_25_500 VGND VGND VPWR VPWR sky130_fd_sc_hd__decap_3
X_4028_ _4361_/A _4028_/B _4028_/C VGND VGND VPWR VPWR _4036_/D sky130_fd_sc_hd__and3_2
XTAP_TAPCELL_ROW_55_804 VGND VPWR sky130_fd_sc_hd__tapvpwrvgnd_1
XTAP_TAPCELL_ROW_27_506 VGND VPWR sky130_fd_sc_hd__tapvpwrvgnd_1
XFILLER_37_393 VGND VGND VPWR VPWR sky130_fd_sc_hd__fill_2
XFILLER_71_149 VGND VGND VPWR VPWR sky130_fd_sc_hd__decap_3
XFILLER_25_588 VGND VGND VPWR VPWR sky130_fd_sc_hd__fill_2
XFILLER_40_536 VGND VGND VPWR VPWR sky130_fd_sc_hd__fill_1
XFILLER_52_363 VGND VGND VPWR VPWR sky130_fd_sc_hd__fill_1
X_5979_ _5979_/A _5979_/B VGND VGND VPWR VPWR _6011_/B sky130_fd_sc_hd__nand2_4
XTAP_TAPCELL_ROW_63_881 VGND VPWR sky130_fd_sc_hd__tapvpwrvgnd_1
XFILLER_8_209 VGND VGND VPWR VPWR sky130_fd_sc_hd__decap_3
XTAP_TAPCELL_ROW_35_594 VGND VPWR sky130_fd_sc_hd__tapvpwrvgnd_1
XFILLER_20_260 VGND VGND VPWR VPWR sky130_fd_sc_hd__decap_3
XFILLER_4_448 VGND VGND VPWR VPWR sky130_fd_sc_hd__fill_1
XFILLER_4_459 VGND VGND VPWR VPWR sky130_fd_sc_hd__decap_3
XTAP_TAPCELL_ROW_7_297 VGND VPWR sky130_fd_sc_hd__tapvpwrvgnd_1
XFILLER_47_146 VGND VGND VPWR VPWR sky130_fd_sc_hd__fill_1
XFILLER_85_55 VGND VGND VPWR VPWR sky130_fd_sc_hd__fill_1
Xhold2870 _7482_/Q VGND VGND VPWR VPWR _6638_/A0 sky130_fd_sc_hd__dlygate4sd3_1
Xhold2881 _7387_/Q VGND VGND VPWR VPWR _6346_/B2 sky130_fd_sc_hd__dlygate4sd3_1
Xhold2892 _7461_/Q VGND VGND VPWR VPWR _6594_/A0 sky130_fd_sc_hd__dlygate4sd3_1
XFILLER_47_157 VGND VGND VPWR VPWR sky130_fd_sc_hd__decap_3
XFILLER_16_533 VGND VGND VPWR VPWR sky130_fd_sc_hd__decap_3
XFILLER_31_514 VGND VGND VPWR VPWR sky130_fd_sc_hd__fill_1
XFILLER_31_547 VGND VGND VPWR VPWR sky130_fd_sc_hd__fill_2
XFILLER_31_558 VGND VGND VPWR VPWR sky130_fd_sc_hd__fill_2
XFILLER_31_569 VGND VGND VPWR VPWR sky130_fd_sc_hd__decap_3
XFILLER_7_275 VGND VGND VPWR VPWR sky130_fd_sc_hd__decap_3
XFILLER_3_492 VGND VGND VPWR VPWR sky130_fd_sc_hd__fill_1
XFILLER_22_3 VGND VGND VPWR VPWR sky130_fd_sc_hd__decap_3
XFILLER_38_168 VGND VGND VPWR VPWR sky130_fd_sc_hd__decap_3
XFILLER_19_393 VGND VGND VPWR VPWR sky130_fd_sc_hd__fill_1
XFILLER_81_436 VGND VGND VPWR VPWR sky130_fd_sc_hd__decap_3
X_6951_ _7287_/CLK _6951_/D VGND VGND VPWR VPWR _6951_/Q sky130_fd_sc_hd__dfxtp_2
XFILLER_34_330 VGND VGND VPWR VPWR sky130_fd_sc_hd__decap_3
XFILLER_34_352 VGND VGND VPWR VPWR sky130_fd_sc_hd__decap_3
X_6882_ _7274_/CLK _6882_/D VGND VGND VPWR VPWR _6882_/Q sky130_fd_sc_hd__dfxtp_2
XFILLER_34_374 VGND VGND VPWR VPWR sky130_fd_sc_hd__decap_3
X_5833_ _6984_/Q _5488_/B _5671_/C _6956_/Q VGND VGND VPWR VPWR _5833_/X sky130_fd_sc_hd__a22o_2
XFILLER_14_29 VGND VGND VPWR VPWR sky130_fd_sc_hd__fill_1
XFILLER_22_569 VGND VGND VPWR VPWR sky130_fd_sc_hd__decap_3
X_7503_ _7608_/CLK _7503_/D place2067/X VGND VGND VPWR VPWR _7503_/Q sky130_fd_sc_hd__dfrtp_2
X_5764_ _5764_/A VGND VGND VPWR VPWR _5764_/Y sky130_fd_sc_hd__inv_2
XTAP_TAPCELL_ROW_60_851 VGND VPWR sky130_fd_sc_hd__tapvpwrvgnd_1
XTAP_TAPCELL_ROW_32_564 VGND VPWR sky130_fd_sc_hd__tapvpwrvgnd_1
XFILLER_30_580 VGND VGND VPWR VPWR sky130_fd_sc_hd__decap_3
X_7434_ clkload3/A _7434_/D place2059/X VGND VGND VPWR VPWR _7434_/Q sky130_fd_sc_hd__dfrtp_2
X_4646_ _4646_/A0 _4644_/X _4665_/S VGND VGND VPWR VPWR _6852_/D sky130_fd_sc_hd__mux2_2
X_7365_ clkload9/A _7365_/D place2034/X VGND VGND VPWR VPWR _7365_/Q sky130_fd_sc_hd__dfrtp_2
XFILLER_89_503 VGND VGND VPWR VPWR sky130_fd_sc_hd__fill_1
Xplace1420 _6254_/A VGND VGND VPWR VPWR _6247_/A sky130_fd_sc_hd__buf_2
Xplace1431 _4133_/A VGND VGND VPWR VPWR _4110_/A sky130_fd_sc_hd__buf_2
Xplace1442 _3900_/Y VGND VGND VPWR VPWR _3905_/C sky130_fd_sc_hd__buf_2
Xplace1453 _3795_/Y VGND VGND VPWR VPWR place1453/X sky130_fd_sc_hd__buf_2
Xplace1464 _3668_/A2 VGND VGND VPWR VPWR _4272_/A3 sky130_fd_sc_hd__buf_2
Xplace1475 _5841_/X VGND VGND VPWR VPWR _6564_/D sky130_fd_sc_hd__buf_2
Xplace1486 _3972_/B VGND VGND VPWR VPWR _4131_/A2 sky130_fd_sc_hd__buf_2
X_7296_ clkload6/A _7296_/D place2061/X VGND VGND VPWR VPWR _7296_/Q sky130_fd_sc_hd__dfrtp_2
X_3528_ _7420_/Q VGND VGND VPWR VPWR _3528_/Y sky130_fd_sc_hd__inv_2
XFILLER_103_335 VGND VGND VPWR VPWR sky130_fd_sc_hd__fill_1
Xplace1497 _3896_/C VGND VGND VPWR VPWR _4629_/A1 sky130_fd_sc_hd__buf_2
X_6247_ _6247_/A _6247_/B VGND VGND VPWR VPWR _7331_/D sky130_fd_sc_hd__and2_2
X_3459_ _3459_/A _3459_/B _3843_/B VGND VGND VPWR VPWR _3459_/Y sky130_fd_sc_hd__nand3_2
XFILLER_57_400 VGND VGND VPWR VPWR sky130_fd_sc_hd__decap_3
XFILLER_69_260 VGND VGND VPWR VPWR sky130_fd_sc_hd__decap_3
X_6178_ _6178_/A1 _6177_/Y _6178_/A3 _6083_/Y _6404_/B1 VGND VGND VPWR VPWR _6179_/A
+ sky130_fd_sc_hd__a311o_2
XFILLER_29_113 VGND VGND VPWR VPWR sky130_fd_sc_hd__fill_2
XFILLER_69_293 VGND VGND VPWR VPWR sky130_fd_sc_hd__fill_2
XFILLER_84_230 VGND VGND VPWR VPWR sky130_fd_sc_hd__fill_1
XFILLER_97_591 VGND VGND VPWR VPWR sky130_fd_sc_hd__decap_3
X_5129_ _5129_/A0 _5707_/A1 _5146_/S VGND VGND VPWR VPWR _7028_/D sky130_fd_sc_hd__mux2_2
XTAP_TAPCELL_ROW_68_940 VGND VPWR sky130_fd_sc_hd__tapvpwrvgnd_1
XFILLER_29_146 VGND VGND VPWR VPWR sky130_fd_sc_hd__fill_1
XTAP_TAPCELL_ROW_4_267 VGND VPWR sky130_fd_sc_hd__tapvpwrvgnd_1
XFILLER_72_414 VGND VGND VPWR VPWR sky130_fd_sc_hd__fill_2
XFILLER_25_396 VGND VGND VPWR VPWR sky130_fd_sc_hd__fill_2
XFILLER_52_182 VGND VGND VPWR VPWR sky130_fd_sc_hd__decap_3
XFILLER_40_377 VGND VGND VPWR VPWR sky130_fd_sc_hd__fill_1
XFILLER_40_399 VGND VGND VPWR VPWR sky130_fd_sc_hd__decap_3
XTAP_TAPCELL_ROW_78_1046 VGND VPWR sky130_fd_sc_hd__tapvpwrvgnd_1
XFILLER_0_473 VGND VGND VPWR VPWR sky130_fd_sc_hd__decap_3
XFILLER_29_92 VGND VGND VPWR VPWR sky130_fd_sc_hd__decap_3
XTAP_TAPCELL_ROW_89_1153 VGND VPWR sky130_fd_sc_hd__tapvpwrvgnd_1
XFILLER_63_447 VGND VGND VPWR VPWR sky130_fd_sc_hd__fill_1
XFILLER_16_330 VGND VGND VPWR VPWR sky130_fd_sc_hd__fill_2
XFILLER_31_300 VGND VGND VPWR VPWR sky130_fd_sc_hd__decap_3
XTAP_TAPCELL_ROW_74_998 VGND VPWR sky130_fd_sc_hd__tapvpwrvgnd_1
XFILLER_31_322 VGND VGND VPWR VPWR sky130_fd_sc_hd__decap_3
XFILLER_43_193 VGND VGND VPWR VPWR sky130_fd_sc_hd__decap_3
XFILLER_91_6 VGND VGND VPWR VPWR sky130_fd_sc_hd__decap_3
XFILLER_12_580 VGND VGND VPWR VPWR sky130_fd_sc_hd__decap_3
X_5480_ _5480_/A0 _5724_/A1 _5486_/S VGND VGND VPWR VPWR _7176_/D sky130_fd_sc_hd__mux2_2
X_4500_ _4559_/A _4497_/Y _4498_/X _4499_/X VGND VGND VPWR VPWR _4500_/Y sky130_fd_sc_hd__o31ai_2
XANTENNA_1 _4569_/X VGND VGND VPWR VPWR sky130_fd_sc_hd__diode_2
X_4431_ _4427_/X _4428_/X _4429_/X _4430_/Y VGND VGND VPWR VPWR _4433_/B sky130_fd_sc_hd__a211oi_2
XFILLER_6_85 VGND VGND VPWR VPWR sky130_fd_sc_hd__decap_3
X_7150_ _7217_/CLK _7150_/D VGND VGND VPWR VPWR _7150_/Q sky130_fd_sc_hd__dfxtp_2
X_4362_ _4362_/A _4362_/B _4362_/C _4362_/D VGND VGND VPWR VPWR _4362_/X sky130_fd_sc_hd__and4_2
X_7081_ _7280_/CLK _7081_/D VGND VGND VPWR VPWR _7081_/Q sky130_fd_sc_hd__dfxtp_2
X_4293_ _6183_/A _6183_/B _4300_/A3 _6221_/D1 _4289_/Y VGND VGND VPWR VPWR _4293_/X
+ sky130_fd_sc_hd__o311a_4
XFILLER_86_517 VGND VGND VPWR VPWR sky130_fd_sc_hd__fill_1
X_6032_ _6963_/Q _6501_/A1 _6030_/X _6031_/X VGND VGND VPWR VPWR _6032_/X sky130_fd_sc_hd__o211a_2
XFILLER_94_561 VGND VGND VPWR VPWR sky130_fd_sc_hd__decap_3
XFILLER_66_296 VGND VGND VPWR VPWR sky130_fd_sc_hd__decap_3
XTAP_TAPCELL_ROW_65_910 VGND VPWR sky130_fd_sc_hd__tapvpwrvgnd_1
XTAP_TAPCELL_ROW_37_612 VGND VPWR sky130_fd_sc_hd__tapvpwrvgnd_1
XTAP_TAPCELL_ROW_1_237 VGND VPWR sky130_fd_sc_hd__tapvpwrvgnd_1
XFILLER_26_138 VGND VGND VPWR VPWR sky130_fd_sc_hd__fill_2
X_6934_ _7243_/CLK _6934_/D VGND VGND VPWR VPWR _6934_/Q sky130_fd_sc_hd__dfxtp_2
XFILLER_41_119 VGND VGND VPWR VPWR sky130_fd_sc_hd__decap_3
XFILLER_34_193 VGND VGND VPWR VPWR sky130_fd_sc_hd__decap_3
X_6865_ _7217_/CLK _6865_/D VGND VGND VPWR VPWR _6865_/Q sky130_fd_sc_hd__dfxtp_2
XFILLER_22_344 VGND VGND VPWR VPWR sky130_fd_sc_hd__decap_3
X_6796_ _6805_/A _6796_/B VGND VGND VPWR VPWR _7556_/D sky130_fd_sc_hd__and2_2
X_5816_ _5814_/X _5815_/X _6398_/B1 VGND VGND VPWR VPWR _5820_/C sky130_fd_sc_hd__a21oi_2
XFILLER_10_528 VGND VGND VPWR VPWR sky130_fd_sc_hd__decap_3
X_7417_ _7507_/CLK _7417_/D place2038/X VGND VGND VPWR VPWR _7417_/Q sky130_fd_sc_hd__dfrtp_2
X_4629_ _4750_/A1 _4629_/A1 _4629_/S VGND VGND VPWR VPWR _4629_/X sky130_fd_sc_hd__mux2_2
XTAP_TAPCELL_ROW_9_315 VGND VPWR sky130_fd_sc_hd__tapvpwrvgnd_1
Xplace1250 _5813_/A VGND VGND VPWR VPWR _6392_/A sky130_fd_sc_hd__buf_2
Xplace1261 _4904_/A VGND VGND VPWR VPWR _6506_/A1 sky130_fd_sc_hd__buf_2
X_7348_ _7577_/CLK _7348_/D place2036/X VGND VGND VPWR VPWR _7348_/Q sky130_fd_sc_hd__dfrtp_2
Xplace1272 _6173_/A1 VGND VGND VPWR VPWR _6168_/B2 sky130_fd_sc_hd__buf_6
Xplace1283 _5981_/B2 VGND VGND VPWR VPWR _6507_/B2 sky130_fd_sc_hd__buf_2
Xplace1294 place1295/X VGND VGND VPWR VPWR _6171_/A2 sky130_fd_sc_hd__buf_8
X_7279_ _7279_/CLK _7279_/D VGND VGND VPWR VPWR _7279_/Q sky130_fd_sc_hd__dfxtp_2
XFILLER_77_528 VGND VGND VPWR VPWR sky130_fd_sc_hd__fill_1
XFILLER_17_105 VGND VGND VPWR VPWR sky130_fd_sc_hd__decap_3
XFILLER_57_274 VGND VGND VPWR VPWR sky130_fd_sc_hd__decap_3
XFILLER_45_469 VGND VGND VPWR VPWR sky130_fd_sc_hd__decap_3
XFILLER_72_233 VGND VGND VPWR VPWR sky130_fd_sc_hd__decap_3
XFILLER_82_23 VGND VGND VPWR VPWR sky130_fd_sc_hd__decap_3
XFILLER_13_300 VGND VGND VPWR VPWR sky130_fd_sc_hd__fill_2
XFILLER_13_322 VGND VGND VPWR VPWR sky130_fd_sc_hd__decap_3
XFILLER_15_50 VGND VGND VPWR VPWR sky130_fd_sc_hd__decap_3
XTAP_TAPCELL_ROW_71_968 VGND VPWR sky130_fd_sc_hd__tapvpwrvgnd_1
XFILLER_15_72 VGND VGND VPWR VPWR sky130_fd_sc_hd__fill_1
XFILLER_9_315 VGND VGND VPWR VPWR sky130_fd_sc_hd__fill_1
XFILLER_9_337 VGND VGND VPWR VPWR sky130_fd_sc_hd__fill_2
XFILLER_5_532 VGND VGND VPWR VPWR sky130_fd_sc_hd__fill_1
XFILLER_0_281 VGND VGND VPWR VPWR sky130_fd_sc_hd__decap_3
XFILLER_95_358 VGND VGND VPWR VPWR sky130_fd_sc_hd__fill_1
XFILLER_36_447 VGND VGND VPWR VPWR sky130_fd_sc_hd__decap_3
XFILLER_63_222 VGND VGND VPWR VPWR sky130_fd_sc_hd__fill_2
XFILLER_63_266 VGND VGND VPWR VPWR sky130_fd_sc_hd__decap_3
XFILLER_44_480 VGND VGND VPWR VPWR sky130_fd_sc_hd__fill_2
X_3931_ _7297_/Q _3931_/B _3931_/C VGND VGND VPWR VPWR _3931_/X sky130_fd_sc_hd__and3_2
X_3862_ _4184_/A _3862_/A2 _3862_/A3 _3859_/Y _3861_/Y VGND VGND VPWR VPWR _4189_/A
+ sky130_fd_sc_hd__o41a_4
XFILLER_31_163 VGND VGND VPWR VPWR sky130_fd_sc_hd__decap_3
X_6581_ _6581_/A0 _6441_/X _6590_/S VGND VGND VPWR VPWR _7455_/D sky130_fd_sc_hd__mux2_2
XTAP_TAPCELL_ROW_14_372 VGND VPWR sky130_fd_sc_hd__tapvpwrvgnd_1
X_5532_ _5532_/A0 _5532_/A1 _5532_/S VGND VGND VPWR VPWR _7200_/D sky130_fd_sc_hd__mux2_2
X_3793_ _7439_/Q _3793_/A2 _3816_/B1 _7343_/Q _3792_/X VGND VGND VPWR VPWR _3793_/X
+ sky130_fd_sc_hd__a221o_2
XFILLER_11_19 VGND VGND VPWR VPWR sky130_fd_sc_hd__fill_2
X_5463_ _5463_/A0 _4700_/X _5471_/S VGND VGND VPWR VPWR _7168_/D sky130_fd_sc_hd__mux2_2
X_7202_ _7288_/CLK _7202_/D VGND VGND VPWR VPWR _7202_/Q sky130_fd_sc_hd__dfxtp_2
X_4414_ _4422_/A _4414_/B VGND VGND VPWR VPWR _4430_/B sky130_fd_sc_hd__nand2_2
X_7133_ _7217_/CLK _7133_/D VGND VGND VPWR VPWR _7133_/Q sky130_fd_sc_hd__dfxtp_2
X_4345_ _4345_/A _4345_/B VGND VGND VPWR VPWR _4346_/B sky130_fd_sc_hd__and2_2
XFILLER_98_141 VGND VGND VPWR VPWR sky130_fd_sc_hd__fill_2
X_7064_ _7280_/CLK _7064_/D VGND VGND VPWR VPWR _7064_/Q sky130_fd_sc_hd__dfxtp_2
X_4276_ _4276_/A _4276_/B _4276_/C VGND VGND VPWR VPWR _4276_/X sky130_fd_sc_hd__or3_4
XFILLER_39_252 VGND VGND VPWR VPWR sky130_fd_sc_hd__decap_3
XFILLER_67_561 VGND VGND VPWR VPWR sky130_fd_sc_hd__fill_2
XFILLER_36_27 VGND VGND VPWR VPWR sky130_fd_sc_hd__fill_1
XFILLER_54_200 VGND VGND VPWR VPWR sky130_fd_sc_hd__decap_3
XPHY_EDGE_ROW_6_Left_110 VGND VGND VPWR VPWR sky130_fd_sc_hd__decap_3
XFILLER_15_609 VGND VGND VPWR VPWR sky130_fd_sc_hd__decap_3
XFILLER_36_38 VGND VGND VPWR VPWR sky130_fd_sc_hd__fill_2
XFILLER_36_49 VGND VGND VPWR VPWR sky130_fd_sc_hd__fill_1
XFILLER_82_542 VGND VGND VPWR VPWR sky130_fd_sc_hd__decap_3
XFILLER_14_108 VGND VGND VPWR VPWR sky130_fd_sc_hd__decap_3
X_6917_ _7509_/CLK _6917_/D VGND VGND VPWR VPWR _6917_/Q sky130_fd_sc_hd__dfxtp_2
X_6848_ _7266_/CLK _6848_/D VGND VGND VPWR VPWR _6848_/Q sky130_fd_sc_hd__dfxtp_2
XFILLER_10_303 VGND VGND VPWR VPWR sky130_fd_sc_hd__decap_3
XFILLER_10_347 VGND VGND VPWR VPWR sky130_fd_sc_hd__decap_3
XFILLER_6_307 VGND VGND VPWR VPWR sky130_fd_sc_hd__fill_1
X_6779_ _6789_/A _6779_/B VGND VGND VPWR VPWR _7548_/D sky130_fd_sc_hd__and2_2
XFILLER_6_318 VGND VGND VPWR VPWR sky130_fd_sc_hd__decap_3
XFILLER_89_152 VGND VGND VPWR VPWR sky130_fd_sc_hd__fill_1
Xplace1091 _4257_/Y VGND VGND VPWR VPWR _6202_/B1 sky130_fd_sc_hd__buf_2
XFILLER_45_200 VGND VGND VPWR VPWR sky130_fd_sc_hd__decap_3
XFILLER_92_339 VGND VGND VPWR VPWR sky130_fd_sc_hd__decap_3
XTAP_TAPCELL_ROW_48_729 VGND VPWR sky130_fd_sc_hd__tapvpwrvgnd_1
XTAP_TAPCELL_ROW_86_1123 VGND VPWR sky130_fd_sc_hd__tapvpwrvgnd_1
XFILLER_33_417 VGND VGND VPWR VPWR sky130_fd_sc_hd__fill_2
XFILLER_45_266 VGND VGND VPWR VPWR sky130_fd_sc_hd__fill_1
XFILLER_13_163 VGND VGND VPWR VPWR sky130_fd_sc_hd__decap_3
XTAP_TAPCELL_ROW_97_1241 VGND VPWR sky130_fd_sc_hd__tapvpwrvgnd_1
XTAP_TAPCELL_ROW_11_342 VGND VPWR sky130_fd_sc_hd__tapvpwrvgnd_1
XFILLER_95_122 VGND VGND VPWR VPWR sky130_fd_sc_hd__fill_2
XPHY_EDGE_ROW_79_Left_183 VGND VGND VPWR VPWR sky130_fd_sc_hd__decap_3
XFILLER_3_86 VGND VGND VPWR VPWR sky130_fd_sc_hd__decap_3
X_4061_ _4499_/B _4499_/C VGND VGND VPWR VPWR _7600_/D sky130_fd_sc_hd__nor2_2
XFILLER_49_572 VGND VGND VPWR VPWR sky130_fd_sc_hd__decap_3
XFILLER_83_317 VGND VGND VPWR VPWR sky130_fd_sc_hd__fill_2
XTAP_TAPCELL_ROW_19_420 VGND VPWR sky130_fd_sc_hd__tapvpwrvgnd_1
XFILLER_36_288 VGND VGND VPWR VPWR sky130_fd_sc_hd__decap_3
XFILLER_51_225 VGND VGND VPWR VPWR sky130_fd_sc_hd__decap_3
X_6702_ _6702_/A0 _6561_/Y _6704_/S VGND VGND VPWR VPWR _7512_/D sky130_fd_sc_hd__mux2_2
X_3914_ _7399_/Q _3914_/A2 _3912_/X _3913_/X VGND VGND VPWR VPWR _3915_/C sky130_fd_sc_hd__a211oi_2
XFILLER_32_472 VGND VGND VPWR VPWR sky130_fd_sc_hd__decap_3
XFILLER_32_483 VGND VGND VPWR VPWR sky130_fd_sc_hd__decap_3
XPHY_EDGE_ROW_88_Left_192 VGND VGND VPWR VPWR sky130_fd_sc_hd__decap_3
X_4894_ _4894_/A0 _5661_/A1 _4900_/S VGND VGND VPWR VPWR _6923_/D sky130_fd_sc_hd__mux2_2
X_3845_ _3845_/A _3845_/B _3845_/C VGND VGND VPWR VPWR _3845_/X sky130_fd_sc_hd__and3_2
XTAP_TAPCELL_ROW_102_1289 VGND VPWR sky130_fd_sc_hd__tapvpwrvgnd_1
X_6564_ _6564_/A _6564_/B _6564_/C _6564_/D VGND VGND VPWR VPWR _6564_/Y sky130_fd_sc_hd__nand4_2
X_3776_ _7376_/Q _3776_/A2 _3776_/A3 _3893_/A2 _7536_/Q VGND VGND VPWR VPWR _3776_/X
+ sky130_fd_sc_hd__a32o_2
X_6495_ _6495_/A1 _6495_/A2 _6514_/B1 _5734_/A VGND VGND VPWR VPWR _6495_/X sky130_fd_sc_hd__a211o_2
X_5515_ _5515_/A0 _4670_/X _5547_/S VGND VGND VPWR VPWR _7192_/D sky130_fd_sc_hd__mux2_2
X_5446_ _5446_/A0 _5446_/A1 _5452_/S VGND VGND VPWR VPWR _7160_/D sky130_fd_sc_hd__mux2_2
XFILLER_86_122 VGND VGND VPWR VPWR sky130_fd_sc_hd__fill_1
XFILLER_99_494 VGND VGND VPWR VPWR sky130_fd_sc_hd__fill_1
X_7116_ _7235_/CLK _7116_/D VGND VGND VPWR VPWR _7116_/Q sky130_fd_sc_hd__dfxtp_2
X_4328_ _4324_/X _7583_/D _4388_/S VGND VGND VPWR VPWR _4328_/X sky130_fd_sc_hd__mux2_2
XFILLER_59_369 VGND VGND VPWR VPWR sky130_fd_sc_hd__decap_3
X_7047_ _7273_/CLK _7047_/D VGND VGND VPWR VPWR _7047_/Q sky130_fd_sc_hd__dfxtp_2
X_4259_ _4260_/B _4257_/B _4257_/Y _5750_/A1 VGND VGND VPWR VPWR _4259_/X sky130_fd_sc_hd__o211a_2
XFILLER_86_177 VGND VGND VPWR VPWR sky130_fd_sc_hd__fill_2
XFILLER_42_236 VGND VGND VPWR VPWR sky130_fd_sc_hd__decap_3
XTAP_TAPCELL_ROW_53_776 VGND VPWR sky130_fd_sc_hd__tapvpwrvgnd_1
XFILLER_10_100 VGND VGND VPWR VPWR sky130_fd_sc_hd__decap_3
XFILLER_11_601 VGND VGND VPWR VPWR sky130_fd_sc_hd__fill_1
XFILLER_23_461 VGND VGND VPWR VPWR sky130_fd_sc_hd__fill_1
XFILLER_70_589 VGND VGND VPWR VPWR sky130_fd_sc_hd__decap_3
XTAP_TAPCELL_ROW_81_1075 VGND VPWR sky130_fd_sc_hd__tapvpwrvgnd_1
XTAP_TAPCELL_ROW_25_489 VGND VPWR sky130_fd_sc_hd__tapvpwrvgnd_1
XFILLER_10_166 VGND VGND VPWR VPWR sky130_fd_sc_hd__decap_3
XFILLER_6_104 VGND VGND VPWR VPWR sky130_fd_sc_hd__decap_3
XFILLER_2_365 VGND VGND VPWR VPWR sky130_fd_sc_hd__decap_3
XTAP_TAPCELL_ROW_92_1193 VGND VPWR sky130_fd_sc_hd__tapvpwrvgnd_1
XFILLER_65_317 VGND VGND VPWR VPWR sky130_fd_sc_hd__fill_1
XFILLER_18_233 VGND VGND VPWR VPWR sky130_fd_sc_hd__decap_3
XFILLER_46_531 VGND VGND VPWR VPWR sky130_fd_sc_hd__fill_1
XFILLER_46_542 VGND VGND VPWR VPWR sky130_fd_sc_hd__decap_3
XFILLER_18_277 VGND VGND VPWR VPWR sky130_fd_sc_hd__decap_3
XFILLER_33_203 VGND VGND VPWR VPWR sky130_fd_sc_hd__decap_3
XFILLER_80_309 VGND VGND VPWR VPWR sky130_fd_sc_hd__decap_3
XFILLER_33_225 VGND VGND VPWR VPWR sky130_fd_sc_hd__decap_3
XFILLER_73_372 VGND VGND VPWR VPWR sky130_fd_sc_hd__decap_3
XFILLER_33_258 VGND VGND VPWR VPWR sky130_fd_sc_hd__decap_3
XFILLER_61_578 VGND VGND VPWR VPWR sky130_fd_sc_hd__fill_2
XFILLER_14_472 VGND VGND VPWR VPWR sky130_fd_sc_hd__decap_3
XFILLER_53_80 VGND VGND VPWR VPWR sky130_fd_sc_hd__decap_3
X_3630_ _7477_/Q _3769_/B1 _3789_/B1 _7413_/Q VGND VGND VPWR VPWR _3631_/C sky130_fd_sc_hd__a22oi_2
X_3561_ _3561_/A _3561_/B VGND VGND VPWR VPWR _3561_/Y sky130_fd_sc_hd__nor2_2
XFILLER_52_3 VGND VGND VPWR VPWR sky130_fd_sc_hd__fill_1
Xplace1827 _3544_/B VGND VGND VPWR VPWR _3948_/B sky130_fd_sc_hd__buf_2
Xplace1816 _3975_/B VGND VGND VPWR VPWR _4279_/D sky130_fd_sc_hd__buf_2
Xplace1805 _4003_/A2 VGND VGND VPWR VPWR _4707_/A3 sky130_fd_sc_hd__buf_2
Xplace1849 _3478_/C VGND VGND VPWR VPWR _6708_/A3 sky130_fd_sc_hd__buf_2
Xplace1838 _3815_/A1 VGND VGND VPWR VPWR _3780_/A1 sky130_fd_sc_hd__buf_2
XFILLER_68_100 VGND VGND VPWR VPWR sky130_fd_sc_hd__decap_3
Xhold2529 _6977_/Q VGND VGND VPWR VPWR _5018_/A0 sky130_fd_sc_hd__dlygate4sd3_1
Xhold2518 _6921_/Q VGND VGND VPWR VPWR _4890_/A0 sky130_fd_sc_hd__dlygate4sd3_1
Xhold2507 _7014_/Q VGND VGND VPWR VPWR _5099_/A0 sky130_fd_sc_hd__dlygate4sd3_1
X_5162_ _5162_/A0 _5162_/A1 _5181_/S VGND VGND VPWR VPWR _7043_/D sky130_fd_sc_hd__mux2_2
X_5093_ _5427_/A _5549_/B _5093_/C VGND VGND VPWR VPWR _5095_/S sky130_fd_sc_hd__and3_2
X_4113_ _4110_/A _4110_/B _4109_/Y _4112_/X VGND VGND VPWR VPWR _4114_/A sky130_fd_sc_hd__a31o_2
X_4044_ _7303_/Q _4044_/B VGND VGND VPWR VPWR _4045_/B sky130_fd_sc_hd__nor2_2
XFILLER_24_236 VGND VGND VPWR VPWR sky130_fd_sc_hd__decap_3
XFILLER_24_247 VGND VGND VPWR VPWR sky130_fd_sc_hd__fill_1
X_5995_ _7235_/Q _6168_/B2 _6453_/B1 _7179_/Q VGND VGND VPWR VPWR _5995_/X sky130_fd_sc_hd__o22a_2
XPHY_EDGE_ROW_96_Left_200 VGND VGND VPWR VPWR sky130_fd_sc_hd__decap_3
XFILLER_52_589 VGND VGND VPWR VPWR sky130_fd_sc_hd__fill_2
XFILLER_32_280 VGND VGND VPWR VPWR sky130_fd_sc_hd__decap_3
X_4877_ _4877_/A0 _5705_/A1 _4896_/S VGND VGND VPWR VPWR _6915_/D sky130_fd_sc_hd__mux2_2
XTAP_TAPCELL_ROW_50_746 VGND VPWR sky130_fd_sc_hd__tapvpwrvgnd_1
XTAP_TAPCELL_ROW_22_459 VGND VPWR sky130_fd_sc_hd__tapvpwrvgnd_1
XFILLER_20_464 VGND VGND VPWR VPWR sky130_fd_sc_hd__fill_2
X_7596_ _7610_/CLK _7596_/D place2053/X VGND VGND VPWR VPWR _7596_/Q sky130_fd_sc_hd__dfrtp_2
X_3828_ _6329_/B2 _3855_/A2 _7469_/Q _3828_/B2 VGND VGND VPWR VPWR _3829_/B sky130_fd_sc_hd__a22oi_2
X_6547_ _6547_/A1 _6547_/A2 _6547_/B1 VGND VGND VPWR VPWR _6547_/Y sky130_fd_sc_hd__o21ai_2
X_3759_ _7506_/Q _3788_/B1 _3789_/B1 _7410_/Q _3758_/X VGND VGND VPWR VPWR _4231_/B
+ sky130_fd_sc_hd__a221oi_2
X_6478_ _6476_/X _6477_/X _6478_/B1 VGND VGND VPWR VPWR _6478_/Y sky130_fd_sc_hd__a21oi_2
X_5429_ _5429_/A0 _4576_/X _5454_/S VGND VGND VPWR VPWR _7152_/D sky130_fd_sc_hd__mux2_2
XFILLER_59_188 VGND VGND VPWR VPWR sky130_fd_sc_hd__decap_3
XFILLER_74_147 VGND VGND VPWR VPWR sky130_fd_sc_hd__fill_1
XTAP_TAPCELL_ROW_58_835 VGND VPWR sky130_fd_sc_hd__tapvpwrvgnd_1
XFILLER_62_309 VGND VGND VPWR VPWR sky130_fd_sc_hd__fill_2
XFILLER_74_169 VGND VGND VPWR VPWR sky130_fd_sc_hd__decap_3
XFILLER_74_46 VGND VGND VPWR VPWR sky130_fd_sc_hd__fill_1
XFILLER_15_225 VGND VGND VPWR VPWR sky130_fd_sc_hd__decap_3
XFILLER_43_512 VGND VGND VPWR VPWR sky130_fd_sc_hd__fill_1
XFILLER_82_191 VGND VGND VPWR VPWR sky130_fd_sc_hd__fill_1
XFILLER_30_217 VGND VGND VPWR VPWR sky130_fd_sc_hd__decap_3
XFILLER_7_446 VGND VGND VPWR VPWR sky130_fd_sc_hd__fill_2
XFILLER_7_468 VGND VGND VPWR VPWR sky130_fd_sc_hd__decap_3
XTAP_TAPCELL_ROW_94_1211 VGND VPWR sky130_fd_sc_hd__tapvpwrvgnd_1
XFILLER_2_162 VGND VGND VPWR VPWR sky130_fd_sc_hd__fill_2
XFILLER_78_475 VGND VGND VPWR VPWR sky130_fd_sc_hd__fill_1
XFILLER_46_361 VGND VGND VPWR VPWR sky130_fd_sc_hd__decap_3
XFILLER_65_158 VGND VGND VPWR VPWR sky130_fd_sc_hd__fill_2
XFILLER_65_169 VGND VGND VPWR VPWR sky130_fd_sc_hd__decap_3
XFILLER_34_545 VGND VGND VPWR VPWR sky130_fd_sc_hd__fill_1
XFILLER_61_331 VGND VGND VPWR VPWR sky130_fd_sc_hd__decap_3
X_4800_ _4800_/A0 _5690_/A1 _4806_/S VGND VGND VPWR VPWR _6880_/D sky130_fd_sc_hd__mux2_2
XFILLER_21_217 VGND VGND VPWR VPWR sky130_fd_sc_hd__decap_3
XFILLER_34_589 VGND VGND VPWR VPWR sky130_fd_sc_hd__fill_2
X_5780_ _5775_/X _5777_/X _5778_/X VGND VGND VPWR VPWR _5789_/C sky130_fd_sc_hd__a21oi_2
XFILLER_9_52 VGND VGND VPWR VPWR sky130_fd_sc_hd__decap_3
XFILLER_9_96 VGND VGND VPWR VPWR sky130_fd_sc_hd__decap_3
X_7450_ _7514_/CLK _7450_/D place2040/X VGND VGND VPWR VPWR _7450_/Q sky130_fd_sc_hd__dfrtp_2
X_4662_ _4675_/B _6437_/B1 _4662_/B1 VGND VGND VPWR VPWR _4662_/Y sky130_fd_sc_hd__o21ai_2
X_6401_ _6401_/A1 _6896_/Q _7288_/Q _6401_/B2 VGND VGND VPWR VPWR _6401_/X sky130_fd_sc_hd__o22a_2
X_3613_ _7315_/Q _3761_/B _3761_/C VGND VGND VPWR VPWR _3670_/B sky130_fd_sc_hd__and3_2
Xplace1602 _3541_/X VGND VGND VPWR VPWR _3999_/B1 sky130_fd_sc_hd__buf_4
X_7381_ _7577_/CLK _7381_/D place2036/X VGND VGND VPWR VPWR _7381_/Q sky130_fd_sc_hd__dfrtp_2
X_4593_ _4593_/A0 _4755_/A _4665_/S VGND VGND VPWR VPWR _6845_/D sky130_fd_sc_hd__mux2_2
Xplace1613 _6634_/S VGND VGND VPWR VPWR _6638_/S sky130_fd_sc_hd__buf_2
Xplace1624 _6163_/A VGND VGND VPWR VPWR _5750_/A1 sky130_fd_sc_hd__buf_2
Xplace1635 _3881_/B VGND VGND VPWR VPWR _3788_/B1 sky130_fd_sc_hd__buf_6
X_6332_ _7408_/Q _6346_/A2 _6335_/A3 _6345_/B1 _6332_/B2 VGND VGND VPWR VPWR _6332_/X
+ sky130_fd_sc_hd__a32o_2
X_3544_ _7389_/Q _3544_/B _3544_/C VGND VGND VPWR VPWR _3549_/A sky130_fd_sc_hd__nand3_2
Xhold3005 _7544_/Q VGND VGND VPWR VPWR _6769_/A1 sky130_fd_sc_hd__dlygate4sd3_1
Xplace1646 _3582_/Y VGND VGND VPWR VPWR _6465_/B sky130_fd_sc_hd__buf_2
Xplace1657 _3536_/X VGND VGND VPWR VPWR _3965_/B1 sky130_fd_sc_hd__buf_4
Xplace1668 _3901_/C VGND VGND VPWR VPWR _3817_/A3 sky130_fd_sc_hd__buf_2
X_3475_ _3414_/B _3475_/B _3475_/C VGND VGND VPWR VPWR _3542_/B sky130_fd_sc_hd__nand3b_2
XFILLER_103_539 VGND VGND VPWR VPWR sky130_fd_sc_hd__fill_1
Xhold3016 _7442_/Q VGND VGND VPWR VPWR _6544_/A0 sky130_fd_sc_hd__dlygate4sd3_1
Xhold3027 _7540_/Q VGND VGND VPWR VPWR _6761_/A1 sky130_fd_sc_hd__dlygate4sd3_1
Xhold3038 _7589_/Q VGND VGND VPWR VPWR _6018_/B2 sky130_fd_sc_hd__dlygate4sd3_1
Xplace1679 _3825_/A2 VGND VGND VPWR VPWR _3903_/A2 sky130_fd_sc_hd__buf_4
X_6194_ _6192_/X _6193_/X _6211_/B1 _6457_/C1 VGND VGND VPWR VPWR _6198_/B sky130_fd_sc_hd__a211o_2
XFILLER_29_317 VGND VGND VPWR VPWR sky130_fd_sc_hd__decap_3
XFILLER_69_486 VGND VGND VPWR VPWR sky130_fd_sc_hd__fill_1
XFILLER_56_114 VGND VGND VPWR VPWR sky130_fd_sc_hd__decap_3
XFILLER_56_147 VGND VGND VPWR VPWR sky130_fd_sc_hd__decap_3
X_5076_ _5076_/A0 _5715_/A1 _5091_/S VGND VGND VPWR VPWR _7004_/D sky130_fd_sc_hd__mux2_2
XFILLER_37_350 VGND VGND VPWR VPWR sky130_fd_sc_hd__decap_3
XFILLER_44_309 VGND VGND VPWR VPWR sky130_fd_sc_hd__decap_3
X_4027_ _4028_/B _4028_/C _4027_/B1 VGND VGND VPWR VPWR _7586_/D sky130_fd_sc_hd__a21oi_2
XTAP_TAPCELL_ROW_55_805 VGND VPWR sky130_fd_sc_hd__tapvpwrvgnd_1
XTAP_TAPCELL_ROW_27_507 VGND VPWR sky130_fd_sc_hd__tapvpwrvgnd_1
XFILLER_25_545 VGND VGND VPWR VPWR sky130_fd_sc_hd__decap_3
XFILLER_44_27 VGND VGND VPWR VPWR sky130_fd_sc_hd__fill_1
X_5978_ _5978_/A _5978_/B _5978_/C _5978_/D VGND VGND VPWR VPWR _5979_/B sky130_fd_sc_hd__and4_2
XTAP_TAPCELL_ROW_63_882 VGND VPWR sky130_fd_sc_hd__tapvpwrvgnd_1
XFILLER_12_239 VGND VGND VPWR VPWR sky130_fd_sc_hd__decap_3
XTAP_TAPCELL_ROW_35_595 VGND VPWR sky130_fd_sc_hd__tapvpwrvgnd_1
XFILLER_60_26 VGND VGND VPWR VPWR sky130_fd_sc_hd__fill_2
X_7579_ _7579_/CLK _7579_/D place2035/X VGND VGND VPWR VPWR _7579_/Q sky130_fd_sc_hd__dfrtp_2
XFILLER_79_206 VGND VGND VPWR VPWR sky130_fd_sc_hd__fill_1
XFILLER_0_611 VGND VGND VPWR VPWR sky130_fd_sc_hd__fill_1
XTAP_TAPCELL_ROW_7_298 VGND VPWR sky130_fd_sc_hd__tapvpwrvgnd_1
XFILLER_47_136 VGND VGND VPWR VPWR sky130_fd_sc_hd__decap_3
XFILLER_85_45 VGND VGND VPWR VPWR sky130_fd_sc_hd__fill_2
Xhold2860 _7343_/Q VGND VGND VPWR VPWR _6273_/B sky130_fd_sc_hd__dlygate4sd3_1
Xhold2871 _7347_/Q VGND VGND VPWR VPWR _6281_/B sky130_fd_sc_hd__dlygate4sd3_1
Xhold2882 _6346_/X VGND VGND VPWR VPWR _7387_/D sky130_fd_sc_hd__dlygate4sd3_1
Xhold2893 _7382_/Q VGND VGND VPWR VPWR _6341_/B2 sky130_fd_sc_hd__dlygate4sd3_1
XFILLER_35_309 VGND VGND VPWR VPWR sky130_fd_sc_hd__decap_3
XFILLER_47_169 VGND VGND VPWR VPWR sky130_fd_sc_hd__decap_3
XFILLER_18_83 VGND VGND VPWR VPWR sky130_fd_sc_hd__fill_1
XFILLER_28_361 VGND VGND VPWR VPWR sky130_fd_sc_hd__decap_3
XFILLER_62_128 VGND VGND VPWR VPWR sky130_fd_sc_hd__fill_2
XFILLER_43_331 VGND VGND VPWR VPWR sky130_fd_sc_hd__decap_3
XFILLER_55_180 VGND VGND VPWR VPWR sky130_fd_sc_hd__fill_1
XFILLER_55_191 VGND VGND VPWR VPWR sky130_fd_sc_hd__fill_1
XFILLER_16_589 VGND VGND VPWR VPWR sky130_fd_sc_hd__fill_1
XFILLER_31_526 VGND VGND VPWR VPWR sky130_fd_sc_hd__decap_3
XFILLER_34_71 VGND VGND VPWR VPWR sky130_fd_sc_hd__fill_1
XFILLER_7_254 VGND VGND VPWR VPWR sky130_fd_sc_hd__decap_3
XFILLER_50_81 VGND VGND VPWR VPWR sky130_fd_sc_hd__decap_3
XFILLER_7_287 VGND VGND VPWR VPWR sky130_fd_sc_hd__decap_3
XFILLER_98_504 VGND VGND VPWR VPWR sky130_fd_sc_hd__fill_1
XFILLER_15_3 VGND VGND VPWR VPWR sky130_fd_sc_hd__decap_3
XFILLER_38_136 VGND VGND VPWR VPWR sky130_fd_sc_hd__decap_3
XFILLER_78_283 VGND VGND VPWR VPWR sky130_fd_sc_hd__fill_2
XFILLER_78_294 VGND VGND VPWR VPWR sky130_fd_sc_hd__decap_3
XFILLER_26_309 VGND VGND VPWR VPWR sky130_fd_sc_hd__decap_3
XFILLER_66_467 VGND VGND VPWR VPWR sky130_fd_sc_hd__fill_1
X_6950_ _7291_/CLK _6950_/D VGND VGND VPWR VPWR _6950_/Q sky130_fd_sc_hd__dfxtp_2
XFILLER_53_128 VGND VGND VPWR VPWR sky130_fd_sc_hd__decap_3
XFILLER_46_180 VGND VGND VPWR VPWR sky130_fd_sc_hd__decap_3
X_6881_ _7273_/CLK _6881_/D VGND VGND VPWR VPWR _6881_/Q sky130_fd_sc_hd__dfxtp_2
XFILLER_22_504 VGND VGND VPWR VPWR sky130_fd_sc_hd__decap_3
X_5832_ _5830_/X _5831_/X _5549_/C VGND VGND VPWR VPWR _5832_/Y sky130_fd_sc_hd__o21ai_2
XFILLER_22_548 VGND VGND VPWR VPWR sky130_fd_sc_hd__decap_3
XFILLER_61_172 VGND VGND VPWR VPWR sky130_fd_sc_hd__decap_3
X_5763_ _6893_/Q _6204_/A2 _6921_/Q _6451_/B1 VGND VGND VPWR VPWR _5763_/X sky130_fd_sc_hd__o22a_2
X_7502_ _7610_/CLK _7502_/D place2056/X VGND VGND VPWR VPWR _7502_/Q sky130_fd_sc_hd__dfrtp_2
X_4714_ _7377_/Q _4767_/B2 _4767_/B1 _4713_/X VGND VGND VPWR VPWR _4714_/X sky130_fd_sc_hd__a31o_2
XTAP_TAPCELL_ROW_60_852 VGND VPWR sky130_fd_sc_hd__tapvpwrvgnd_1
XTAP_TAPCELL_ROW_32_554 VGND VPWR sky130_fd_sc_hd__tapvpwrvgnd_1
X_5694_ _5694_/A0 _5694_/A1 _5696_/S VGND VGND VPWR VPWR _7274_/D sky130_fd_sc_hd__mux2_2
XPHY_EDGE_ROW_15_Left_119 VGND VGND VPWR VPWR sky130_fd_sc_hd__decap_3
X_7433_ clkload4/A _7433_/D place2063/X VGND VGND VPWR VPWR _7433_/Q sky130_fd_sc_hd__dfrtp_2
Xplace1410 _3741_/B VGND VGND VPWR VPWR _4289_/A sky130_fd_sc_hd__buf_2
X_7364_ _7493_/CLK _7364_/D place2017/X VGND VGND VPWR VPWR _7364_/Q sky130_fd_sc_hd__dfrtp_2
X_4576_ _7388_/Q _6658_/S _4576_/B1 _6416_/A0 _4576_/C1 VGND VGND VPWR VPWR _4576_/X
+ sky130_fd_sc_hd__a221o_2
Xplace1421 _6292_/A VGND VGND VPWR VPWR _6298_/A sky130_fd_sc_hd__buf_2
Xplace1432 _4001_/B VGND VGND VPWR VPWR _4136_/A2 sky130_fd_sc_hd__buf_2
Xplace1443 _3896_/X VGND VGND VPWR VPWR _4157_/B sky130_fd_sc_hd__buf_2
X_3527_ _3536_/B _3566_/D1 _3526_/Y VGND VGND VPWR VPWR _3527_/Y sky130_fd_sc_hd__a21oi_4
Xplace1454 _3794_/Y VGND VGND VPWR VPWR _4698_/A1 sky130_fd_sc_hd__buf_2
Xplace1465 _3665_/Y VGND VGND VPWR VPWR _3668_/A2 sky130_fd_sc_hd__buf_2
Xplace1476 _5612_/A1 VGND VGND VPWR VPWR _5673_/A1 sky130_fd_sc_hd__buf_2
Xplace1487 _3972_/B VGND VGND VPWR VPWR _4584_/B1 sky130_fd_sc_hd__buf_2
X_7295_ clkload6/A _7295_/D place2030/X VGND VGND VPWR VPWR _7295_/Q sky130_fd_sc_hd__dfrtp_2
Xplace1498 _3882_/Y VGND VGND VPWR VPWR _4435_/B1 sky130_fd_sc_hd__buf_2
X_3458_ _3458_/A _4337_/B _4373_/B _3843_/B VGND VGND VPWR VPWR _3458_/Y sky130_fd_sc_hd__nand4_2
XFILLER_57_412 VGND VGND VPWR VPWR sky130_fd_sc_hd__decap_3
X_6177_ _5813_/A _6166_/X _6169_/X _6176_/X VGND VGND VPWR VPWR _6177_/Y sky130_fd_sc_hd__o211ai_2
XPHY_EDGE_ROW_24_Left_128 VGND VGND VPWR VPWR sky130_fd_sc_hd__decap_3
XTAP_TAPCELL_ROW_68_941 VGND VPWR sky130_fd_sc_hd__tapvpwrvgnd_1
XFILLER_29_169 VGND VGND VPWR VPWR sky130_fd_sc_hd__decap_3
XTAP_TAPCELL_ROW_4_268 VGND VPWR sky130_fd_sc_hd__tapvpwrvgnd_1
XFILLER_55_48 VGND VGND VPWR VPWR sky130_fd_sc_hd__decap_3
X_5059_ _5059_/A0 _5637_/A1 _5059_/S VGND VGND VPWR VPWR _6996_/D sky130_fd_sc_hd__mux2_2
XFILLER_25_331 VGND VGND VPWR VPWR sky130_fd_sc_hd__decap_3
XFILLER_25_353 VGND VGND VPWR VPWR sky130_fd_sc_hd__decap_3
XFILLER_52_161 VGND VGND VPWR VPWR sky130_fd_sc_hd__decap_3
XFILLER_52_194 VGND VGND VPWR VPWR sky130_fd_sc_hd__fill_2
XFILLER_9_508 VGND VGND VPWR VPWR sky130_fd_sc_hd__decap_3
XFILLER_21_570 VGND VGND VPWR VPWR sky130_fd_sc_hd__fill_2
XPHY_EDGE_ROW_33_Left_137 VGND VGND VPWR VPWR sky130_fd_sc_hd__decap_3
XTAP_TAPCELL_ROW_78_1047 VGND VPWR sky130_fd_sc_hd__tapvpwrvgnd_1
XFILLER_0_452 VGND VGND VPWR VPWR sky130_fd_sc_hd__decap_3
XPHY_EDGE_ROW_42_Left_146 VGND VGND VPWR VPWR sky130_fd_sc_hd__decap_3
XFILLER_102_391 VGND VGND VPWR VPWR sky130_fd_sc_hd__decap_3
XFILLER_29_60 VGND VGND VPWR VPWR sky130_fd_sc_hd__decap_3
XFILLER_75_220 VGND VGND VPWR VPWR sky130_fd_sc_hd__decap_3
XFILLER_48_456 VGND VGND VPWR VPWR sky130_fd_sc_hd__decap_3
Xhold2690 _7222_/Q VGND VGND VPWR VPWR _5581_/A0 sky130_fd_sc_hd__dlygate4sd3_1
XTAP_TAPCELL_ROW_89_1154 VGND VPWR sky130_fd_sc_hd__tapvpwrvgnd_1
XFILLER_75_275 VGND VGND VPWR VPWR sky130_fd_sc_hd__fill_1
XFILLER_16_320 VGND VGND VPWR VPWR sky130_fd_sc_hd__decap_3
XFILLER_28_180 VGND VGND VPWR VPWR sky130_fd_sc_hd__fill_1
XTAP_TAPCELL_ROW_74_999 VGND VPWR sky130_fd_sc_hd__tapvpwrvgnd_1
XFILLER_43_172 VGND VGND VPWR VPWR sky130_fd_sc_hd__decap_3
XFILLER_71_481 VGND VGND VPWR VPWR sky130_fd_sc_hd__fill_2
XFILLER_31_356 VGND VGND VPWR VPWR sky130_fd_sc_hd__decap_3
XPHY_EDGE_ROW_51_Left_155 VGND VGND VPWR VPWR sky130_fd_sc_hd__decap_3
XFILLER_31_389 VGND VGND VPWR VPWR sky130_fd_sc_hd__decap_3
XANTENNA_2 _4776_/S VGND VGND VPWR VPWR sky130_fd_sc_hd__diode_2
X_4430_ _4430_/A _4430_/B _4430_/C VGND VGND VPWR VPWR _4430_/Y sky130_fd_sc_hd__nor3_2
XFILLER_6_53 VGND VGND VPWR VPWR sky130_fd_sc_hd__decap_3
X_6100_ _6095_/X _6395_/B1 _6392_/A _6099_/X VGND VGND VPWR VPWR _6100_/X sky130_fd_sc_hd__o22a_2
X_4361_ _4361_/A _4361_/B VGND VGND VPWR VPWR _4362_/D sky130_fd_sc_hd__nand2_2
XFILLER_98_334 VGND VGND VPWR VPWR sky130_fd_sc_hd__fill_2
XPHY_EDGE_ROW_60_Left_164 VGND VGND VPWR VPWR sky130_fd_sc_hd__decap_3
X_7080_ _7276_/CLK _7080_/D VGND VGND VPWR VPWR _7080_/Q sky130_fd_sc_hd__dfxtp_2
X_4292_ _4288_/X _4282_/Y _4290_/Y _4291_/X VGND VGND VPWR VPWR _4292_/Y sky130_fd_sc_hd__o2bb2ai_2
X_6031_ _6507_/A1 _7019_/Q _6935_/Q _6507_/B2 VGND VGND VPWR VPWR _6031_/X sky130_fd_sc_hd__o22a_2
XFILLER_66_220 VGND VGND VPWR VPWR sky130_fd_sc_hd__decap_3
XFILLER_66_275 VGND VGND VPWR VPWR sky130_fd_sc_hd__decap_3
XTAP_TAPCELL_ROW_37_613 VGND VPWR sky130_fd_sc_hd__tapvpwrvgnd_1
XTAP_TAPCELL_ROW_1_238 VGND VPWR sky130_fd_sc_hd__tapvpwrvgnd_1
X_6933_ _7243_/CLK _6933_/D VGND VGND VPWR VPWR _6933_/Q sky130_fd_sc_hd__dfxtp_2
XFILLER_22_301 VGND VGND VPWR VPWR sky130_fd_sc_hd__decap_3
X_6864_ _7235_/CLK _6864_/D VGND VGND VPWR VPWR _6864_/Q sky130_fd_sc_hd__dfxtp_2
XFILLER_22_312 VGND VGND VPWR VPWR sky130_fd_sc_hd__fill_2
X_5815_ _5815_/A1 _6997_/Q _6969_/Q _6390_/A1 VGND VGND VPWR VPWR _5815_/X sky130_fd_sc_hd__o22a_2
X_5746_ _6064_/A1 _5759_/D1 _4842_/C _4780_/C VGND VGND VPWR VPWR _5746_/X sky130_fd_sc_hd__a31o_4
X_5677_ _5677_/A0 _5677_/A1 _5696_/S VGND VGND VPWR VPWR _7266_/D sky130_fd_sc_hd__mux2_2
X_7416_ _7507_/CLK _7416_/D place2039/X VGND VGND VPWR VPWR _7416_/Q sky130_fd_sc_hd__dfrtp_2
XTAP_TAPCELL_ROW_9_316 VGND VPWR sky130_fd_sc_hd__tapvpwrvgnd_1
Xplace1240 _4508_/A VGND VGND VPWR VPWR _4533_/A sky130_fd_sc_hd__buf_2
Xplace1251 _5781_/Y VGND VGND VPWR VPWR _5813_/A sky130_fd_sc_hd__buf_2
X_7347_ _7575_/CLK _7347_/D place2012/X VGND VGND VPWR VPWR _7347_/Q sky130_fd_sc_hd__dfrtp_2
X_4559_ _4559_/A _4559_/B _4572_/B VGND VGND VPWR VPWR _4559_/X sky130_fd_sc_hd__or3_2
XFILLER_1_249 VGND VGND VPWR VPWR sky130_fd_sc_hd__fill_1
XFILLER_89_334 VGND VGND VPWR VPWR sky130_fd_sc_hd__fill_2
Xplace1262 _4105_/Y VGND VGND VPWR VPWR _4904_/A sky130_fd_sc_hd__buf_2
Xplace1273 _6138_/A1 VGND VGND VPWR VPWR _6154_/A1 sky130_fd_sc_hd__buf_4
Xplace1284 _6450_/B2 VGND VGND VPWR VPWR _6448_/B2 sky130_fd_sc_hd__buf_2
Xplace1295 _5750_/X VGND VGND VPWR VPWR place1295/X sky130_fd_sc_hd__buf_8
X_7278_ _7407_/CLK _7278_/D VGND VGND VPWR VPWR _7278_/Q sky130_fd_sc_hd__dfxtp_2
X_6229_ _6229_/A1 _6229_/A2 _6229_/B1 _7611_/Q VGND VGND VPWR VPWR _6229_/X sky130_fd_sc_hd__o22a_2
XFILLER_66_25 VGND VGND VPWR VPWR sky130_fd_sc_hd__decap_3
XFILLER_57_231 VGND VGND VPWR VPWR sky130_fd_sc_hd__fill_1
XFILLER_66_58 VGND VGND VPWR VPWR sky130_fd_sc_hd__decap_3
XFILLER_72_256 VGND VGND VPWR VPWR sky130_fd_sc_hd__fill_2
XFILLER_13_334 VGND VGND VPWR VPWR sky130_fd_sc_hd__fill_2
XFILLER_25_172 VGND VGND VPWR VPWR sky130_fd_sc_hd__fill_1
XFILLER_25_183 VGND VGND VPWR VPWR sky130_fd_sc_hd__decap_3
XFILLER_53_481 VGND VGND VPWR VPWR sky130_fd_sc_hd__decap_3
XFILLER_15_84 VGND VGND VPWR VPWR sky130_fd_sc_hd__decap_3
XTAP_TAPCELL_ROW_71_969 VGND VPWR sky130_fd_sc_hd__tapvpwrvgnd_1
XFILLER_9_349 VGND VGND VPWR VPWR sky130_fd_sc_hd__decap_3
XFILLER_31_50 VGND VGND VPWR VPWR sky130_fd_sc_hd__decap_3
XFILLER_48_253 VGND VGND VPWR VPWR sky130_fd_sc_hd__decap_3
XFILLER_63_212 VGND VGND VPWR VPWR sky130_fd_sc_hd__decap_3
XFILLER_48_297 VGND VGND VPWR VPWR sky130_fd_sc_hd__decap_3
XFILLER_56_91 VGND VGND VPWR VPWR sky130_fd_sc_hd__decap_3
XFILLER_63_278 VGND VGND VPWR VPWR sky130_fd_sc_hd__fill_2
X_3930_ _3832_/A _3946_/C _3974_/A2 VGND VGND VPWR VPWR _3930_/Y sky130_fd_sc_hd__o21ai_2
XFILLER_16_172 VGND VGND VPWR VPWR sky130_fd_sc_hd__decap_3
XFILLER_44_470 VGND VGND VPWR VPWR sky130_fd_sc_hd__decap_3
XFILLER_16_194 VGND VGND VPWR VPWR sky130_fd_sc_hd__fill_2
X_3861_ _3832_/A _3862_/A3 _3860_/Y VGND VGND VPWR VPWR _3861_/Y sky130_fd_sc_hd__o21bai_2
XFILLER_82_3 VGND VGND VPWR VPWR sky130_fd_sc_hd__decap_3
X_5600_ _5600_/A0 _5600_/A1 _5606_/S VGND VGND VPWR VPWR _7231_/D sky130_fd_sc_hd__mux2_2
X_3792_ _3815_/A1 _3792_/A2 _7375_/Q _3792_/B1 _7567_/Q VGND VGND VPWR VPWR _3792_/X
+ sky130_fd_sc_hd__a32o_2
XTAP_TAPCELL_ROW_42_660 VGND VPWR sky130_fd_sc_hd__tapvpwrvgnd_1
XTAP_TAPCELL_ROW_14_373 VGND VPWR sky130_fd_sc_hd__tapvpwrvgnd_1
X_7201_ _7217_/CLK _7201_/D VGND VGND VPWR VPWR _7201_/Q sky130_fd_sc_hd__dfxtp_2
X_5393_ _5393_/A0 _4670_/X _5425_/S VGND VGND VPWR VPWR _7136_/D sky130_fd_sc_hd__mux2_2
X_4413_ _4379_/A _4379_/B _4448_/B _7300_/Q VGND VGND VPWR VPWR _4414_/B sky130_fd_sc_hd__a31o_2
X_7132_ _7272_/CLK _7132_/D VGND VGND VPWR VPWR _7132_/Q sky130_fd_sc_hd__dfxtp_2
X_4344_ _4345_/A _4345_/B VGND VGND VPWR VPWR _4346_/A sky130_fd_sc_hd__nor2_2
XFILLER_59_518 VGND VGND VPWR VPWR sky130_fd_sc_hd__fill_1
X_7063_ _7289_/CLK _7063_/D VGND VGND VPWR VPWR _7063_/Q sky130_fd_sc_hd__dfxtp_2
X_6014_ _5807_/X _4905_/A _6495_/A2 VGND VGND VPWR VPWR _6014_/Y sky130_fd_sc_hd__a21oi_2
X_4275_ _4266_/X _4255_/Y _4274_/X VGND VGND VPWR VPWR _4276_/C sky130_fd_sc_hd__a21oi_4
XFILLER_39_231 VGND VGND VPWR VPWR sky130_fd_sc_hd__decap_3
XFILLER_100_169 VGND VGND VPWR VPWR sky130_fd_sc_hd__fill_1
XFILLER_54_212 VGND VGND VPWR VPWR sky130_fd_sc_hd__decap_3
XFILLER_27_459 VGND VGND VPWR VPWR sky130_fd_sc_hd__fill_1
XFILLER_23_610 VGND VGND VPWR VPWR sky130_fd_sc_hd__fill_2
X_6916_ _7282_/CLK _6916_/D VGND VGND VPWR VPWR _6916_/Q sky130_fd_sc_hd__dfxtp_2
XFILLER_52_38 VGND VGND VPWR VPWR sky130_fd_sc_hd__decap_3
X_6847_ _7272_/CLK _6847_/D VGND VGND VPWR VPWR _6847_/Q sky130_fd_sc_hd__dfxtp_2
XFILLER_22_164 VGND VGND VPWR VPWR sky130_fd_sc_hd__decap_3
XFILLER_50_462 VGND VGND VPWR VPWR sky130_fd_sc_hd__decap_3
XTAP_TAPCELL_ROW_75_1006 VGND VPWR sky130_fd_sc_hd__tapvpwrvgnd_1
XFILLER_2_536 VGND VGND VPWR VPWR sky130_fd_sc_hd__decap_3
Xplace1081 _4299_/Y VGND VGND VPWR VPWR _6225_/D1 sky130_fd_sc_hd__buf_2
Xplace1092 _4208_/Y VGND VGND VPWR VPWR _6143_/B1 sky130_fd_sc_hd__buf_2
XFILLER_18_404 VGND VGND VPWR VPWR sky130_fd_sc_hd__decap_3
XFILLER_45_212 VGND VGND VPWR VPWR sky130_fd_sc_hd__decap_3
XFILLER_45_234 VGND VGND VPWR VPWR sky130_fd_sc_hd__decap_3
XTAP_TAPCELL_ROW_86_1124 VGND VPWR sky130_fd_sc_hd__tapvpwrvgnd_1
XFILLER_45_278 VGND VGND VPWR VPWR sky130_fd_sc_hd__fill_2
XFILLER_26_492 VGND VGND VPWR VPWR sky130_fd_sc_hd__decap_3
XFILLER_26_61 VGND VGND VPWR VPWR sky130_fd_sc_hd__fill_1
XFILLER_60_215 VGND VGND VPWR VPWR sky130_fd_sc_hd__decap_3
XFILLER_60_237 VGND VGND VPWR VPWR sky130_fd_sc_hd__decap_3
XFILLER_13_142 VGND VGND VPWR VPWR sky130_fd_sc_hd__decap_3
XFILLER_60_259 VGND VGND VPWR VPWR sky130_fd_sc_hd__fill_2
XFILLER_9_113 VGND VGND VPWR VPWR sky130_fd_sc_hd__decap_3
XFILLER_13_186 VGND VGND VPWR VPWR sky130_fd_sc_hd__decap_3
XFILLER_9_135 VGND VGND VPWR VPWR sky130_fd_sc_hd__decap_3
XTAP_TAPCELL_ROW_11_343 VGND VPWR sky130_fd_sc_hd__tapvpwrvgnd_1
XTAP_TAPCELL_ROW_97_1242 VGND VPWR sky130_fd_sc_hd__tapvpwrvgnd_1
XFILLER_68_315 VGND VGND VPWR VPWR sky130_fd_sc_hd__fill_1
XFILLER_36_212 VGND VGND VPWR VPWR sky130_fd_sc_hd__decap_3
XTAP_TAPCELL_ROW_19_421 VGND VPWR sky130_fd_sc_hd__tapvpwrvgnd_1
XFILLER_36_256 VGND VGND VPWR VPWR sky130_fd_sc_hd__fill_2
XFILLER_36_267 VGND VGND VPWR VPWR sky130_fd_sc_hd__decap_3
XFILLER_17_470 VGND VGND VPWR VPWR sky130_fd_sc_hd__decap_3
XFILLER_17_481 VGND VGND VPWR VPWR sky130_fd_sc_hd__decap_3
XFILLER_17_492 VGND VGND VPWR VPWR sky130_fd_sc_hd__decap_3
XFILLER_51_215 VGND VGND VPWR VPWR sky130_fd_sc_hd__decap_3
XFILLER_51_237 VGND VGND VPWR VPWR sky130_fd_sc_hd__decap_3
X_4962_ _4962_/A0 _4769_/Y _4964_/S VGND VGND VPWR VPWR _6954_/D sky130_fd_sc_hd__mux2_2
XFILLER_32_451 VGND VGND VPWR VPWR sky130_fd_sc_hd__decap_3
X_3913_ _7431_/Q _3913_/A2 _3923_/B1 _7335_/Q VGND VGND VPWR VPWR _3913_/X sky130_fd_sc_hd__a22o_2
XFILLER_20_602 VGND VGND VPWR VPWR sky130_fd_sc_hd__fill_2
X_6632_ _6632_/A0 _6406_/Y _6638_/S VGND VGND VPWR VPWR _7479_/D sky130_fd_sc_hd__mux2_2
X_3844_ _3844_/A _3961_/C VGND VGND VPWR VPWR _3845_/B sky130_fd_sc_hd__nor2_2
XFILLER_32_495 VGND VGND VPWR VPWR sky130_fd_sc_hd__decap_3
X_3775_ _4905_/A _3767_/Y _4142_/B2 _3773_/Y _3774_/X VGND VGND VPWR VPWR _4236_/C
+ sky130_fd_sc_hd__o41a_2
XFILLER_8_190 VGND VGND VPWR VPWR sky130_fd_sc_hd__decap_3
X_6494_ _5962_/B _5962_/C _5962_/D _6513_/B1 VGND VGND VPWR VPWR _6494_/X sky130_fd_sc_hd__a31o_2
X_7115_ _7575_/CLK _7115_/D VGND VGND VPWR VPWR _7115_/Q sky130_fd_sc_hd__dfxtp_2
X_5376_ _5376_/A0 _5376_/A1 _5425_/S VGND VGND VPWR VPWR _7128_/D sky130_fd_sc_hd__mux2_2
XFILLER_59_337 VGND VGND VPWR VPWR sky130_fd_sc_hd__fill_2
XFILLER_101_445 VGND VGND VPWR VPWR sky130_fd_sc_hd__decap_3
X_7046_ _7243_/CLK _7046_/D VGND VGND VPWR VPWR _7046_/Q sky130_fd_sc_hd__dfxtp_2
XFILLER_27_212 VGND VGND VPWR VPWR sky130_fd_sc_hd__decap_3
X_4189_ _4189_/A _3850_/Y VGND VGND VPWR VPWR _4192_/C sky130_fd_sc_hd__or2b_4
XFILLER_27_256 VGND VGND VPWR VPWR sky130_fd_sc_hd__decap_3
XFILLER_82_362 VGND VGND VPWR VPWR sky130_fd_sc_hd__fill_2
XFILLER_42_215 VGND VGND VPWR VPWR sky130_fd_sc_hd__decap_3
XFILLER_23_440 VGND VGND VPWR VPWR sky130_fd_sc_hd__decap_3
XTAP_TAPCELL_ROW_81_1076 VGND VPWR sky130_fd_sc_hd__tapvpwrvgnd_1
XTAP_TAPCELL_ROW_53_777 VGND VPWR sky130_fd_sc_hd__tapvpwrvgnd_1
XFILLER_10_112 VGND VGND VPWR VPWR sky130_fd_sc_hd__decap_3
XFILLER_10_123 VGND VGND VPWR VPWR sky130_fd_sc_hd__decap_3
XFILLER_50_292 VGND VGND VPWR VPWR sky130_fd_sc_hd__decap_3
XFILLER_6_116 VGND VGND VPWR VPWR sky130_fd_sc_hd__decap_3
XFILLER_12_41 VGND VGND VPWR VPWR sky130_fd_sc_hd__decap_3
XFILLER_6_127 VGND VGND VPWR VPWR sky130_fd_sc_hd__decap_3
XFILLER_12_74 VGND VGND VPWR VPWR sky130_fd_sc_hd__fill_1
XFILLER_12_85 VGND VGND VPWR VPWR sky130_fd_sc_hd__decap_3
XFILLER_2_377 VGND VGND VPWR VPWR sky130_fd_sc_hd__fill_1
XTAP_TAPCELL_ROW_92_1194 VGND VPWR sky130_fd_sc_hd__tapvpwrvgnd_1
XFILLER_65_307 VGND VGND VPWR VPWR sky130_fd_sc_hd__fill_2
XFILLER_37_60 VGND VGND VPWR VPWR sky130_fd_sc_hd__decap_3
XFILLER_18_245 VGND VGND VPWR VPWR sky130_fd_sc_hd__decap_3
XFILLER_37_93 VGND VGND VPWR VPWR sky130_fd_sc_hd__decap_3
XPHY_EDGE_ROW_16_Right_16 VGND VGND VPWR VPWR sky130_fd_sc_hd__decap_3
XFILLER_18_289 VGND VGND VPWR VPWR sky130_fd_sc_hd__decap_3
XFILLER_33_215 VGND VGND VPWR VPWR sky130_fd_sc_hd__decap_3
XFILLER_33_237 VGND VGND VPWR VPWR sky130_fd_sc_hd__decap_3
XFILLER_14_462 VGND VGND VPWR VPWR sky130_fd_sc_hd__fill_1
XFILLER_41_281 VGND VGND VPWR VPWR sky130_fd_sc_hd__decap_3
XFILLER_53_92 VGND VGND VPWR VPWR sky130_fd_sc_hd__decap_3
XPHY_EDGE_ROW_25_Right_25 VGND VGND VPWR VPWR sky130_fd_sc_hd__decap_3
X_3560_ _7517_/Q VGND VGND VPWR VPWR _3561_/A sky130_fd_sc_hd__inv_2
Xplace1817 _3931_/C VGND VGND VPWR VPWR _6804_/A1 sky130_fd_sc_hd__buf_2
Xplace1806 _4003_/A2 VGND VGND VPWR VPWR _3898_/A2 sky130_fd_sc_hd__buf_2
Xplace1839 _3995_/A1 VGND VGND VPWR VPWR _3815_/A1 sky130_fd_sc_hd__buf_2
Xplace1828 _3544_/B VGND VGND VPWR VPWR _6347_/A sky130_fd_sc_hd__buf_2
X_5230_ _5230_/A0 _5681_/A1 _5230_/S VGND VGND VPWR VPWR _7072_/D sky130_fd_sc_hd__mux2_2
X_3491_ _4337_/B _3491_/B VGND VGND VPWR VPWR _3499_/B sky130_fd_sc_hd__nor2_2
XFILLER_45_3 VGND VGND VPWR VPWR sky130_fd_sc_hd__fill_2
XFILLER_96_421 VGND VGND VPWR VPWR sky130_fd_sc_hd__decap_3
Xhold2519 _6949_/Q VGND VGND VPWR VPWR _4952_/A0 sky130_fd_sc_hd__dlygate4sd3_1
Xhold2508 _7071_/Q VGND VGND VPWR VPWR _5227_/A0 sky130_fd_sc_hd__dlygate4sd3_1
X_4112_ _5862_/A3 _4111_/X _3582_/Y VGND VGND VPWR VPWR _4112_/X sky130_fd_sc_hd__a21o_2
XFILLER_56_329 VGND VGND VPWR VPWR sky130_fd_sc_hd__fill_1
X_4043_ _7301_/Q _7302_/Q _7303_/Q _4043_/D VGND VGND VPWR VPWR _4050_/D sky130_fd_sc_hd__and4_2
XPHY_EDGE_ROW_34_Right_34 VGND VGND VPWR VPWR sky130_fd_sc_hd__decap_3
XFILLER_64_384 VGND VGND VPWR VPWR sky130_fd_sc_hd__fill_2
X_5994_ _4610_/X _6082_/B _6082_/C _6082_/D VGND VGND VPWR VPWR _6011_/C sky130_fd_sc_hd__nand4b_2
XFILLER_24_259 VGND VGND VPWR VPWR sky130_fd_sc_hd__decap_3
XFILLER_52_546 VGND VGND VPWR VPWR sky130_fd_sc_hd__decap_3
X_4945_ _4945_/A0 _5344_/A1 _4958_/S VGND VGND VPWR VPWR _6946_/D sky130_fd_sc_hd__mux2_2
XFILLER_20_421 VGND VGND VPWR VPWR sky130_fd_sc_hd__decap_3
XTAP_TAPCELL_ROW_50_747 VGND VPWR sky130_fd_sc_hd__tapvpwrvgnd_1
XTAP_TAPCELL_ROW_22_449 VGND VPWR sky130_fd_sc_hd__tapvpwrvgnd_1
XPHY_EDGE_ROW_43_Right_43 VGND VGND VPWR VPWR sky130_fd_sc_hd__decap_3
X_7595_ _7611_/CLK _7595_/D place2058/X VGND VGND VPWR VPWR _7595_/Q sky130_fd_sc_hd__dfrtp_2
X_6615_ _6615_/A0 _6144_/X _6634_/S VGND VGND VPWR VPWR _7471_/D sky130_fd_sc_hd__mux2_4
X_3827_ _7405_/Q _3827_/B VGND VGND VPWR VPWR _3829_/C sky130_fd_sc_hd__nand2_2
XFILLER_20_487 VGND VGND VPWR VPWR sky130_fd_sc_hd__fill_1
X_6546_ _4235_/A _6546_/A2 _6546_/A3 _5824_/Y _6179_/B VGND VGND VPWR VPWR _6546_/X
+ sky130_fd_sc_hd__o41a_2
X_3758_ _7538_/Q _3812_/A2 _3812_/B1 _7474_/Q VGND VGND VPWR VPWR _3758_/X sky130_fd_sc_hd__a22o_2
XFILLER_3_119 VGND VGND VPWR VPWR sky130_fd_sc_hd__decap_3
X_6477_ _7183_/Q _6477_/A2 _7211_/Q _6484_/B2 VGND VGND VPWR VPWR _6477_/X sky130_fd_sc_hd__o22a_2
X_5359_ _5359_/A0 _4763_/Y _5361_/S VGND VGND VPWR VPWR _7121_/D sky130_fd_sc_hd__mux2_2
XFILLER_59_167 VGND VGND VPWR VPWR sky130_fd_sc_hd__fill_1
XPHY_EDGE_ROW_52_Right_52 VGND VGND VPWR VPWR sky130_fd_sc_hd__decap_3
X_7029_ _7279_/CLK _7029_/D VGND VGND VPWR VPWR _7029_/Q sky130_fd_sc_hd__dfxtp_2
XFILLER_74_137 VGND VGND VPWR VPWR sky130_fd_sc_hd__decap_3
XTAP_TAPCELL_ROW_58_836 VGND VPWR sky130_fd_sc_hd__tapvpwrvgnd_1
XFILLER_55_351 VGND VGND VPWR VPWR sky130_fd_sc_hd__decap_3
XFILLER_74_159 VGND VGND VPWR VPWR sky130_fd_sc_hd__fill_1
XFILLER_43_546 VGND VGND VPWR VPWR sky130_fd_sc_hd__fill_1
XFILLER_43_568 VGND VGND VPWR VPWR sky130_fd_sc_hd__decap_3
XFILLER_43_579 VGND VGND VPWR VPWR sky130_fd_sc_hd__decap_3
XFILLER_23_270 VGND VGND VPWR VPWR sky130_fd_sc_hd__fill_1
XPHY_EDGE_ROW_61_Right_61 VGND VGND VPWR VPWR sky130_fd_sc_hd__decap_3
XTAP_TAPCELL_ROW_94_1212 VGND VPWR sky130_fd_sc_hd__tapvpwrvgnd_1
XFILLER_2_130 VGND VGND VPWR VPWR sky130_fd_sc_hd__decap_3
XPHY_EDGE_ROW_70_Right_70 VGND VGND VPWR VPWR sky130_fd_sc_hd__decap_3
XFILLER_38_307 VGND VGND VPWR VPWR sky130_fd_sc_hd__fill_1
XFILLER_38_318 VGND VGND VPWR VPWR sky130_fd_sc_hd__decap_3
XFILLER_48_81 VGND VGND VPWR VPWR sky130_fd_sc_hd__decap_3
XFILLER_65_137 VGND VGND VPWR VPWR sky130_fd_sc_hd__decap_3
XFILLER_93_446 VGND VGND VPWR VPWR sky130_fd_sc_hd__fill_2
XFILLER_19_565 VGND VGND VPWR VPWR sky130_fd_sc_hd__decap_3
XFILLER_46_340 VGND VGND VPWR VPWR sky130_fd_sc_hd__decap_3
XFILLER_0_66 VGND VGND VPWR VPWR sky130_fd_sc_hd__decap_3
XFILLER_34_513 VGND VGND VPWR VPWR sky130_fd_sc_hd__fill_1
XFILLER_34_524 VGND VGND VPWR VPWR sky130_fd_sc_hd__decap_3
XFILLER_0_88 VGND VGND VPWR VPWR sky130_fd_sc_hd__decap_3
XFILLER_34_557 VGND VGND VPWR VPWR sky130_fd_sc_hd__fill_1
XFILLER_73_181 VGND VGND VPWR VPWR sky130_fd_sc_hd__fill_2
XFILLER_73_192 VGND VGND VPWR VPWR sky130_fd_sc_hd__fill_1
X_4730_ _4730_/A0 _5593_/A1 _4776_/S VGND VGND VPWR VPWR _6864_/D sky130_fd_sc_hd__mux2_2
X_4661_ _4637_/A _6489_/A1 _4637_/B _5162_/A1 _6437_/B1 VGND VGND VPWR VPWR _4661_/X
+ sky130_fd_sc_hd__a311o_2
X_7380_ _7577_/CLK _7380_/D place2036/X VGND VGND VPWR VPWR _7380_/Q sky130_fd_sc_hd__dfrtp_2
X_6331_ _7407_/Q _6331_/A2 _6335_/A3 _6345_/B1 _6331_/B2 VGND VGND VPWR VPWR _7375_/D
+ sky130_fd_sc_hd__a32o_2
XFILLER_6_480 VGND VGND VPWR VPWR sky130_fd_sc_hd__decap_3
Xplace1603 _3502_/Y VGND VGND VPWR VPWR _4576_/C1 sky130_fd_sc_hd__buf_2
Xplace1614 _6600_/S VGND VGND VPWR VPWR _6634_/S sky130_fd_sc_hd__buf_2
Xplace1625 _4014_/X VGND VGND VPWR VPWR _6163_/A sky130_fd_sc_hd__buf_2
Xplace1636 _3614_/X VGND VGND VPWR VPWR _3881_/B sky130_fd_sc_hd__buf_4
X_3543_ _3543_/A _3543_/B VGND VGND VPWR VPWR _3544_/C sky130_fd_sc_hd__nor2_4
Xhold3006 _7520_/Q VGND VGND VPWR VPWR _6718_/A1 sky130_fd_sc_hd__dlygate4sd3_1
Xplace1647 _4250_/C1 VGND VGND VPWR VPWR _6436_/A sky130_fd_sc_hd__buf_2
Xplace1658 _3986_/B2 VGND VGND VPWR VPWR _4007_/A2 sky130_fd_sc_hd__buf_2
Xplace1669 _3901_/C VGND VGND VPWR VPWR _6322_/A3 sky130_fd_sc_hd__buf_2
X_6262_ _6298_/A _6262_/B VGND VGND VPWR VPWR _7338_/D sky130_fd_sc_hd__and2_2
X_3474_ _3474_/A _3468_/A VGND VGND VPWR VPWR _3475_/C sky130_fd_sc_hd__or2b_2
Xhold3017 _7538_/Q VGND VGND VPWR VPWR _6756_/A1 sky130_fd_sc_hd__dlygate4sd3_1
Xhold3028 _7427_/Q VGND VGND VPWR VPWR _6497_/A0 sky130_fd_sc_hd__dlygate4sd3_1
Xhold3039 _7306_/Q VGND VGND VPWR VPWR _4051_/A sky130_fd_sc_hd__dlygate4sd3_1
X_6193_ _6394_/A1 _6894_/Q _7286_/Q _6401_/B2 VGND VGND VPWR VPWR _6193_/X sky130_fd_sc_hd__o22a_2
X_5213_ _5213_/A0 _5730_/A1 _5213_/S VGND VGND VPWR VPWR _7067_/D sky130_fd_sc_hd__mux2_2
X_5144_ _5144_/A0 _5661_/A1 _5152_/S VGND VGND VPWR VPWR _7035_/D sky130_fd_sc_hd__mux2_2
XFILLER_28_29 VGND VGND VPWR VPWR sky130_fd_sc_hd__decap_3
XFILLER_56_104 VGND VGND VPWR VPWR sky130_fd_sc_hd__fill_2
XFILLER_56_159 VGND VGND VPWR VPWR sky130_fd_sc_hd__decap_3
X_4026_ _4373_/B _4373_/C _4503_/C VGND VGND VPWR VPWR _4028_/C sky130_fd_sc_hd__and3_2
XTAP_TAPCELL_ROW_27_508 VGND VPWR sky130_fd_sc_hd__tapvpwrvgnd_1
XFILLER_25_535 VGND VGND VPWR VPWR sky130_fd_sc_hd__decap_3
XFILLER_25_557 VGND VGND VPWR VPWR sky130_fd_sc_hd__decap_3
XFILLER_25_579 VGND VGND VPWR VPWR sky130_fd_sc_hd__decap_3
XFILLER_40_527 VGND VGND VPWR VPWR sky130_fd_sc_hd__decap_3
X_5977_ _5975_/Y _5976_/Y _5671_/B VGND VGND VPWR VPWR _5978_/D sky130_fd_sc_hd__o21ai_2
XTAP_TAPCELL_ROW_63_883 VGND VPWR sky130_fd_sc_hd__tapvpwrvgnd_1
XFILLER_40_549 VGND VGND VPWR VPWR sky130_fd_sc_hd__decap_3
X_4928_ _4928_/A0 _5694_/A1 _4930_/S VGND VGND VPWR VPWR _6938_/D sky130_fd_sc_hd__mux2_2
Xclkbuf_3_0__f_clk clkbuf_0_clk/X VGND VGND VPWR VPWR clkbuf_leaf_0_clk/A sky130_fd_sc_hd__clkbuf_8
X_7578_ _7579_/CLK _7578_/D place2016/X VGND VGND VPWR VPWR _7578_/Q sky130_fd_sc_hd__dfrtp_2
X_6529_ _7435_/Q _6086_/X _6529_/S VGND VGND VPWR VPWR _7435_/D sky130_fd_sc_hd__mux2_2
XFILLER_79_229 VGND VGND VPWR VPWR sky130_fd_sc_hd__fill_1
Xhold2850 _7552_/Q VGND VGND VPWR VPWR _6787_/B sky130_fd_sc_hd__dlygate4sd3_1
XTAP_TAPCELL_ROW_7_299 VGND VPWR sky130_fd_sc_hd__tapvpwrvgnd_1
Xhold2861 _7346_/Q VGND VGND VPWR VPWR _6279_/B sky130_fd_sc_hd__dlygate4sd3_1
Xhold2872 _7329_/Q VGND VGND VPWR VPWR _6243_/B sky130_fd_sc_hd__dlygate4sd3_1
Xhold2883 _7344_/Q VGND VGND VPWR VPWR _6275_/B sky130_fd_sc_hd__dlygate4sd3_1
XFILLER_75_457 VGND VGND VPWR VPWR sky130_fd_sc_hd__decap_3
Xhold2894 _6341_/X VGND VGND VPWR VPWR _7382_/D sky130_fd_sc_hd__dlygate4sd3_1
XFILLER_18_73 VGND VGND VPWR VPWR sky130_fd_sc_hd__decap_3
XFILLER_16_568 VGND VGND VPWR VPWR sky130_fd_sc_hd__decap_3
XFILLER_31_505 VGND VGND VPWR VPWR sky130_fd_sc_hd__decap_3
XFILLER_31_538 VGND VGND VPWR VPWR sky130_fd_sc_hd__decap_3
XFILLER_70_184 VGND VGND VPWR VPWR sky130_fd_sc_hd__decap_3
XFILLER_11_240 VGND VGND VPWR VPWR sky130_fd_sc_hd__decap_3
XFILLER_34_94 VGND VGND VPWR VPWR sky130_fd_sc_hd__decap_3
XFILLER_7_266 VGND VGND VPWR VPWR sky130_fd_sc_hd__decap_3
XFILLER_50_93 VGND VGND VPWR VPWR sky130_fd_sc_hd__fill_1
XFILLER_3_461 VGND VGND VPWR VPWR sky130_fd_sc_hd__decap_3
XFILLER_66_402 VGND VGND VPWR VPWR sky130_fd_sc_hd__fill_2
XFILLER_78_251 VGND VGND VPWR VPWR sky130_fd_sc_hd__fill_1
XFILLER_19_340 VGND VGND VPWR VPWR sky130_fd_sc_hd__decap_3
XFILLER_38_159 VGND VGND VPWR VPWR sky130_fd_sc_hd__fill_2
XFILLER_19_373 VGND VGND VPWR VPWR sky130_fd_sc_hd__decap_3
XFILLER_53_107 VGND VGND VPWR VPWR sky130_fd_sc_hd__decap_3
X_5900_ _6136_/A2 _7002_/Q _6974_/Q _6401_/B2 VGND VGND VPWR VPWR _5900_/X sky130_fd_sc_hd__o22a_4
XFILLER_34_321 VGND VGND VPWR VPWR sky130_fd_sc_hd__decap_3
XFILLER_46_192 VGND VGND VPWR VPWR sky130_fd_sc_hd__decap_3
X_6880_ _7247_/CLK _6880_/D VGND VGND VPWR VPWR _6880_/Q sky130_fd_sc_hd__dfxtp_2
XFILLER_22_516 VGND VGND VPWR VPWR sky130_fd_sc_hd__decap_3
XFILLER_34_365 VGND VGND VPWR VPWR sky130_fd_sc_hd__decap_3
XFILLER_61_140 VGND VGND VPWR VPWR sky130_fd_sc_hd__decap_3
X_5831_ _7180_/Q _5488_/B _5671_/C _7152_/Q VGND VGND VPWR VPWR _5831_/X sky130_fd_sc_hd__a22o_2
XFILLER_61_195 VGND VGND VPWR VPWR sky130_fd_sc_hd__fill_1
X_7501_ clkload3/A _7501_/D place2059/X VGND VGND VPWR VPWR _7501_/Q sky130_fd_sc_hd__dfrtp_2
X_4713_ _4733_/B1 _4761_/A _4727_/D _4711_/X _4712_/Y VGND VGND VPWR VPWR _4713_/X
+ sky130_fd_sc_hd__o311a_2
XTAP_TAPCELL_ROW_60_853 VGND VPWR sky130_fd_sc_hd__tapvpwrvgnd_1
XTAP_TAPCELL_ROW_32_555 VGND VPWR sky130_fd_sc_hd__tapvpwrvgnd_1
X_7432_ clkload3/A _7432_/D place2063/X VGND VGND VPWR VPWR _7432_/Q sky130_fd_sc_hd__dfrtp_2
X_4644_ _7367_/Q _6178_/A1 _6178_/A3 _4641_/Y _4643_/X VGND VGND VPWR VPWR _4644_/X
+ sky130_fd_sc_hd__a32o_2
Xplace1400 _4148_/B VGND VGND VPWR VPWR _3945_/B1 sky130_fd_sc_hd__buf_2
X_7363_ _7490_/CLK _7363_/D place2024/X VGND VGND VPWR VPWR _7363_/Q sky130_fd_sc_hd__dfrtp_2
X_4575_ _4571_/Y _4574_/Y _4452_/S _7547_/Q VGND VGND VPWR VPWR _7321_/D sky130_fd_sc_hd__a2bb2o_2
XFILLER_89_505 VGND VGND VPWR VPWR sky130_fd_sc_hd__decap_3
Xplace1411 _4281_/C VGND VGND VPWR VPWR _4271_/B sky130_fd_sc_hd__buf_2
Xplace1422 _6292_/A VGND VGND VPWR VPWR _6294_/A sky130_fd_sc_hd__buf_2
Xplace1433 _4001_/A VGND VGND VPWR VPWR _4406_/B1 sky130_fd_sc_hd__buf_2
Xplace1444 _3895_/Y VGND VGND VPWR VPWR _4157_/A sky130_fd_sc_hd__buf_2
X_7294_ clkload2/A _7294_/D place2029/X VGND VGND VPWR VPWR _7294_/Q sky130_fd_sc_hd__dfrtp_2
X_3526_ _3529_/A _3529_/B VGND VGND VPWR VPWR _3526_/Y sky130_fd_sc_hd__nand2_2
Xplace1455 _3794_/Y VGND VGND VPWR VPWR _4211_/C sky130_fd_sc_hd__buf_2
Xplace1466 _3665_/Y VGND VGND VPWR VPWR _4757_/A2 sky130_fd_sc_hd__buf_2
Xplace1477 _4576_/X VGND VGND VPWR VPWR _5612_/A1 sky130_fd_sc_hd__buf_2
X_6245_ _6247_/A _6245_/B VGND VGND VPWR VPWR _7330_/D sky130_fd_sc_hd__and2_2
XFILLER_103_337 VGND VGND VPWR VPWR sky130_fd_sc_hd__decap_3
XFILLER_103_359 VGND VGND VPWR VPWR sky130_fd_sc_hd__decap_3
Xplace1488 _3972_/A VGND VGND VPWR VPWR _4108_/A sky130_fd_sc_hd__buf_2
Xplace1499 _3876_/Y VGND VGND VPWR VPWR _4648_/B1 sky130_fd_sc_hd__buf_2
X_3457_ _3505_/A1 _3505_/A2 _3457_/B1 _3505_/C1 VGND VGND VPWR VPWR _3975_/B sky130_fd_sc_hd__a211o_4
X_6176_ _6172_/X _6398_/B1 _6458_/B2 _6175_/X VGND VGND VPWR VPWR _6176_/X sky130_fd_sc_hd__o22a_2
XFILLER_57_424 VGND VGND VPWR VPWR sky130_fd_sc_hd__decap_3
XFILLER_57_435 VGND VGND VPWR VPWR sky130_fd_sc_hd__decap_3
XFILLER_69_284 VGND VGND VPWR VPWR sky130_fd_sc_hd__decap_3
X_5127_ _5127_/A0 _5188_/A1 _5146_/S VGND VGND VPWR VPWR _7027_/D sky130_fd_sc_hd__mux2_2
XFILLER_29_159 VGND VGND VPWR VPWR sky130_fd_sc_hd__fill_1
XPHY_EDGE_ROW_2_Right_2 VGND VGND VPWR VPWR sky130_fd_sc_hd__decap_3
XTAP_TAPCELL_ROW_68_942 VGND VPWR sky130_fd_sc_hd__tapvpwrvgnd_1
XTAP_TAPCELL_ROW_4_269 VGND VPWR sky130_fd_sc_hd__tapvpwrvgnd_1
XFILLER_44_118 VGND VGND VPWR VPWR sky130_fd_sc_hd__decap_3
X_4009_ _7521_/Q _5734_/A _4009_/B1 _6446_/A0 VGND VGND VPWR VPWR _4011_/A sky130_fd_sc_hd__a22oi_2
XFILLER_37_181 VGND VGND VPWR VPWR sky130_fd_sc_hd__fill_2
XFILLER_13_505 VGND VGND VPWR VPWR sky130_fd_sc_hd__decap_3
XFILLER_25_365 VGND VGND VPWR VPWR sky130_fd_sc_hd__decap_3
XFILLER_25_376 VGND VGND VPWR VPWR sky130_fd_sc_hd__decap_3
XFILLER_40_368 VGND VGND VPWR VPWR sky130_fd_sc_hd__decap_3
XTAP_TAPCELL_ROW_78_1037 VGND VPWR sky130_fd_sc_hd__tapvpwrvgnd_1
XFILLER_4_247 VGND VGND VPWR VPWR sky130_fd_sc_hd__decap_3
XFILLER_20_63 VGND VGND VPWR VPWR sky130_fd_sc_hd__fill_1
XFILLER_20_74 VGND VGND VPWR VPWR sky130_fd_sc_hd__fill_1
XFILLER_20_85 VGND VGND VPWR VPWR sky130_fd_sc_hd__decap_3
XFILLER_0_442 VGND VGND VPWR VPWR sky130_fd_sc_hd__decap_3
XFILLER_0_464 VGND VGND VPWR VPWR sky130_fd_sc_hd__decap_3
XFILLER_0_486 VGND VGND VPWR VPWR sky130_fd_sc_hd__decap_3
XFILLER_48_424 VGND VGND VPWR VPWR sky130_fd_sc_hd__decap_3
XFILLER_29_83 VGND VGND VPWR VPWR sky130_fd_sc_hd__decap_3
Xhold2680 _7286_/Q VGND VGND VPWR VPWR _5720_/A0 sky130_fd_sc_hd__dlygate4sd3_1
Xhold2691 _7020_/Q VGND VGND VPWR VPWR _5112_/A0 sky130_fd_sc_hd__dlygate4sd3_1
XTAP_TAPCELL_ROW_89_1155 VGND VPWR sky130_fd_sc_hd__tapvpwrvgnd_1
XFILLER_75_298 VGND VGND VPWR VPWR sky130_fd_sc_hd__decap_3
XFILLER_45_82 VGND VGND VPWR VPWR sky130_fd_sc_hd__decap_3
XFILLER_16_398 VGND VGND VPWR VPWR sky130_fd_sc_hd__fill_1
XFILLER_31_368 VGND VGND VPWR VPWR sky130_fd_sc_hd__decap_3
XFILLER_8_531 VGND VGND VPWR VPWR sky130_fd_sc_hd__fill_1
XANTENNA_3 _4776_/S VGND VGND VPWR VPWR sky130_fd_sc_hd__diode_2
X_4360_ _4352_/A _4352_/B _4352_/C _4361_/A VGND VGND VPWR VPWR _4362_/C sky130_fd_sc_hd__a31o_2
XFILLER_6_98 VGND VGND VPWR VPWR sky130_fd_sc_hd__decap_3
X_4291_ _4297_/A _4297_/B _4297_/C _4297_/D VGND VGND VPWR VPWR _4291_/X sky130_fd_sc_hd__o22a_2
XFILLER_86_508 VGND VGND VPWR VPWR sky130_fd_sc_hd__fill_1
X_6030_ _6064_/A1 _4582_/A _4582_/B _6991_/Q _6064_/C1 VGND VGND VPWR VPWR _6030_/X
+ sky130_fd_sc_hd__a311o_2
XFILLER_39_424 VGND VGND VPWR VPWR sky130_fd_sc_hd__decap_3
XFILLER_79_593 VGND VGND VPWR VPWR sky130_fd_sc_hd__fill_2
XFILLER_94_585 VGND VGND VPWR VPWR sky130_fd_sc_hd__decap_3
XTAP_TAPCELL_ROW_65_901 VGND VPWR sky130_fd_sc_hd__tapvpwrvgnd_1
XTAP_TAPCELL_ROW_37_614 VGND VPWR sky130_fd_sc_hd__tapvpwrvgnd_1
XFILLER_19_181 VGND VGND VPWR VPWR sky130_fd_sc_hd__decap_3
XFILLER_54_438 VGND VGND VPWR VPWR sky130_fd_sc_hd__fill_2
XFILLER_54_449 VGND VGND VPWR VPWR sky130_fd_sc_hd__fill_1
X_6932_ _7275_/CLK _6932_/D VGND VGND VPWR VPWR _6932_/Q sky130_fd_sc_hd__dfxtp_2
X_6863_ _7287_/CLK _6863_/D VGND VGND VPWR VPWR _6863_/Q sky130_fd_sc_hd__dfxtp_2
X_5814_ _6146_/B1 _7025_/Q _6941_/Q _6399_/B2 VGND VGND VPWR VPWR _5814_/X sky130_fd_sc_hd__o22a_2
XFILLER_22_335 VGND VGND VPWR VPWR sky130_fd_sc_hd__fill_2
XFILLER_22_368 VGND VGND VPWR VPWR sky130_fd_sc_hd__decap_3
XTAP_TAPCELL_ROW_45_691 VGND VPWR sky130_fd_sc_hd__tapvpwrvgnd_1
X_5745_ _5843_/A _5843_/B _7580_/Q VGND VGND VPWR VPWR _5745_/X sky130_fd_sc_hd__o21a_2
X_7415_ _7507_/CLK _7415_/D place2037/X VGND VGND VPWR VPWR _7415_/Q sky130_fd_sc_hd__dfrtp_2
X_4627_ _4627_/A0 _5564_/A1 _4672_/S VGND VGND VPWR VPWR _6850_/D sky130_fd_sc_hd__mux2_2
Xplace1230 _5576_/S VGND VGND VPWR VPWR _5608_/S sky130_fd_sc_hd__buf_2
Xplace1241 _4215_/Y VGND VGND VPWR VPWR _4221_/A2 sky130_fd_sc_hd__buf_2
Xplace1252 _5778_/X VGND VGND VPWR VPWR _6398_/B1 sky130_fd_sc_hd__buf_2
X_7346_ _7575_/CLK _7346_/D place2012/X VGND VGND VPWR VPWR _7346_/Q sky130_fd_sc_hd__dfrtp_2
X_4558_ _7318_/Q _4558_/B _7320_/Q _4558_/D VGND VGND VPWR VPWR _4572_/B sky130_fd_sc_hd__and4_2
XTAP_TAPCELL_ROW_9_317 VGND VPWR sky130_fd_sc_hd__tapvpwrvgnd_1
XFILLER_1_228 VGND VGND VPWR VPWR sky130_fd_sc_hd__fill_1
XFILLER_9_9 VGND VGND VPWR VPWR sky130_fd_sc_hd__fill_1
Xplace1263 _4018_/Y VGND VGND VPWR VPWR _4675_/A sky130_fd_sc_hd__buf_6
Xplace1274 _6173_/A1 VGND VGND VPWR VPWR _6138_/A1 sky130_fd_sc_hd__buf_2
Xplace1285 _5991_/B2 VGND VGND VPWR VPWR _6450_/B2 sky130_fd_sc_hd__buf_2
X_7277_ _7291_/CLK _7277_/D VGND VGND VPWR VPWR _7277_/Q sky130_fd_sc_hd__dfxtp_2
X_4489_ _7309_/Q _4489_/B VGND VGND VPWR VPWR _4489_/X sky130_fd_sc_hd__xor2_2
X_3509_ _3509_/A _3509_/B _3509_/C VGND VGND VPWR VPWR _3509_/Y sky130_fd_sc_hd__nor3_4
Xplace1296 _4288_/X VGND VGND VPWR VPWR _4289_/C sky130_fd_sc_hd__buf_2
X_6228_ _6228_/A _6228_/B VGND VGND VPWR VPWR _6228_/Y sky130_fd_sc_hd__nand2_2
X_6159_ _6219_/A1 _6220_/A2 _6185_/B1 _7600_/Q _6158_/X VGND VGND VPWR VPWR _6159_/X
+ sky130_fd_sc_hd__o221a_2
XFILLER_17_129 VGND VGND VPWR VPWR sky130_fd_sc_hd__fill_1
XFILLER_72_246 VGND VGND VPWR VPWR sky130_fd_sc_hd__decap_3
Xclkbuf_leaf_37_clk clkbuf_3_2__f_clk/X VGND VGND VPWR VPWR _7606_/CLK sky130_fd_sc_hd__clkbuf_16
XFILLER_72_268 VGND VGND VPWR VPWR sky130_fd_sc_hd__decap_3
XFILLER_13_313 VGND VGND VPWR VPWR sky130_fd_sc_hd__decap_3
XFILLER_25_162 VGND VGND VPWR VPWR sky130_fd_sc_hd__decap_3
XFILLER_13_346 VGND VGND VPWR VPWR sky130_fd_sc_hd__fill_1
XFILLER_25_195 VGND VGND VPWR VPWR sky130_fd_sc_hd__decap_3
XFILLER_80_290 VGND VGND VPWR VPWR sky130_fd_sc_hd__fill_1
XFILLER_15_96 VGND VGND VPWR VPWR sky130_fd_sc_hd__fill_2
XFILLER_40_165 VGND VGND VPWR VPWR sky130_fd_sc_hd__decap_3
XFILLER_5_512 VGND VGND VPWR VPWR sky130_fd_sc_hd__fill_2
XFILLER_31_84 VGND VGND VPWR VPWR sky130_fd_sc_hd__decap_3
XFILLER_63_202 VGND VGND VPWR VPWR sky130_fd_sc_hd__decap_3
XFILLER_56_81 VGND VGND VPWR VPWR sky130_fd_sc_hd__decap_3
Xclkbuf_leaf_28_clk clkbuf_3_6__f_clk/X VGND VGND VPWR VPWR _7282_/CLK sky130_fd_sc_hd__clkbuf_16
XFILLER_91_599 VGND VGND VPWR VPWR sky130_fd_sc_hd__decap_3
X_3860_ _7304_/Q _3860_/A2 _4461_/A VGND VGND VPWR VPWR _3860_/Y sky130_fd_sc_hd__a21oi_2
XFILLER_31_154 VGND VGND VPWR VPWR sky130_fd_sc_hd__decap_3
XTAP_TAPCELL_ROW_42_661 VGND VPWR sky130_fd_sc_hd__tapvpwrvgnd_1
XFILLER_31_198 VGND VGND VPWR VPWR sky130_fd_sc_hd__decap_3
XFILLER_75_3 VGND VGND VPWR VPWR sky130_fd_sc_hd__fill_2
X_5530_ _5530_/A0 _5591_/A1 _5532_/S VGND VGND VPWR VPWR _7199_/D sky130_fd_sc_hd__mux2_2
XTAP_TAPCELL_ROW_14_374 VGND VPWR sky130_fd_sc_hd__tapvpwrvgnd_1
X_5461_ _5461_/A0 _4693_/X _5471_/S VGND VGND VPWR VPWR _7167_/D sky130_fd_sc_hd__mux2_2
X_7200_ _7235_/CLK _7200_/D VGND VGND VPWR VPWR _7200_/Q sky130_fd_sc_hd__dfxtp_2
X_4412_ _4503_/A _4503_/B _4503_/C _7300_/Q VGND VGND VPWR VPWR _4422_/A sky130_fd_sc_hd__or4b_2
XFILLER_99_611 VGND VGND VPWR VPWR sky130_fd_sc_hd__fill_1
X_7131_ _7273_/CLK _7131_/D VGND VGND VPWR VPWR _7131_/Q sky130_fd_sc_hd__dfxtp_2
X_4343_ _3843_/B _4341_/X _4352_/A _4342_/Y VGND VGND VPWR VPWR _4345_/B sky130_fd_sc_hd__a31o_2
XPHY_EDGE_ROW_99_Right_99 VGND VGND VPWR VPWR sky130_fd_sc_hd__decap_3
XFILLER_59_508 VGND VGND VPWR VPWR sky130_fd_sc_hd__fill_1
X_7062_ _7288_/CLK _7062_/D VGND VGND VPWR VPWR _7062_/Q sky130_fd_sc_hd__dfxtp_2
X_4274_ _4274_/A _4274_/B VGND VGND VPWR VPWR _4274_/X sky130_fd_sc_hd__or2_2
XFILLER_39_243 VGND VGND VPWR VPWR sky130_fd_sc_hd__decap_3
XFILLER_67_541 VGND VGND VPWR VPWR sky130_fd_sc_hd__fill_2
XFILLER_27_405 VGND VGND VPWR VPWR sky130_fd_sc_hd__decap_3
XFILLER_39_276 VGND VGND VPWR VPWR sky130_fd_sc_hd__decap_3
XFILLER_39_287 VGND VGND VPWR VPWR sky130_fd_sc_hd__fill_2
XFILLER_54_224 VGND VGND VPWR VPWR sky130_fd_sc_hd__decap_3
XFILLER_94_393 VGND VGND VPWR VPWR sky130_fd_sc_hd__fill_1
Xclkbuf_leaf_19_clk clkload0/A VGND VGND VPWR VPWR _7235_/CLK sky130_fd_sc_hd__clkbuf_16
XFILLER_54_246 VGND VGND VPWR VPWR sky130_fd_sc_hd__fill_2
X_6915_ _7282_/CLK _6915_/D VGND VGND VPWR VPWR _6915_/Q sky130_fd_sc_hd__dfxtp_2
XFILLER_35_482 VGND VGND VPWR VPWR sky130_fd_sc_hd__fill_1
XFILLER_35_493 VGND VGND VPWR VPWR sky130_fd_sc_hd__decap_3
XFILLER_22_121 VGND VGND VPWR VPWR sky130_fd_sc_hd__fill_1
XFILLER_50_430 VGND VGND VPWR VPWR sky130_fd_sc_hd__decap_3
X_6846_ _7266_/CLK _6846_/D VGND VGND VPWR VPWR _6846_/Q sky130_fd_sc_hd__dfxtp_2
XFILLER_22_176 VGND VGND VPWR VPWR sky130_fd_sc_hd__fill_2
XFILLER_50_474 VGND VGND VPWR VPWR sky130_fd_sc_hd__fill_2
XFILLER_50_485 VGND VGND VPWR VPWR sky130_fd_sc_hd__decap_3
X_5728_ _5728_/A0 _5728_/A1 _5728_/S VGND VGND VPWR VPWR _7290_/D sky130_fd_sc_hd__mux2_2
X_3989_ _3982_/A _3982_/B _3988_/B VGND VGND VPWR VPWR _3989_/Y sky130_fd_sc_hd__o21bai_4
XFILLER_6_309 VGND VGND VPWR VPWR sky130_fd_sc_hd__decap_3
X_5659_ _5659_/A0 _5720_/A1 _5669_/S VGND VGND VPWR VPWR _7258_/D sky130_fd_sc_hd__mux2_2
XTAP_TAPCELL_ROW_75_1007 VGND VPWR sky130_fd_sc_hd__tapvpwrvgnd_1
XFILLER_7_6 VGND VGND VPWR VPWR sky130_fd_sc_hd__decap_3
X_7329_ _7393_/CLK _7329_/D place2023/X VGND VGND VPWR VPWR _7329_/Q sky130_fd_sc_hd__dfrtp_2
Xplace1082 _4295_/Y VGND VGND VPWR VPWR _6225_/C1 sky130_fd_sc_hd__buf_2
Xplace1093 _6089_/X VGND VGND VPWR VPWR _6184_/B1 sky130_fd_sc_hd__buf_8
XFILLER_58_541 VGND VGND VPWR VPWR sky130_fd_sc_hd__decap_3
XFILLER_93_57 VGND VGND VPWR VPWR sky130_fd_sc_hd__decap_3
XTAP_TAPCELL_ROW_86_1125 VGND VPWR sky130_fd_sc_hd__tapvpwrvgnd_1
XFILLER_45_257 VGND VGND VPWR VPWR sky130_fd_sc_hd__decap_3
XFILLER_73_577 VGND VGND VPWR VPWR sky130_fd_sc_hd__decap_3
XFILLER_13_110 VGND VGND VPWR VPWR sky130_fd_sc_hd__fill_2
XFILLER_41_441 VGND VGND VPWR VPWR sky130_fd_sc_hd__decap_3
XFILLER_60_249 VGND VGND VPWR VPWR sky130_fd_sc_hd__decap_3
XFILLER_13_154 VGND VGND VPWR VPWR sky130_fd_sc_hd__decap_3
XFILLER_13_198 VGND VGND VPWR VPWR sky130_fd_sc_hd__decap_3
XFILLER_9_147 VGND VGND VPWR VPWR sky130_fd_sc_hd__decap_3
XFILLER_42_94 VGND VGND VPWR VPWR sky130_fd_sc_hd__decap_3
XFILLER_9_169 VGND VGND VPWR VPWR sky130_fd_sc_hd__fill_2
XTAP_TAPCELL_ROW_97_1243 VGND VPWR sky130_fd_sc_hd__tapvpwrvgnd_1
XFILLER_3_33 VGND VGND VPWR VPWR sky130_fd_sc_hd__fill_1
XFILLER_3_55 VGND VGND VPWR VPWR sky130_fd_sc_hd__fill_1
XFILLER_64_533 VGND VGND VPWR VPWR sky130_fd_sc_hd__decap_3
XFILLER_76_382 VGND VGND VPWR VPWR sky130_fd_sc_hd__fill_1
XFILLER_91_330 VGND VGND VPWR VPWR sky130_fd_sc_hd__decap_3
XTAP_TAPCELL_ROW_47_720 VGND VPWR sky130_fd_sc_hd__tapvpwrvgnd_1
XTAP_TAPCELL_ROW_19_422 VGND VPWR sky130_fd_sc_hd__tapvpwrvgnd_1
XFILLER_24_419 VGND VGND VPWR VPWR sky130_fd_sc_hd__fill_1
XFILLER_32_430 VGND VGND VPWR VPWR sky130_fd_sc_hd__decap_3
XFILLER_44_290 VGND VGND VPWR VPWR sky130_fd_sc_hd__decap_3
X_6700_ _6700_/A0 _6406_/Y _6704_/S VGND VGND VPWR VPWR _7511_/D sky130_fd_sc_hd__mux2_2
X_4892_ _4892_/A0 _5353_/A1 _4900_/S VGND VGND VPWR VPWR _6922_/D sky130_fd_sc_hd__mux2_2
X_3912_ _3842_/C _3842_/B _7367_/Q _3936_/B1 _7559_/Q VGND VGND VPWR VPWR _3912_/X
+ sky130_fd_sc_hd__a32o_2
X_3843_ _4373_/B _3843_/B VGND VGND VPWR VPWR _3845_/A sky130_fd_sc_hd__and2_2
X_6562_ _6562_/A0 _6561_/Y _6567_/S VGND VGND VPWR VPWR _7448_/D sky130_fd_sc_hd__mux2_2
X_3774_ _3767_/Y _3670_/A _3773_/B _3773_/A VGND VGND VPWR VPWR _3774_/X sky130_fd_sc_hd__a2bb2o_2
X_5513_ _5513_/A0 _5635_/A1 _5513_/S VGND VGND VPWR VPWR _7191_/D sky130_fd_sc_hd__mux2_2
Xclkbuf_leaf_8_clk clkbuf_leaf_8_clk/A VGND VGND VPWR VPWR _7275_/CLK sky130_fd_sc_hd__clkbuf_16
X_5444_ _5444_/A0 _5566_/A1 _5452_/S VGND VGND VPWR VPWR _7159_/D sky130_fd_sc_hd__mux2_2
X_7114_ _7114_/CLK _7114_/D VGND VGND VPWR VPWR _7114_/Q sky130_fd_sc_hd__dfxtp_2
XFILLER_59_349 VGND VGND VPWR VPWR sky130_fd_sc_hd__decap_3
X_7045_ _7241_/CLK _7045_/D VGND VGND VPWR VPWR _7045_/Q sky130_fd_sc_hd__dfxtp_2
X_4257_ _4260_/B _4257_/B VGND VGND VPWR VPWR _4257_/Y sky130_fd_sc_hd__nand2_2
X_4188_ _4188_/A1 _4669_/B2 _4151_/A _4188_/C1 VGND VGND VPWR VPWR _4188_/X sky130_fd_sc_hd__o211a_2
XFILLER_27_202 VGND VGND VPWR VPWR sky130_fd_sc_hd__fill_1
XFILLER_67_393 VGND VGND VPWR VPWR sky130_fd_sc_hd__fill_2
XFILLER_27_246 VGND VGND VPWR VPWR sky130_fd_sc_hd__decap_3
XFILLER_27_279 VGND VGND VPWR VPWR sky130_fd_sc_hd__fill_1
XFILLER_42_227 VGND VGND VPWR VPWR sky130_fd_sc_hd__decap_3
XFILLER_35_290 VGND VGND VPWR VPWR sky130_fd_sc_hd__decap_3
XFILLER_23_474 VGND VGND VPWR VPWR sky130_fd_sc_hd__decap_3
XTAP_TAPCELL_ROW_53_778 VGND VPWR sky130_fd_sc_hd__tapvpwrvgnd_1
XFILLER_23_496 VGND VGND VPWR VPWR sky130_fd_sc_hd__fill_1
XFILLER_50_282 VGND VGND VPWR VPWR sky130_fd_sc_hd__fill_1
XTAP_TAPCELL_ROW_81_1077 VGND VPWR sky130_fd_sc_hd__tapvpwrvgnd_1
XFILLER_10_157 VGND VGND VPWR VPWR sky130_fd_sc_hd__decap_3
XFILLER_10_179 VGND VGND VPWR VPWR sky130_fd_sc_hd__decap_3
XFILLER_12_53 VGND VGND VPWR VPWR sky130_fd_sc_hd__decap_3
XFILLER_12_97 VGND VGND VPWR VPWR sky130_fd_sc_hd__decap_3
XFILLER_2_301 VGND VGND VPWR VPWR sky130_fd_sc_hd__decap_3
XFILLER_2_323 VGND VGND VPWR VPWR sky130_fd_sc_hd__fill_2
XFILLER_77_102 VGND VGND VPWR VPWR sky130_fd_sc_hd__fill_2
XFILLER_77_113 VGND VGND VPWR VPWR sky130_fd_sc_hd__fill_2
XTAP_TAPCELL_ROW_92_1184 VGND VPWR sky130_fd_sc_hd__tapvpwrvgnd_1
XFILLER_18_224 VGND VGND VPWR VPWR sky130_fd_sc_hd__decap_3
XFILLER_46_533 VGND VGND VPWR VPWR sky130_fd_sc_hd__decap_3
XFILLER_46_566 VGND VGND VPWR VPWR sky130_fd_sc_hd__fill_1
XFILLER_61_525 VGND VGND VPWR VPWR sky130_fd_sc_hd__fill_2
XFILLER_73_385 VGND VGND VPWR VPWR sky130_fd_sc_hd__decap_3
XFILLER_14_430 VGND VGND VPWR VPWR sky130_fd_sc_hd__fill_2
XFILLER_33_249 VGND VGND VPWR VPWR sky130_fd_sc_hd__decap_3
XFILLER_41_293 VGND VGND VPWR VPWR sky130_fd_sc_hd__fill_2
XTAP_TAPCELL_ROW_24_480 VGND VPWR sky130_fd_sc_hd__tapvpwrvgnd_1
XTAP_TAPCELL_ROW_101_1280 VGND VPWR sky130_fd_sc_hd__tapvpwrvgnd_1
Xplace1818 _3931_/C VGND VGND VPWR VPWR _3761_/C sky130_fd_sc_hd__buf_2
Xplace1807 _3498_/Y VGND VGND VPWR VPWR _4003_/A2 sky130_fd_sc_hd__buf_4
X_3490_ _3490_/A _3490_/B _3490_/C VGND VGND VPWR VPWR _3490_/X sky130_fd_sc_hd__and3_4
XFILLER_5_150 VGND VGND VPWR VPWR sky130_fd_sc_hd__fill_2
XFILLER_5_172 VGND VGND VPWR VPWR sky130_fd_sc_hd__fill_1
Xplace1829 _3544_/B VGND VGND VPWR VPWR _3776_/A2 sky130_fd_sc_hd__buf_2
XFILLER_5_183 VGND VGND VPWR VPWR sky130_fd_sc_hd__decap_3
Xhold2509 _6910_/Q VGND VGND VPWR VPWR _4866_/A0 sky130_fd_sc_hd__dlygate4sd3_1
X_5160_ _5160_/A0 _5310_/A1 _5181_/S VGND VGND VPWR VPWR _7042_/D sky130_fd_sc_hd__mux2_2
X_5091_ _5091_/A0 _5608_/A1 _5091_/S VGND VGND VPWR VPWR _7011_/D sky130_fd_sc_hd__mux2_2
X_4111_ _4111_/A1 _4584_/B1 _4110_/Y VGND VGND VPWR VPWR _4111_/X sky130_fd_sc_hd__o21a_2
XFILLER_68_157 VGND VGND VPWR VPWR sky130_fd_sc_hd__decap_3
X_4042_ _4044_/B _4042_/B VGND VGND VPWR VPWR _7592_/D sky130_fd_sc_hd__nor2_2
XFILLER_24_227 VGND VGND VPWR VPWR sky130_fd_sc_hd__decap_3
XFILLER_37_588 VGND VGND VPWR VPWR sky130_fd_sc_hd__decap_3
XFILLER_52_536 VGND VGND VPWR VPWR sky130_fd_sc_hd__fill_2
XFILLER_64_374 VGND VGND VPWR VPWR sky130_fd_sc_hd__fill_1
X_5993_ _5671_/B _5989_/Y _5992_/Y VGND VGND VPWR VPWR _6082_/D sky130_fd_sc_hd__a21oi_2
XFILLER_20_433 VGND VGND VPWR VPWR sky130_fd_sc_hd__decap_3
XFILLER_32_271 VGND VGND VPWR VPWR sky130_fd_sc_hd__decap_3
X_4875_ _4875_/A0 _5703_/A1 _4896_/S VGND VGND VPWR VPWR _6914_/D sky130_fd_sc_hd__mux2_2
XTAP_TAPCELL_ROW_50_748 VGND VPWR sky130_fd_sc_hd__tapvpwrvgnd_1
X_7594_ _7611_/CLK _7594_/D place2054/X VGND VGND VPWR VPWR _7594_/Q sky130_fd_sc_hd__dfrtp_2
X_3826_ _3826_/A _4510_/B _3826_/C _7533_/Q VGND VGND VPWR VPWR _3829_/D sky130_fd_sc_hd__or4b_4
XFILLER_20_477 VGND VGND VPWR VPWR sky130_fd_sc_hd__fill_2
X_3757_ _6334_/B2 _3811_/A2 _3757_/B1 _7442_/Q VGND VGND VPWR VPWR _4231_/A sky130_fd_sc_hd__a22oi_2
XFILLER_3_109 VGND VGND VPWR VPWR sky130_fd_sc_hd__decap_3
X_6476_ _6476_/A1 _7155_/Q _7127_/Q _6476_/B2 VGND VGND VPWR VPWR _6476_/X sky130_fd_sc_hd__o22a_2
X_3688_ _7419_/Q _4725_/A2 _3687_/X VGND VGND VPWR VPWR _3688_/Y sky130_fd_sc_hd__a21oi_2
X_5427_ _5427_/A _5671_/C _5549_/C VGND VGND VPWR VPWR _5454_/S sky130_fd_sc_hd__and3_2
XFILLER_59_113 VGND VGND VPWR VPWR sky130_fd_sc_hd__decap_3
XFILLER_87_433 VGND VGND VPWR VPWR sky130_fd_sc_hd__fill_2
X_4309_ _4510_/A _6231_/A2 _4510_/B _4308_/X _6231_/A1 VGND VGND VPWR VPWR _5843_/B
+ sky130_fd_sc_hd__o311a_2
X_7028_ _7114_/CLK _7028_/D VGND VGND VPWR VPWR _7028_/Q sky130_fd_sc_hd__dfxtp_2
XFILLER_28_533 VGND VGND VPWR VPWR sky130_fd_sc_hd__decap_3
XFILLER_74_127 VGND VGND VPWR VPWR sky130_fd_sc_hd__fill_2
XTAP_TAPCELL_ROW_58_837 VGND VPWR sky130_fd_sc_hd__tapvpwrvgnd_1
XFILLER_28_566 VGND VGND VPWR VPWR sky130_fd_sc_hd__fill_1
XFILLER_15_238 VGND VGND VPWR VPWR sky130_fd_sc_hd__decap_3
XFILLER_55_396 VGND VGND VPWR VPWR sky130_fd_sc_hd__decap_3
XFILLER_7_437 VGND VGND VPWR VPWR sky130_fd_sc_hd__decap_3
XFILLER_99_45 VGND VGND VPWR VPWR sky130_fd_sc_hd__decap_3
XTAP_TAPCELL_ROW_94_1213 VGND VPWR sky130_fd_sc_hd__tapvpwrvgnd_1
XFILLER_24_9 VGND VGND VPWR VPWR sky130_fd_sc_hd__fill_2
XFILLER_19_511 VGND VGND VPWR VPWR sky130_fd_sc_hd__decap_3
XFILLER_46_352 VGND VGND VPWR VPWR sky130_fd_sc_hd__decap_3
XFILLER_65_149 VGND VGND VPWR VPWR sky130_fd_sc_hd__decap_3
XFILLER_34_536 VGND VGND VPWR VPWR sky130_fd_sc_hd__decap_3
XFILLER_21_208 VGND VGND VPWR VPWR sky130_fd_sc_hd__decap_3
XTAP_TAPCELL_ROW_103_1320 VGND VPWR sky130_fd_sc_hd__tapvpwrvgnd_1
XFILLER_9_43 VGND VGND VPWR VPWR sky130_fd_sc_hd__decap_3
X_6330_ _6380_/B2 _6346_/A2 _6335_/A3 _6345_/B1 _6330_/B2 VGND VGND VPWR VPWR _7374_/D
+ sky130_fd_sc_hd__a32o_2
Xplace1604 _4261_/A VGND VGND VPWR VPWR _4253_/A sky130_fd_sc_hd__clkbuf_4
Xplace1615 _6529_/S VGND VGND VPWR VPWR _6541_/S sky130_fd_sc_hd__buf_2
Xplace1626 _4009_/B1 VGND VGND VPWR VPWR _3934_/B1 sky130_fd_sc_hd__buf_2
X_3542_ _4473_/D _3542_/B _3845_/C _3542_/D VGND VGND VPWR VPWR _3544_/B sky130_fd_sc_hd__and4_4
XFILLER_6_492 VGND VGND VPWR VPWR sky130_fd_sc_hd__decap_3
Xplace1637 _3614_/X VGND VGND VPWR VPWR _3968_/B sky130_fd_sc_hd__buf_2
Xplace1648 _4250_/C1 VGND VGND VPWR VPWR _4235_/A sky130_fd_sc_hd__buf_2
Xplace1659 _3986_/B2 VGND VGND VPWR VPWR _3908_/B1 sky130_fd_sc_hd__buf_2
X_3473_ _3473_/A _7292_/Q VGND VGND VPWR VPWR _3475_/B sky130_fd_sc_hd__or2b_4
Xhold3007 _7503_/Q VGND VGND VPWR VPWR _6381_/A1 sky130_fd_sc_hd__dlygate4sd3_1
Xhold3018 _7533_/Q VGND VGND VPWR VPWR _6746_/A1 sky130_fd_sc_hd__dlygate4sd3_1
Xhold3029 _7437_/Q VGND VGND VPWR VPWR _6533_/A0 sky130_fd_sc_hd__dlygate4sd3_1
X_6192_ _6399_/A1 _6922_/Q _7258_/Q _6393_/B2 VGND VGND VPWR VPWR _6192_/X sky130_fd_sc_hd__o22a_2
XFILLER_29_308 VGND VGND VPWR VPWR sky130_fd_sc_hd__decap_3
XFILLER_56_138 VGND VGND VPWR VPWR sky130_fd_sc_hd__fill_2
X_5074_ _5074_/A0 _5591_/A1 _5091_/S VGND VGND VPWR VPWR _7003_/D sky130_fd_sc_hd__mux2_2
X_4025_ _4321_/B _3475_/C _4025_/B1 _3474_/A VGND VGND VPWR VPWR _7585_/D sky130_fd_sc_hd__a2bb2o_2
XFILLER_25_503 VGND VGND VPWR VPWR sky130_fd_sc_hd__fill_1
XTAP_TAPCELL_ROW_27_509 VGND VPWR sky130_fd_sc_hd__tapvpwrvgnd_1
XFILLER_44_29 VGND VGND VPWR VPWR sky130_fd_sc_hd__fill_2
XFILLER_52_322 VGND VGND VPWR VPWR sky130_fd_sc_hd__decap_3
XFILLER_52_333 VGND VGND VPWR VPWR sky130_fd_sc_hd__fill_1
XFILLER_64_182 VGND VGND VPWR VPWR sky130_fd_sc_hd__fill_1
X_5976_ _6173_/A1 _6920_/Q _7256_/Q _6173_/B2 VGND VGND VPWR VPWR _5976_/Y sky130_fd_sc_hd__o22ai_2
XFILLER_52_399 VGND VGND VPWR VPWR sky130_fd_sc_hd__decap_3
XTAP_TAPCELL_ROW_63_884 VGND VPWR sky130_fd_sc_hd__tapvpwrvgnd_1
XTAP_TAPCELL_ROW_35_586 VGND VPWR sky130_fd_sc_hd__tapvpwrvgnd_1
X_4858_ _4858_/A0 _5686_/A1 _4868_/S VGND VGND VPWR VPWR _6906_/D sky130_fd_sc_hd__mux2_2
XFILLER_20_263 VGND VGND VPWR VPWR sky130_fd_sc_hd__decap_3
X_3809_ _3809_/A _3809_/B VGND VGND VPWR VPWR _4197_/A sky130_fd_sc_hd__nand2_2
X_7577_ _7577_/CLK _7577_/D place2013/X VGND VGND VPWR VPWR _7577_/Q sky130_fd_sc_hd__dfrtp_2
X_4789_ _4789_/A0 _5679_/A1 _4806_/S VGND VGND VPWR VPWR _6875_/D sky130_fd_sc_hd__mux2_2
XFILLER_4_418 VGND VGND VPWR VPWR sky130_fd_sc_hd__fill_2
XFILLER_69_15 VGND VGND VPWR VPWR sky130_fd_sc_hd__decap_3
X_6459_ _5772_/Y _6449_/X _6458_/X VGND VGND VPWR VPWR _6459_/Y sky130_fd_sc_hd__o21ai_2
XFILLER_0_602 VGND VGND VPWR VPWR sky130_fd_sc_hd__decap_3
Xhold2840 _7348_/Q VGND VGND VPWR VPWR _6284_/B sky130_fd_sc_hd__dlygate4sd3_1
XFILLER_47_127 VGND VGND VPWR VPWR sky130_fd_sc_hd__decap_3
Xhold2851 _7571_/Q VGND VGND VPWR VPWR _6826_/B sky130_fd_sc_hd__dlygate4sd3_1
Xhold2862 _7568_/Q VGND VGND VPWR VPWR _6820_/B sky130_fd_sc_hd__dlygate4sd3_1
Xhold2873 _7172_/Q VGND VGND VPWR VPWR _5471_/A0 sky130_fd_sc_hd__dlygate4sd3_1
Xhold2884 _7551_/Q VGND VGND VPWR VPWR _6785_/B sky130_fd_sc_hd__dlygate4sd3_1
XFILLER_28_341 VGND VGND VPWR VPWR sky130_fd_sc_hd__fill_2
XFILLER_75_469 VGND VGND VPWR VPWR sky130_fd_sc_hd__fill_2
Xhold2895 _7531_/Q VGND VGND VPWR VPWR _6742_/A1 sky130_fd_sc_hd__dlygate4sd3_1
XFILLER_16_503 VGND VGND VPWR VPWR sky130_fd_sc_hd__decap_3
XFILLER_28_374 VGND VGND VPWR VPWR sky130_fd_sc_hd__decap_3
XFILLER_16_536 VGND VGND VPWR VPWR sky130_fd_sc_hd__decap_3
XFILLER_43_322 VGND VGND VPWR VPWR sky130_fd_sc_hd__decap_3
XFILLER_24_580 VGND VGND VPWR VPWR sky130_fd_sc_hd__decap_3
XFILLER_7_245 VGND VGND VPWR VPWR sky130_fd_sc_hd__decap_3
XFILLER_50_72 VGND VGND VPWR VPWR sky130_fd_sc_hd__decap_3
XFILLER_7_278 VGND VGND VPWR VPWR sky130_fd_sc_hd__fill_2
XFILLER_22_6 VGND VGND VPWR VPWR sky130_fd_sc_hd__decap_3
XFILLER_19_352 VGND VGND VPWR VPWR sky130_fd_sc_hd__decap_3
XFILLER_34_300 VGND VGND VPWR VPWR sky130_fd_sc_hd__decap_3
XFILLER_53_119 VGND VGND VPWR VPWR sky130_fd_sc_hd__decap_3
XFILLER_34_333 VGND VGND VPWR VPWR sky130_fd_sc_hd__fill_1
XFILLER_46_171 VGND VGND VPWR VPWR sky130_fd_sc_hd__decap_3
XFILLER_34_355 VGND VGND VPWR VPWR sky130_fd_sc_hd__decap_3
XFILLER_34_377 VGND VGND VPWR VPWR sky130_fd_sc_hd__decap_3
XFILLER_61_152 VGND VGND VPWR VPWR sky130_fd_sc_hd__decap_3
X_5830_ _7124_/Q _5610_/B _5549_/B _7208_/Q VGND VGND VPWR VPWR _5830_/X sky130_fd_sc_hd__a22o_2
X_7500_ _7610_/CLK _7500_/D place2057/X VGND VGND VPWR VPWR _7500_/Q sky130_fd_sc_hd__dfrtp_2
X_4712_ _4712_/A1 _4735_/C _4726_/B1 VGND VGND VPWR VPWR _4712_/Y sky130_fd_sc_hd__o21ai_2
XTAP_TAPCELL_ROW_60_854 VGND VPWR sky130_fd_sc_hd__tapvpwrvgnd_1
XTAP_TAPCELL_ROW_32_556 VGND VPWR sky130_fd_sc_hd__tapvpwrvgnd_1
XFILLER_30_583 VGND VGND VPWR VPWR sky130_fd_sc_hd__decap_3
X_7431_ _7493_/CLK _7431_/D place2043/X VGND VGND VPWR VPWR _7431_/Q sky130_fd_sc_hd__dfrtp_2
X_5692_ _5692_/A0 _5692_/A1 _5698_/S VGND VGND VPWR VPWR _7273_/D sky130_fd_sc_hd__mux2_2
X_4643_ _4642_/X _4641_/A1 _4755_/A _4629_/S VGND VGND VPWR VPWR _4643_/X sky130_fd_sc_hd__o2bb2a_2
Xplace1401 _3886_/A VGND VGND VPWR VPWR _4178_/A2 sky130_fd_sc_hd__buf_2
X_7362_ _7490_/CLK _7362_/D place2024/X VGND VGND VPWR VPWR _7362_/Q sky130_fd_sc_hd__dfrtp_2
X_4574_ _4572_/Y _4573_/X _4325_/Y VGND VGND VPWR VPWR _4574_/Y sky130_fd_sc_hd__a21oi_2
Xplace1412 _4281_/B VGND VGND VPWR VPWR _4271_/A sky130_fd_sc_hd__buf_2
Xplace1423 _6254_/A VGND VGND VPWR VPWR _6292_/A sky130_fd_sc_hd__buf_2
Xplace1434 _3988_/Y VGND VGND VPWR VPWR _4579_/C sky130_fd_sc_hd__buf_6
X_7293_ clkload6/A _7293_/D place2030/X VGND VGND VPWR VPWR _7293_/Q sky130_fd_sc_hd__dfrtp_2
X_6313_ _7395_/Q _6313_/A2 _6313_/A3 _6313_/B1 _6313_/B2 VGND VGND VPWR VPWR _7363_/D
+ sky130_fd_sc_hd__a32o_2
X_3525_ _3628_/A1 _3525_/A2 _3574_/A1 _3524_/Y _3481_/A VGND VGND VPWR VPWR _3529_/B
+ sky130_fd_sc_hd__o221a_2
Xplace1445 _3884_/A VGND VGND VPWR VPWR _3885_/B sky130_fd_sc_hd__buf_2
Xplace1456 _3785_/A VGND VGND VPWR VPWR _4223_/A1 sky130_fd_sc_hd__buf_2
Xplace1467 _4253_/B VGND VGND VPWR VPWR _4247_/C sky130_fd_sc_hd__buf_2
Xplace1478 _4283_/A VGND VGND VPWR VPWR _4280_/A2 sky130_fd_sc_hd__buf_2
Xplace1489 _4099_/B VGND VGND VPWR VPWR _4098_/A2 sky130_fd_sc_hd__buf_2
XFILLER_57_403 VGND VGND VPWR VPWR sky130_fd_sc_hd__fill_2
X_6175_ _6891_/Q _6175_/A2 _6173_/X _6174_/X VGND VGND VPWR VPWR _6175_/X sky130_fd_sc_hd__o211a_2
XFILLER_69_263 VGND VGND VPWR VPWR sky130_fd_sc_hd__decap_3
XFILLER_97_594 VGND VGND VPWR VPWR sky130_fd_sc_hd__fill_1
XTAP_TAPCELL_ROW_68_932 VGND VPWR sky130_fd_sc_hd__tapvpwrvgnd_1
XFILLER_45_609 VGND VGND VPWR VPWR sky130_fd_sc_hd__decap_3
XFILLER_57_447 VGND VGND VPWR VPWR sky130_fd_sc_hd__fill_1
XFILLER_57_458 VGND VGND VPWR VPWR sky130_fd_sc_hd__decap_3
X_5057_ _5057_/A0 _5696_/A1 _5057_/S VGND VGND VPWR VPWR _6995_/D sky130_fd_sc_hd__mux2_2
XFILLER_55_39 VGND VGND VPWR VPWR sky130_fd_sc_hd__fill_2
X_4008_ _6311_/B2 _6658_/S _3968_/B _7489_/Q VGND VGND VPWR VPWR _4011_/B sky130_fd_sc_hd__a22oi_2
XFILLER_52_185 VGND VGND VPWR VPWR sky130_fd_sc_hd__decap_3
X_5959_ _5959_/A1 _6960_/Q _6932_/Q _5959_/B2 VGND VGND VPWR VPWR _5959_/X sky130_fd_sc_hd__o22a_2
XFILLER_21_561 VGND VGND VPWR VPWR sky130_fd_sc_hd__decap_3
XTAP_TAPCELL_ROW_78_1038 VGND VPWR sky130_fd_sc_hd__tapvpwrvgnd_1
XFILLER_0_421 VGND VGND VPWR VPWR sky130_fd_sc_hd__decap_3
Xplace1990 _4373_/B VGND VGND VPWR VPWR _4510_/A sky130_fd_sc_hd__buf_2
XFILLER_88_561 VGND VGND VPWR VPWR sky130_fd_sc_hd__fill_1
XFILLER_29_51 VGND VGND VPWR VPWR sky130_fd_sc_hd__decap_3
XFILLER_75_200 VGND VGND VPWR VPWR sky130_fd_sc_hd__decap_3
Xhold2670 _7012_/Q VGND VGND VPWR VPWR _5095_/A0 sky130_fd_sc_hd__dlygate4sd3_1
Xhold2681 _6971_/Q VGND VGND VPWR VPWR _5005_/A0 sky130_fd_sc_hd__dlygate4sd3_1
Xhold2692 _7023_/Q VGND VGND VPWR VPWR _5118_/A0 sky130_fd_sc_hd__dlygate4sd3_1
XTAP_TAPCELL_ROW_89_1156 VGND VPWR sky130_fd_sc_hd__tapvpwrvgnd_1
XFILLER_43_152 VGND VGND VPWR VPWR sky130_fd_sc_hd__decap_3
XFILLER_31_303 VGND VGND VPWR VPWR sky130_fd_sc_hd__decap_3
XFILLER_31_325 VGND VGND VPWR VPWR sky130_fd_sc_hd__fill_1
XFILLER_43_185 VGND VGND VPWR VPWR sky130_fd_sc_hd__fill_1
XFILLER_45_94 VGND VGND VPWR VPWR sky130_fd_sc_hd__decap_3
XFILLER_43_196 VGND VGND VPWR VPWR sky130_fd_sc_hd__decap_3
XFILLER_12_583 VGND VGND VPWR VPWR sky130_fd_sc_hd__decap_3
XANTENNA_4 _4595_/X VGND VGND VPWR VPWR sky130_fd_sc_hd__diode_2
X_4290_ _7320_/Q _4294_/A2 _4297_/A _4297_/B _4297_/D VGND VGND VPWR VPWR _4290_/Y
+ sky130_fd_sc_hd__a2111oi_2
XFILLER_20_3 VGND VGND VPWR VPWR sky130_fd_sc_hd__decap_3
XFILLER_66_211 VGND VGND VPWR VPWR sky130_fd_sc_hd__decap_3
XFILLER_66_244 VGND VGND VPWR VPWR sky130_fd_sc_hd__fill_2
XFILLER_94_531 VGND VGND VPWR VPWR sky130_fd_sc_hd__fill_1
XFILLER_94_564 VGND VGND VPWR VPWR sky130_fd_sc_hd__fill_1
XTAP_TAPCELL_ROW_65_902 VGND VPWR sky130_fd_sc_hd__tapvpwrvgnd_1
XTAP_TAPCELL_ROW_37_615 VGND VPWR sky130_fd_sc_hd__tapvpwrvgnd_1
XTAP_TAPCELL_ROW_1_229 VGND VPWR sky130_fd_sc_hd__tapvpwrvgnd_1
XFILLER_19_160 VGND VGND VPWR VPWR sky130_fd_sc_hd__decap_3
XFILLER_66_299 VGND VGND VPWR VPWR sky130_fd_sc_hd__fill_1
XFILLER_81_225 VGND VGND VPWR VPWR sky130_fd_sc_hd__decap_3
X_6931_ _7266_/CLK _6931_/D VGND VGND VPWR VPWR _6931_/Q sky130_fd_sc_hd__dfxtp_2
XFILLER_34_141 VGND VGND VPWR VPWR sky130_fd_sc_hd__fill_2
X_6862_ _7114_/CLK _6862_/D VGND VGND VPWR VPWR _6862_/Q sky130_fd_sc_hd__dfxtp_2
XFILLER_34_174 VGND VGND VPWR VPWR sky130_fd_sc_hd__fill_1
X_5813_ _5813_/A _5813_/B VGND VGND VPWR VPWR _5820_/B sky130_fd_sc_hd__nor2_2
XTAP_TAPCELL_ROW_73_990 VGND VPWR sky130_fd_sc_hd__tapvpwrvgnd_1
XFILLER_22_347 VGND VGND VPWR VPWR sky130_fd_sc_hd__decap_3
X_6793_ _6805_/A _6793_/B VGND VGND VPWR VPWR _7555_/D sky130_fd_sc_hd__and2_2
XTAP_TAPCELL_ROW_45_692 VGND VPWR sky130_fd_sc_hd__tapvpwrvgnd_1
XFILLER_30_380 VGND VGND VPWR VPWR sky130_fd_sc_hd__decap_3
XFILLER_30_391 VGND VGND VPWR VPWR sky130_fd_sc_hd__fill_1
X_5675_ _5675_/A0 _4755_/A _5696_/S VGND VGND VPWR VPWR _7265_/D sky130_fd_sc_hd__mux2_2
X_7414_ _7507_/CLK _7414_/D place2038/X VGND VGND VPWR VPWR _7414_/Q sky130_fd_sc_hd__dfrtp_2
X_7345_ _7514_/CLK _7345_/D place2044/X VGND VGND VPWR VPWR _7345_/Q sky130_fd_sc_hd__dfrtp_2
Xplace1220 _4168_/Y VGND VGND VPWR VPWR _4176_/A1 sky130_fd_sc_hd__buf_2
Xplace1231 _5576_/S VGND VGND VPWR VPWR _5574_/S sky130_fd_sc_hd__buf_2
Xplace1242 _4168_/A VGND VGND VPWR VPWR _4152_/A sky130_fd_sc_hd__buf_2
X_4557_ _7318_/Q _4558_/B _4558_/D _7320_/Q VGND VGND VPWR VPWR _4559_/B sky130_fd_sc_hd__a31oi_2
XTAP_TAPCELL_ROW_9_318 VGND VPWR sky130_fd_sc_hd__tapvpwrvgnd_1
XFILLER_103_113 VGND VGND VPWR VPWR sky130_fd_sc_hd__decap_3
Xplace1253 _4273_/Y VGND VGND VPWR VPWR _4276_/B sky130_fd_sc_hd__buf_4
Xplace1264 _6502_/B1 VGND VGND VPWR VPWR _6507_/A1 sky130_fd_sc_hd__buf_2
Xplace1275 _6451_/B1 VGND VGND VPWR VPWR _6173_/A1 sky130_fd_sc_hd__buf_6
Xplace1286 place1295/X VGND VGND VPWR VPWR _5991_/B2 sky130_fd_sc_hd__buf_2
X_7276_ _7276_/CLK _7276_/D VGND VGND VPWR VPWR _7276_/Q sky130_fd_sc_hd__dfxtp_2
X_4488_ _4482_/B _4482_/C _4495_/A _7308_/Q VGND VGND VPWR VPWR _4489_/B sky130_fd_sc_hd__and4bb_2
X_3508_ _3508_/A _3519_/C _3508_/C VGND VGND VPWR VPWR _3509_/A sky130_fd_sc_hd__nand3_4
Xplace1297 _4285_/A VGND VGND VPWR VPWR _6564_/C sky130_fd_sc_hd__buf_2
X_6227_ _6547_/B1 _6226_/X _6440_/B1 VGND VGND VPWR VPWR _6228_/B sky130_fd_sc_hd__a21oi_2
X_6158_ _6158_/A1 _6564_/D _6184_/B1 _6157_/X _6184_/C1 VGND VGND VPWR VPWR _6158_/X
+ sky130_fd_sc_hd__a221o_2
XFILLER_97_391 VGND VGND VPWR VPWR sky130_fd_sc_hd__fill_1
XFILLER_17_108 VGND VGND VPWR VPWR sky130_fd_sc_hd__decap_3
XFILLER_57_277 VGND VGND VPWR VPWR sky130_fd_sc_hd__decap_3
X_6089_ _6089_/A1 _6082_/X _6089_/B1 _6012_/X VGND VGND VPWR VPWR _6089_/X sky130_fd_sc_hd__o211a_4
XFILLER_38_480 VGND VGND VPWR VPWR sky130_fd_sc_hd__decap_3
XFILLER_72_236 VGND VGND VPWR VPWR sky130_fd_sc_hd__fill_1
XFILLER_85_597 VGND VGND VPWR VPWR sky130_fd_sc_hd__fill_2
XFILLER_82_26 VGND VGND VPWR VPWR sky130_fd_sc_hd__fill_2
XFILLER_13_325 VGND VGND VPWR VPWR sky130_fd_sc_hd__decap_3
XFILLER_53_461 VGND VGND VPWR VPWR sky130_fd_sc_hd__decap_3
XFILLER_53_472 VGND VGND VPWR VPWR sky130_fd_sc_hd__decap_3
XFILLER_53_494 VGND VGND VPWR VPWR sky130_fd_sc_hd__decap_3
XFILLER_15_53 VGND VGND VPWR VPWR sky130_fd_sc_hd__decap_3
XFILLER_9_329 VGND VGND VPWR VPWR sky130_fd_sc_hd__decap_3
XFILLER_40_188 VGND VGND VPWR VPWR sky130_fd_sc_hd__fill_1
XFILLER_48_211 VGND VGND VPWR VPWR sky130_fd_sc_hd__fill_2
XFILLER_29_491 VGND VGND VPWR VPWR sky130_fd_sc_hd__decap_3
XFILLER_63_225 VGND VGND VPWR VPWR sky130_fd_sc_hd__fill_2
XFILLER_16_141 VGND VGND VPWR VPWR sky130_fd_sc_hd__decap_3
XFILLER_31_100 VGND VGND VPWR VPWR sky130_fd_sc_hd__fill_1
XFILLER_16_185 VGND VGND VPWR VPWR sky130_fd_sc_hd__decap_3
XFILLER_31_111 VGND VGND VPWR VPWR sky130_fd_sc_hd__fill_1
XFILLER_31_166 VGND VGND VPWR VPWR sky130_fd_sc_hd__fill_2
X_3790_ _3787_/X _3790_/B _3790_/C VGND VGND VPWR VPWR _3790_/Y sky130_fd_sc_hd__nand3b_2
XTAP_TAPCELL_ROW_70_960 VGND VPWR sky130_fd_sc_hd__tapvpwrvgnd_1
XTAP_TAPCELL_ROW_42_662 VGND VPWR sky130_fd_sc_hd__tapvpwrvgnd_1
XTAP_TAPCELL_ROW_14_375 VGND VPWR sky130_fd_sc_hd__tapvpwrvgnd_1
XFILLER_8_362 VGND VGND VPWR VPWR sky130_fd_sc_hd__fill_2
X_4411_ _4411_/A _4416_/B _4411_/C VGND VGND VPWR VPWR _4430_/A sky130_fd_sc_hd__nand3_2
X_5391_ _5391_/A0 _5635_/A1 _5391_/S VGND VGND VPWR VPWR _7135_/D sky130_fd_sc_hd__mux2_2
X_7130_ _7274_/CLK _7130_/D VGND VGND VPWR VPWR _7130_/Q sky130_fd_sc_hd__dfxtp_2
X_4342_ _4341_/X _4392_/B1 _3843_/B VGND VGND VPWR VPWR _4342_/Y sky130_fd_sc_hd__a21oi_2
X_7061_ _7217_/CLK _7061_/D VGND VGND VPWR VPWR _7061_/Q sky130_fd_sc_hd__dfxtp_2
X_4273_ _4273_/A VGND VGND VPWR VPWR _4273_/Y sky130_fd_sc_hd__inv_2
X_6012_ _4613_/X _6011_/Y _5850_/C _4905_/A VGND VGND VPWR VPWR _6012_/X sky130_fd_sc_hd__a211o_4
.ends
